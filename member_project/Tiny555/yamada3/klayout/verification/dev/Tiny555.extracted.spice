* Created by KLayout
*** My special header ***

* cell Tiny555
* pin VDD
* pin VTH_H
* pin RAMP
* pin VTH_L
* pin OUT
* pin DISCH
* pin VSS
.SUBCKT Tiny555 VDD VTH_H RAMP VTH_L OUT DISCH VSS
* device instance $1 r0 *1 24,-360 PMOS
XM$1 \$2 \$3 VDD VDD PMOS L=1u W=180u AS=296p AD=296p PS=229.6u PD=229.6u
* device instance $10 r0 *1 32,-315 PMOS
XM$10 \$3 \$3 VDD VDD PMOS L=1u W=200u AS=352p AD=352p PS=275.2u PD=275.2u
* device instance $15 r0 *1 32,-267 PMOS
XM$15 \$4 VTH_H \$2 \$2 PMOS L=1u W=100u AS=176p AD=176p PS=137.6u PD=137.6u
* device instance $20 r0 *1 32,-222 PMOS
XM$20 \$6 RAMP \$2 \$2 PMOS L=1u W=100u AS=176p AD=176p PS=137.6u PD=137.6u
* device instance $25 r0 *1 24,-87 PMOS
XM$25 \$9 \$3 VDD VDD PMOS L=1u W=180u AS=296p AD=296p PS=229.6u PD=229.6u
* device instance $34 r0 *1 32,6 PMOS
XM$34 \$10 RAMP \$9 \$9 PMOS L=1u W=100u AS=176p AD=176p PS=137.6u PD=137.6u
* device instance $44 r0 *1 32,51 PMOS
XM$44 \$11 VTH_L \$9 \$9 PMOS L=1u W=100u AS=176p AD=176p PS=137.6u PD=137.6u
* device instance $49 r0 *1 40,321 PMOS
XM$49 \$18 OUT VDD VDD PMOS L=1u W=10u AS=28p AD=28p PS=25.6u PD=25.6u
* device instance $50 r0 *1 40,276 PMOS
XM$50 \$17 \$14 VDD VDD PMOS L=1u W=10u AS=28p AD=28p PS=25.6u PD=25.6u
* device instance $51 r0 *1 40,186 PMOS
XM$51 \$13 \$14 VDD VDD PMOS L=1u W=10u AS=28p AD=28p PS=25.6u PD=25.6u
* device instance $52 r0 *1 40,231 PMOS
XM$52 OUT \$15 \$13 VDD PMOS L=1u W=10u AS=28p AD=28p PS=25.6u PD=25.6u
* device instance $53 r0 *1 40,366 PMOS
XM$53 \$15 \$19 \$18 VDD PMOS L=1u W=10u AS=28p AD=28p PS=25.6u PD=25.6u
* device instance $54 r0 *1 40,411 PMOS
XM$54 \$15 \$17 \$18 VDD PMOS L=1u W=10u AS=28p AD=28p PS=25.6u PD=25.6u
* device instance $55 r0 *1 40,726 PMOS
XM$55 \$19 \$6 VDD VDD PMOS L=1u W=10u AS=28p AD=28p PS=25.6u PD=25.6u
* device instance $56 r0 *1 40,816 PMOS
XM$56 \$14 \$11 VDD VDD PMOS L=2u W=10u AS=28p AD=28p PS=25.6u PD=25.6u
* device instance $57 r0 *1 32,-177 NMOS
XM$57 \$4 \$4 VSS VSS NMOS L=1u W=50u AS=88p AD=88p PS=77.6u PD=77.6u
* device instance $62 r0 *1 32,-132 NMOS
XM$62 \$6 \$4 VSS VSS NMOS L=1u W=50u AS=88p AD=88p PS=77.6u PD=77.6u
* device instance $67 r0 *1 32,96 NMOS
XM$67 \$10 \$10 VSS VSS NMOS L=1u W=50u AS=88p AD=88p PS=77.6u PD=77.6u
* device instance $72 r0 *1 32,141 NMOS
XM$72 \$11 \$10 VSS VSS NMOS L=1u W=50u AS=88p AD=88p PS=77.6u PD=77.6u
* device instance $77 r0 *1 40,456 NMOS
XM$77 OUT \$14 VSS VSS NMOS L=1u W=3.4u AS=9.52p AD=9.52p PS=12.4u PD=12.4u
* device instance $78 r0 *1 40,501 NMOS
XM$78 OUT \$15 VSS VSS NMOS L=1u W=3.4u AS=9.52p AD=9.52p PS=12.4u PD=12.4u
* device instance $79 r0 *1 40,546 NMOS
XM$79 \$17 \$14 VSS VSS NMOS L=1u W=3.4u AS=9.52p AD=9.52p PS=12.4u PD=12.4u
* device instance $80 r0 *1 40,591 NMOS
XM$80 \$15 \$19 \$20 VSS NMOS L=1u W=3.4u AS=9.52p AD=9.52p PS=12.4u PD=12.4u
* device instance $81 r0 *1 40,636 NMOS
XM$81 \$15 OUT VSS VSS NMOS L=1u W=3.4u AS=9.52p AD=9.52p PS=12.4u PD=12.4u
* device instance $82 r0 *1 40,681 NMOS
XM$82 \$20 \$17 VSS VSS NMOS L=1u W=3.4u AS=9.52p AD=9.52p PS=12.4u PD=12.4u
* device instance $83 r0 *1 40,771 NMOS
XM$83 \$19 \$6 VSS VSS NMOS L=1u W=10u AS=28p AD=28p PS=25.6u PD=25.6u
* device instance $84 r0 *1 32,861 NMOS
XM$84 \$14 \$11 VSS VSS NMOS L=1u W=50u AS=88p AD=88p PS=77.6u PD=77.6u
* device instance $89 r0 *1 40,906 NMOS
XM$89 DISCH OUT VSS VSS NMOS L=2u W=4u AS=11.2p AD=11.2p PS=13.6u PD=13.6u
* device instance $90 r0 *1 110,-415 DN
D$90 VSS VTH_H DN A=12.96p P=14.4u
* device instance $91 r0 *1 110,-400 DN
D$91 VSS VTH_L DN A=12.96p P=14.4u
* device instance $92 r0 *1 90,960 F_RR
XR$92 VTH_H VDD VDD F_RR R=12.5 L=50u W=4u A=200p P=108u m=1
* device instance $93 r0 *1 90,1020 F_RR
XR$93 VTH_L VTH_H VDD F_RR R=12.5 L=50u W=4u A=200p P=108u m=1
* device instance $94 r0 *1 90,1080 F_RR
XR$94 VSS VTH_L VDD F_RR R=12.5 L=50u W=4u A=200p P=108u m=1
* device instance $95 r0 *1 90,1220 F_RR
XR$95 VSS \$3 VDD F_RR R=25 L=100u W=4u A=400p P=208u m=1
.ENDS Tiny555
