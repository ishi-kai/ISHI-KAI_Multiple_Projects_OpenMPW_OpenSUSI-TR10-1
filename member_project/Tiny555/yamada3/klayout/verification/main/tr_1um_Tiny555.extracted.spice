* Created by KLayout
*** My special header ***

* cell tr_1um_Tiny555
* pin VDD
* pin P7
* pin P9
* pin P10
* pin P6
* pin DISCH
* pin VTH_H
* pin VTH_L
* pin P5
* pin RAMP
* pin P4
* pin OUT
* pin P3
* pin P14
* pin P2
* pin P1
* pin P15
* pin VSS
.SUBCKT tr_1um_Tiny555 VDD P7 P9 P10 P6 DISCH VTH_H VTH_L P5 RAMP P4 OUT P3 P14
+ P2 P1 P15 VSS
* device instance $1 r0 *1 144,-805 PMOS
XM$1 \$6 \$7 VDD VDD PMOS L=1u W=180u AS=296p AD=296p PS=229.6u PD=229.6u
* device instance $10 r0 *1 152,-760 PMOS
XM$10 \$7 \$7 VDD VDD PMOS L=1u W=200u AS=352p AD=352p PS=275.2u PD=275.2u
* device instance $15 r0 *1 152,-712 PMOS
XM$15 \$10 VTH_H \$6 \$6 PMOS L=1u W=100u AS=176p AD=176p PS=137.6u PD=137.6u
* device instance $20 r0 *1 152,-667 PMOS
XM$20 \$12 RAMP \$6 \$6 PMOS L=1u W=100u AS=176p AD=176p PS=137.6u PD=137.6u
* device instance $25 r0 *1 144,-532 PMOS
XM$25 \$13 \$7 VDD VDD PMOS L=1u W=180u AS=296p AD=296p PS=229.6u PD=229.6u
* device instance $34 r0 *1 152,-439 PMOS
XM$34 \$14 RAMP \$13 \$13 PMOS L=1u W=100u AS=176p AD=176p PS=137.6u PD=137.6u
* device instance $44 r0 *1 152,-394 PMOS
XM$44 \$15 VTH_L \$13 \$13 PMOS L=1u W=100u AS=176p AD=176p PS=137.6u PD=137.6u
* device instance $49 r0 *1 160,-124 PMOS
XM$49 \$22 OUT VDD VDD PMOS L=1u W=10u AS=28p AD=28p PS=25.6u PD=25.6u
* device instance $50 r0 *1 160,-169 PMOS
XM$50 \$23 \$21 VDD VDD PMOS L=1u W=10u AS=28p AD=28p PS=25.6u PD=25.6u
* device instance $51 r0 *1 160,-259 PMOS
XM$51 \$24 \$21 VDD VDD PMOS L=1u W=10u AS=28p AD=28p PS=25.6u PD=25.6u
* device instance $52 r0 *1 160,-214 PMOS
XM$52 OUT \$20 \$24 VDD PMOS L=1u W=10u AS=28p AD=28p PS=25.6u PD=25.6u
* device instance $53 r0 *1 160,-79 PMOS
XM$53 \$20 \$33 \$22 VDD PMOS L=1u W=10u AS=28p AD=28p PS=25.6u PD=25.6u
* device instance $54 r0 *1 160,-34 PMOS
XM$54 \$20 \$23 \$22 VDD PMOS L=1u W=10u AS=28p AD=28p PS=25.6u PD=25.6u
* device instance $55 r0 *1 160,281 PMOS
XM$55 \$33 \$12 VDD VDD PMOS L=1u W=10u AS=28p AD=28p PS=25.6u PD=25.6u
* device instance $56 r0 *1 160,371 PMOS
XM$56 \$21 \$15 VDD VDD PMOS L=2u W=10u AS=28p AD=28p PS=25.6u PD=25.6u
* device instance $57 r0 *1 152,-622 NMOS
XM$57 \$10 \$10 VSS VSS NMOS L=1u W=50u AS=88p AD=88p PS=77.6u PD=77.6u
* device instance $62 r0 *1 152,-577 NMOS
XM$62 \$12 \$10 VSS VSS NMOS L=1u W=50u AS=88p AD=88p PS=77.6u PD=77.6u
* device instance $67 r0 *1 152,-349 NMOS
XM$67 \$14 \$14 VSS VSS NMOS L=1u W=50u AS=88p AD=88p PS=77.6u PD=77.6u
* device instance $72 r0 *1 152,-304 NMOS
XM$72 \$15 \$14 VSS VSS NMOS L=1u W=50u AS=88p AD=88p PS=77.6u PD=77.6u
* device instance $77 r0 *1 160,11 NMOS
XM$77 OUT \$21 VSS VSS NMOS L=1u W=3.4u AS=9.52p AD=9.52p PS=12.4u PD=12.4u
* device instance $78 r0 *1 160,56 NMOS
XM$78 OUT \$20 VSS VSS NMOS L=1u W=3.4u AS=9.52p AD=9.52p PS=12.4u PD=12.4u
* device instance $79 r0 *1 160,101 NMOS
XM$79 \$23 \$21 VSS VSS NMOS L=1u W=3.4u AS=9.52p AD=9.52p PS=12.4u PD=12.4u
* device instance $80 r0 *1 160,146 NMOS
XM$80 \$20 \$33 \$38 VSS NMOS L=1u W=3.4u AS=9.52p AD=9.52p PS=12.4u PD=12.4u
* device instance $81 r0 *1 160,191 NMOS
XM$81 \$20 OUT VSS VSS NMOS L=1u W=3.4u AS=9.52p AD=9.52p PS=12.4u PD=12.4u
* device instance $82 r0 *1 160,236 NMOS
XM$82 \$38 \$23 VSS VSS NMOS L=1u W=3.4u AS=9.52p AD=9.52p PS=12.4u PD=12.4u
* device instance $83 r0 *1 160,326 NMOS
XM$83 \$33 \$12 VSS VSS NMOS L=1u W=10u AS=28p AD=28p PS=25.6u PD=25.6u
* device instance $84 r0 *1 152,416 NMOS
XM$84 \$21 \$15 VSS VSS NMOS L=1u W=50u AS=88p AD=88p PS=77.6u PD=77.6u
* device instance $89 r0 *1 160,461 NMOS
XM$89 DISCH OUT VSS VSS NMOS L=2u W=4u AS=11.2p AD=11.2p PS=13.6u PD=13.6u
* device instance $90 r0 *1 -730,-1105.5 PMOS
XM$90 P7 VDD VDD VDD PMOS L=2u W=500u AS=3523.04p AD=3523.04p PS=689.36u
+ PD=689.36u
* device instance $100 r0 *1 -70,-1105.5 PMOS
XM$100 VSS VDD VDD VDD PMOS L=2u W=1000u AS=7046.08p AD=7046.08p PS=1378.72u
+ PD=1378.72u
* device instance $110 r0 *1 70,-1105.5 PMOS
XM$110 P9 VDD VDD VDD PMOS L=2u W=500u AS=3523.04p AD=3523.04p PS=689.36u
+ PD=689.36u
* device instance $120 r0 *1 730,-1105.5 PMOS
XM$120 P10 VDD VDD VDD PMOS L=2u W=500u AS=3523.04p AD=3523.04p PS=689.36u
+ PD=689.36u
* device instance $130 r0 *1 -1105.5,-730 PMOS
XM$130 P6 VDD VDD VDD PMOS L=2u W=500u AS=3523.04p AD=3523.04p PS=689.36u
+ PD=689.36u
* device instance $140 r0 *1 974.5,-730 PMOS
XM$140 DISCH VDD VDD VDD PMOS L=2u W=500u AS=3523.04p AD=3523.04p PS=689.36u
+ PD=689.36u
* device instance $150 r0 *1 -1105.5,-70 PMOS
XM$150 P5 VDD VDD VDD PMOS L=2u W=500u AS=3523.04p AD=3523.04p PS=689.36u
+ PD=689.36u
* device instance $160 r0 *1 974.5,-70 PMOS
XM$160 RAMP VDD VDD VDD PMOS L=2u W=500u AS=3523.04p AD=3523.04p PS=689.36u
+ PD=689.36u
* device instance $170 r0 *1 -1105.5,70 PMOS
XM$170 P4 VDD VDD VDD PMOS L=2u W=500u AS=3523.04p AD=3523.04p PS=689.36u
+ PD=689.36u
* device instance $180 r0 *1 974.5,70 PMOS
XM$180 OUT VDD VDD VDD PMOS L=2u W=500u AS=3523.04p AD=3523.04p PS=689.36u
+ PD=689.36u
* device instance $190 r0 *1 -1105.5,730 PMOS
XM$190 P3 VDD VDD VDD PMOS L=2u W=500u AS=3523.04p AD=3523.04p PS=689.36u
+ PD=689.36u
* device instance $200 r0 *1 974.5,730 PMOS
XM$200 P14 VDD VDD VDD PMOS L=2u W=500u AS=3523.04p AD=3523.04p PS=689.36u
+ PD=689.36u
* device instance $210 r0 *1 -730,974.5 PMOS
XM$210 P2 VDD VDD VDD PMOS L=2u W=500u AS=3523.04p AD=3523.04p PS=689.36u
+ PD=689.36u
* device instance $220 r0 *1 -70,974.5 PMOS
XM$220 P1 VDD VDD VDD PMOS L=2u W=500u AS=3523.04p AD=3523.04p PS=689.36u
+ PD=689.36u
* device instance $240 r0 *1 730,974.5 PMOS
XM$240 P15 VDD VDD VDD PMOS L=2u W=500u AS=3523.04p AD=3523.04p PS=689.36u
+ PD=689.36u
* device instance $250 r0 *1 -470,-1105.5 NMOSE
XM$250 P7 VSS VSS VSS NMOSE L=2u W=500u AS=3523.04p AD=3523.04p PS=689.36u
+ PD=689.36u
* device instance $260 r0 *1 -330,-1105.5 NMOSE
XM$260 VDD VSS VSS VSS NMOSE L=2u W=1000u AS=7046.08p AD=7046.08p PS=1378.72u
+ PD=1378.72u
* device instance $270 r0 *1 330,-1105.5 NMOSE
XM$270 P9 VSS VSS VSS NMOSE L=2u W=500u AS=3523.04p AD=3523.04p PS=689.36u
+ PD=689.36u
* device instance $280 r0 *1 470,-1105.5 NMOSE
XM$280 P10 VSS VSS VSS NMOSE L=2u W=500u AS=3523.04p AD=3523.04p PS=689.36u
+ PD=689.36u
* device instance $290 r0 *1 -1105.5,-470 NMOSE
XM$290 P6 VSS VSS VSS NMOSE L=2u W=500u AS=3523.04p AD=3523.04p PS=689.36u
+ PD=689.36u
* device instance $300 r0 *1 974.5,-470 NMOSE
XM$300 DISCH VSS VSS VSS NMOSE L=2u W=500u AS=3523.04p AD=3523.04p PS=689.36u
+ PD=689.36u
* device instance $310 r0 *1 -1105.5,-330 NMOSE
XM$310 P5 VSS VSS VSS NMOSE L=2u W=500u AS=3523.04p AD=3523.04p PS=689.36u
+ PD=689.36u
* device instance $320 r0 *1 974.5,-330 NMOSE
XM$320 RAMP VSS VSS VSS NMOSE L=2u W=500u AS=3523.04p AD=3523.04p PS=689.36u
+ PD=689.36u
* device instance $330 r0 *1 -1105.5,330 NMOSE
XM$330 P4 VSS VSS VSS NMOSE L=2u W=500u AS=3523.04p AD=3523.04p PS=689.36u
+ PD=689.36u
* device instance $340 r0 *1 974.5,330 NMOSE
XM$340 OUT VSS VSS VSS NMOSE L=2u W=500u AS=3523.04p AD=3523.04p PS=689.36u
+ PD=689.36u
* device instance $350 r0 *1 -1105.5,470 NMOSE
XM$350 P3 VSS VSS VSS NMOSE L=2u W=500u AS=3523.04p AD=3523.04p PS=689.36u
+ PD=689.36u
* device instance $360 r0 *1 974.5,470 NMOSE
XM$360 P14 VSS VSS VSS NMOSE L=2u W=500u AS=3523.04p AD=3523.04p PS=689.36u
+ PD=689.36u
* device instance $370 r0 *1 -470,974.5 NMOSE
XM$370 P2 VSS VSS VSS NMOSE L=2u W=500u AS=3523.04p AD=3523.04p PS=689.36u
+ PD=689.36u
* device instance $380 r0 *1 -330,974.5 NMOSE
XM$380 P1 VSS VSS VSS NMOSE L=2u W=500u AS=3523.04p AD=3523.04p PS=689.36u
+ PD=689.36u
* device instance $400 r0 *1 470,974.5 NMOSE
XM$400 P15 VSS VSS VSS NMOSE L=2u W=500u AS=3523.04p AD=3523.04p PS=689.36u
+ PD=689.36u
* device instance $410 r0 *1 230,-860 DN
D$410 VSS VTH_H DN A=12.96p P=14.4u
* device instance $411 r0 *1 230,-845 DN
D$411 VSS VTH_L DN A=12.96p P=14.4u
* device instance $412 r0 *1 210,515 F_RR
XR$412 VTH_H VDD VDD F_RR R=12.5 L=50u W=4u A=200p P=108u m=1
* device instance $413 r0 *1 210,575 F_RR
XR$413 VTH_L VTH_H VDD F_RR R=12.5 L=50u W=4u A=200p P=108u m=1
* device instance $414 r0 *1 210,635 F_RR
XR$414 VSS VTH_L VDD F_RR R=12.5 L=50u W=4u A=200p P=108u m=1
* device instance $415 r0 *1 210,775 F_RR
XR$415 VSS \$7 VDD F_RR R=25 L=100u W=4u A=400p P=208u m=1
.ENDS tr_1um_Tiny555
