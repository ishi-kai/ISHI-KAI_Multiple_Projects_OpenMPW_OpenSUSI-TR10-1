* Tiny555 schematic reference
.subckt Tiny555 VDD VSS DISCH RAMP OUT
MC1_M5 c1_n1 IBIAS VDD VDD PMOS W=180u L=1u
MC1_M20 IBIAS IBIAS VDD VDD PMOS W=100u L=1u
MC1_M1 c1_n2 VTH_H c1_n1 c1_n1 PMOS W=100u L=1u
MC1_M2 CMP_H RAMP c1_n1 c1_n1 PMOS W=100u L=1u
MC1_M3 c1_n2 c1_n2 VSS VSS NMOS W=50u L=1u
MC1_M4 CMP_H c1_n2 VSS VSS NMOS W=50u L=1u
MC2_M5 c2_n1 IBIAS VDD VDD PMOS W=180u L=1u
MC2_M20 IBIAS IBIAS VDD VDD PMOS W=100u L=1u
MC2_M1 c2_n2 RAMP c2_n1 c2_n1 PMOS W=100u L=1u
MC2_M2 CMP_L VTH_L c2_n1 c2_n1 PMOS W=100u L=1u
MC2_M3 c2_n2 c2_n2 VSS VSS NMOS W=50u L=1u
MC2_M4 CMP_L c2_n2 VSS VSS NMOS W=50u L=1u
MXM1 l_n2 RESET VDD VDD PMOS W=10u L=1u
MXM2 OUT l_n1 l_n2 VDD PMOS W=10u L=1u
MXM5 l_n3 RESET VDD VDD PMOS W=10u L=1u
MXM7 l_n5 OUT VDD VDD PMOS W=10u L=1u
MXM8 l_n1 SET l_n5 VDD PMOS W=10u L=1u
MXM9 l_n1 l_n3 l_n5 VDD PMOS W=10u L=1u
MXM3 OUT RESET VSS VSS NMOS W=3.4u L=1u
MXM4 OUT l_n1 VSS VSS NMOS W=3.4u L=1u
MXM6 l_n3 RESET VSS VSS NMOS W=3.4u L=1u
MXM10 l_n1 SET l_n4 VSS NMOS W=3.4u L=1u
MXM11 l_n1 OUT VSS VSS NMOS W=3.4u L=1u
MXM12 l_n4 l_n3 VSS VSS NMOS W=3.4u L=1u
MINV15_P SET CMP_H VDD VDD PMOS W=10u L=1u
MINV15_N SET CMP_H VSS VSS NMOS W=10u L=1u
MINV05_P RESET CMP_L VDD VDD PMOS W=10u L=2u
MINV05_N RESET CMP_L VSS VSS NMOS W=50u L=1u
MDISCH DISCH OUT VSS VSS NMOS W=4u L=2u
DPROT_H VSS VTH_H DN A=12.96p P=14.4u
DPROT_L VSS VTH_L DN A=12.96p P=14.4u
XRTH1 VDD VTH_H VDD F_RR W=4u L=50u
XRTH2 VTH_H VTH_L VDD F_RR W=4u L=50u
XRTH3 VTH_L VSS VDD F_RR W=4u L=50u
XRBIAS IBIAS VSS VDD F_RR W=4u L=100u
.ends Tiny555
