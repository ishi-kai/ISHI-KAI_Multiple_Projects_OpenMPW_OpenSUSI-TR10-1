* tr_1um_Tiny555: Tiny555 plus OSS_FRAME flat schematic reference
* Core source: generated Tiny555 reference with two DN gate-protection diodes
* Frame source: PDK OSS_FRAME.sch and OSS_ESD_5V_{ANA,VDD,VSS}.sch
.subckt tr_1um_Tiny555 VDD VSS DISCH RAMP OUT P1 P2 P3 P4 P5 P6 P7 P9 P10 P14 P15
MC1_M5 c1_n1 IBIAS VDD VDD PMOS W=180u L=1u
MC1_M20 IBIAS IBIAS VDD VDD PMOS W=100u L=1u
MC1_M1 c1_n2 VTH_H c1_n1 c1_n1 PMOS W=100u L=1u
MC1_M2 CMP_H RAMP c1_n1 c1_n1 PMOS W=100u L=1u
MC1_M3 c1_n2 c1_n2 VSS VSS NMOS W=50u L=1u
MC1_M4 CMP_H c1_n2 VSS VSS NMOS W=50u L=1u
MC2_M5 c2_n1 IBIAS VDD VDD PMOS W=180u L=1u
MC2_M20 IBIAS IBIAS VDD VDD PMOS W=100u L=1u
MC2_M1 c2_n2 RAMP c2_n1 c2_n1 PMOS W=100u L=1u
MC2_M2 CMP_L VTH_L c2_n1 c2_n1 PMOS W=100u L=1u
MC2_M3 c2_n2 c2_n2 VSS VSS NMOS W=50u L=1u
MC2_M4 CMP_L c2_n2 VSS VSS NMOS W=50u L=1u
MXM1 l_n2 RESET VDD VDD PMOS W=10u L=1u
MXM2 OUT l_n1 l_n2 VDD PMOS W=10u L=1u
MXM5 l_n3 RESET VDD VDD PMOS W=10u L=1u
MXM7 l_n5 OUT VDD VDD PMOS W=10u L=1u
MXM8 l_n1 SET l_n5 VDD PMOS W=10u L=1u
MXM9 l_n1 l_n3 l_n5 VDD PMOS W=10u L=1u
MXM3 OUT RESET VSS VSS NMOS W=3.4u L=1u
MXM4 OUT l_n1 VSS VSS NMOS W=3.4u L=1u
MXM6 l_n3 RESET VSS VSS NMOS W=3.4u L=1u
MXM10 l_n1 SET l_n4 VSS NMOS W=3.4u L=1u
MXM11 l_n1 OUT VSS VSS NMOS W=3.4u L=1u
MXM12 l_n4 l_n3 VSS VSS NMOS W=3.4u L=1u
MINV15_P SET CMP_H VDD VDD PMOS W=10u L=1u
MINV15_N SET CMP_H VSS VSS NMOS W=10u L=1u
MINV05_P RESET CMP_L VDD VDD PMOS W=10u L=2u
MINV05_N RESET CMP_L VSS VSS NMOS W=50u L=1u
MDISCH DISCH OUT VSS VSS NMOS W=4u L=2u
DPROT_H VSS VTH_H DN A=12.96p P=14.4u
DPROT_L VSS VTH_L DN A=12.96p P=14.4u
XRTH1 VDD VTH_H VDD F_RR W=4u L=50u
XRTH2 VTH_H VTH_L VDD F_RR W=4u L=50u
XRTH3 VTH_L VSS VDD F_RR W=4u L=50u
XRBIAS IBIAS VSS VDD F_RR W=4u L=100u
MESDP_P1 P1 VDD VDD VDD PMOS W=500u L=2u
MESDN_P1 P1 VSS VSS VSS NMOSE W=500u L=2u
MESDP_P2 P2 VDD VDD VDD PMOS W=500u L=2u
MESDN_P2 P2 VSS VSS VSS NMOSE W=500u L=2u
MESDP_P3 P3 VDD VDD VDD PMOS W=500u L=2u
MESDN_P3 P3 VSS VSS VSS NMOSE W=500u L=2u
MESDP_P4 P4 VDD VDD VDD PMOS W=500u L=2u
MESDN_P4 P4 VSS VSS VSS NMOSE W=500u L=2u
MESDP_P5 P5 VDD VDD VDD PMOS W=500u L=2u
MESDN_P5 P5 VSS VSS VSS NMOSE W=500u L=2u
MESDP_P6 P6 VDD VDD VDD PMOS W=500u L=2u
MESDN_P6 P6 VSS VSS VSS NMOSE W=500u L=2u
MESDP_P7 P7 VDD VDD VDD PMOS W=500u L=2u
MESDN_P7 P7 VSS VSS VSS NMOSE W=500u L=2u
MESDP_P9 P9 VDD VDD VDD PMOS W=500u L=2u
MESDN_P9 P9 VSS VSS VSS NMOSE W=500u L=2u
MESDP_P10 P10 VDD VDD VDD PMOS W=500u L=2u
MESDN_P10 P10 VSS VSS VSS NMOSE W=500u L=2u
MESDP_DISCH DISCH VDD VDD VDD PMOS W=500u L=2u
MESDN_DISCH DISCH VSS VSS VSS NMOSE W=500u L=2u
MESDP_RAMP RAMP VDD VDD VDD PMOS W=500u L=2u
MESDN_RAMP RAMP VSS VSS VSS NMOSE W=500u L=2u
MESDP_OUT OUT VDD VDD VDD PMOS W=500u L=2u
MESDN_OUT OUT VSS VSS VSS NMOSE W=500u L=2u
MESDP_P14 P14 VDD VDD VDD PMOS W=500u L=2u
MESDN_P14 P14 VSS VSS VSS NMOSE W=500u L=2u
MESDP_P15 P15 VDD VDD VDD PMOS W=500u L=2u
MESDN_P15 P15 VSS VSS VSS NMOSE W=500u L=2u
MESDN_VDD VDD VSS VSS VSS NMOSE W=1000u L=2u
MESDP_VSS VSS VDD VDD VDD PMOS W=1000u L=2u
.ends tr_1um_Tiny555
