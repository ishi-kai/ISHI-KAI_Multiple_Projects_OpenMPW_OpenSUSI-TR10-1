.subckt serial_macro_16x32 CLK RESET SDI WE SDO VDD VSS
Xg1 C3B C2B VDD logic1 C0B C1B VSS AND4_X1
Xg2 VDD logic2 logic1 C4 VSS AND2_X1
Xg3 VDD logic3 logic2 C4B VSS OR2
Xg4 VDD logic4 C0B logic3 VSS AND2_X1
Xff_C0 VDD C0B logic4 C0 RESET VSS CLK DFFR
Xg6 VDD toggle1 C1 C0 VSS XOR2
Xg7 VDD logic7 toggle1 logic3 VSS AND2_X1
Xff_C1 VDD C1B logic7 C1 RESET VSS CLK DFFR
Xg9 VDD logic9 C0 C1 VSS AND2_X1
Xg10 VDD toggle2 C2 logic9 VSS XOR2
Xg11 VDD logic11 toggle2 logic3 VSS AND2_X1
Xff_C2 VDD C2B logic11 C2 RESET VSS CLK DFFR
Xg13 C2 VDD logic13 C0 C1 VSS AND3_X1
Xg14 VDD toggle3 C3 logic13 VSS XOR2
Xg15 VDD logic15 toggle3 logic3 VSS AND2_X1
Xff_C3 VDD C3B logic15 C3 RESET VSS CLK DFFR
Xg17 C3 C2 VDD logic17 C0 C1 VSS AND4_X1
Xg18 VDD toggle4 C4 logic17 VSS XOR2
Xg19 VDD logic19 toggle4 logic3 VSS AND2_X1
Xff_C4 VDD C4B logic19 C4 RESET VSS CLK DFFR
Xg21 C4B C3 VDD logic21 C1B C2B VSS AND4_X1
Xg22 VDD logic22 C3B C4B VSS AND2_X1
Xg23 VDD logic23 logic21 logic22 VSS OR2
Xg24 C3 C2B VDD logic24 C0B C1 VSS AND4_X1
Xg25 VDD logic25 logic24 C4B VSS AND2_X1
Xg26 C3 C2B VDD logic26 C0 C1 VSS AND4_X1
Xg27 VDD logic27 logic26 C4B VSS AND2_X1
Xg28 C3 C2 VDD logic28 C0B C1B VSS AND4_X1
Xg29 VDD logic29 logic28 C4B VSS AND2_X1
Xg30 C3 C2 VDD logic30 C0 C1B VSS AND4_X1
Xg31 VDD logic31 logic30 C4B VSS AND2_X1
Xg32 C3 C2 VDD logic32 C0B C1 VSS AND4_X1
Xg33 VDD logic33 logic32 C4B VSS AND2_X1
Xg34 C3 C2 VDD logic34 C0 C1 VSS AND4_X1
Xg35 VDD logic35 logic34 C4B VSS AND2_X1
Xg36 C3B C2B VDD logic36 C0B C1B VSS AND4_X1
Xg37 VDD logic37 logic36 C4 VSS AND2_X1
Xg38 C3B C2B VDD logic38 C0 C1B VSS AND4_X1
Xg39 VDD logic39 logic38 C4 VSS AND2_X1
Xff_PC_ON VDD PREB logic25 PC_ON RESET VSS CLK DFFR
Xg41 VDD logic41 logic31 logic33 VSS OR2
Xff_WL_EN VDD WL_ENB logic41 WL_EN RESET VSS CLK DFFR
Xg43 logic29 logic31 logic33 logic35 VDD logic43 VSS OR4
Xg44 VDD logic44 logic43 W VSS AND2_X1
Xff_WRITE_EN VDD WRITE_ENB logic44 WRITE_EN RESET VSS CLK DFFR
Xg46 VDD WE WE_B VSS INV_X1
Xg47 VDD logic47 WE_B logic25 VSS AND2_X1
Xg48 logic31 VDD logic48 logic27 logic29 VSS OR3
Xg49 VDD logic49 logic48 WB VSS AND2_X1
Xg50 VDD logic50 logic47 logic49 VSS OR2
Xff_TRACK VDD SAE logic50 TRACK RESET VSS CLK DFFR
Xg52 SR0 SDI logic23 VDD SR0_next VSS MUX2
Xff_SR0 VDD SR0B SR0_next SR0 RESET VSS CLK DFFR
Xg54 SR1 SR0 logic23 VDD SR1_next VSS MUX2
Xff_SR1 VDD SR1B SR1_next SR1 RESET VSS CLK DFFR
Xg56 SR2 SR1 logic23 VDD SR2_next VSS MUX2
Xff_SR2 VDD SR2B SR2_next SR2 RESET VSS CLK DFFR
Xg58 SR3 SR2 logic23 VDD SR3_next VSS MUX2
Xff_SR3 VDD SR3B SR3_next SR3 RESET VSS CLK DFFR
Xg60 SR4 SR3 logic23 VDD SR4_next VSS MUX2
Xff_SR4 VDD SR4B SR4_next SR4 RESET VSS CLK DFFR
Xg62 SR5 SR4 logic23 VDD SR5_next VSS MUX2
Xff_SR5 VDD SR5B SR5_next SR5 RESET VSS CLK DFFR
Xg64 SR6 SR5 logic23 VDD SR6_next VSS MUX2
Xff_SR6 VDD SR6B SR6_next SR6 RESET VSS CLK DFFR
Xg66 SR7 SR6 logic23 VDD SR7_next VSS MUX2
Xff_SR7 VDD SR7B SR7_next SR7 RESET VSS CLK DFFR
Xg68 SR8 SR7 logic23 VDD SR8_next VSS MUX2
Xff_SR8 VDD SR8B SR8_next SR8 RESET VSS CLK DFFR
Xg70 SR9 SR8 logic23 VDD SR9_next VSS MUX2
Xff_SR9 VDD SR9B SR9_next SR9 RESET VSS CLK DFFR
Xg72 DIN SR0 logic25 VDD DIN_next VSS MUX2
Xff_DIN VDD DINB DIN_next DIN RESET VSS CLK DFFR
Xg74 CA0 SR1 logic25 VDD CA0_next VSS MUX2
Xff_CA0 VDD CA0B CA0_next CA0 RESET VSS CLK DFFR
Xg76 CA1 SR2 logic25 VDD CA1_next VSS MUX2
Xff_CA1 VDD CA1B CA1_next CA1 RESET VSS CLK DFFR
Xg78 CA2 SR3 logic25 VDD CA2_next VSS MUX2
Xff_CA2 VDD CA2B CA2_next CA2 RESET VSS CLK DFFR
Xg80 CA3 SR4 logic25 VDD CA3_next VSS MUX2
Xff_CA3 VDD CA3B CA3_next CA3 RESET VSS CLK DFFR
Xg82 CA4 SR5 logic25 VDD CA4_next VSS MUX2
Xff_CA4 VDD CA4B CA4_next CA4 RESET VSS CLK DFFR
Xg84 RA0 SR6 logic25 VDD RA0_next VSS MUX2
Xff_RA0 VDD RA0B RA0_next RA0 RESET VSS CLK DFFR
Xg86 RA1 SR7 logic25 VDD RA1_next VSS MUX2
Xff_RA1 VDD RA1B RA1_next RA1 RESET VSS CLK DFFR
Xg88 RA2 SR8 logic25 VDD RA2_next VSS MUX2
Xff_RA2 VDD RA2B RA2_next RA2 RESET VSS CLK DFFR
Xg90 RA3 SR9 logic25 VDD RA3_next VSS MUX2
Xff_RA3 VDD RA3B RA3_next RA3 RESET VSS CLK DFFR
Xg92 W WE logic25 VDD W_next VSS MUX2
Xff_W VDD WB W_next W RESET VSS CLK DFFR
Xg94 VDD logic94 logic37 WB VSS AND2_X1
Xg95 SDO SOUT logic94 VDD SDO_next VSS MUX2
Xff_SDO VDD SDOB SDO_next SDO RESET VSS CLK DFFR
Xg97 VDD logic97 RA0B RA1B VSS AND2_X1
Xg98 VDD logic98 RA0 RA1B VSS AND2_X1
Xg99 VDD logic99 RA0B RA1 VSS AND2_X1
Xg100 VDD logic100 RA0 RA1 VSS AND2_X1
Xg101 VDD logic101 RA2B RA3B VSS AND2_X1
Xg102 VDD logic102 RA2 RA3B VSS AND2_X1
Xg103 VDD logic103 RA2B RA3 VSS AND2_X1
Xg104 VDD logic104 RA2 RA3 VSS AND2_X1
Xg105 WL_EN VDD WL0 logic97 logic101 VSS AND3_X1
Xg106 WL_EN VDD WL1 logic98 logic101 VSS AND3_X1
Xg107 WL_EN VDD WL2 logic99 logic101 VSS AND3_X1
Xg108 WL_EN VDD WL3 logic100 logic101 VSS AND3_X1
Xg109 WL_EN VDD WL4 logic97 logic102 VSS AND3_X1
Xg110 WL_EN VDD WL5 logic98 logic102 VSS AND3_X1
Xg111 WL_EN VDD WL6 logic99 logic102 VSS AND3_X1
Xg112 WL_EN VDD WL7 logic100 logic102 VSS AND3_X1
Xg113 WL_EN VDD WL8 logic97 logic103 VSS AND3_X1
Xg114 WL_EN VDD WL9 logic98 logic103 VSS AND3_X1
Xg115 WL_EN VDD WL10 logic99 logic103 VSS AND3_X1
Xg116 WL_EN VDD WL11 logic100 logic103 VSS AND3_X1
Xg117 WL_EN VDD WL12 logic97 logic104 VSS AND3_X1
Xg118 WL_EN VDD WL13 logic98 logic104 VSS AND3_X1
Xg119 WL_EN VDD WL14 logic99 logic104 VSS AND3_X1
Xg120 WL_EN VDD WL15 logic100 logic104 VSS AND3_X1
Xg121 VDD logic121 CA0B CA1B VSS AND2_X1
Xg122 VDD logic122 CA0 CA1B VSS AND2_X1
Xg123 VDD logic123 CA0B CA1 VSS AND2_X1
Xg124 VDD logic124 CA0 CA1 VSS AND2_X1
Xg125 CA4B VDD logic125 CA2B CA3B VSS AND3_X1
Xg126 CA4B VDD logic126 CA2 CA3B VSS AND3_X1
Xg127 CA4B VDD logic127 CA2B CA3 VSS AND3_X1
Xg128 CA4B VDD logic128 CA2 CA3 VSS AND3_X1
Xg129 CA4 VDD logic129 CA2B CA3B VSS AND3_X1
Xg130 CA4 VDD logic130 CA2 CA3B VSS AND3_X1
Xg131 CA4 VDD logic131 CA2B CA3 VSS AND3_X1
Xg132 CA4 VDD logic132 CA2 CA3 VSS AND3_X1
Xg133 VDD COL0 logic121 logic125 VSS AND2_X1
Xg134 VDD COL1 logic122 logic125 VSS AND2_X1
Xg135 VDD COL2 logic123 logic125 VSS AND2_X1
Xg136 VDD COL3 logic124 logic125 VSS AND2_X1
Xg137 VDD COL4 logic121 logic126 VSS AND2_X1
Xg138 VDD COL5 logic122 logic126 VSS AND2_X1
Xg139 VDD COL6 logic123 logic126 VSS AND2_X1
Xg140 VDD COL7 logic124 logic126 VSS AND2_X1
Xg141 VDD COL8 logic121 logic127 VSS AND2_X1
Xg142 VDD COL9 logic122 logic127 VSS AND2_X1
Xg143 VDD COL10 logic123 logic127 VSS AND2_X1
Xg144 VDD COL11 logic124 logic127 VSS AND2_X1
Xg145 VDD COL12 logic121 logic128 VSS AND2_X1
Xg146 VDD COL13 logic122 logic128 VSS AND2_X1
Xg147 VDD COL14 logic123 logic128 VSS AND2_X1
Xg148 VDD COL15 logic124 logic128 VSS AND2_X1
Xg149 VDD COL16 logic121 logic129 VSS AND2_X1
Xg150 VDD COL17 logic122 logic129 VSS AND2_X1
Xg151 VDD COL18 logic123 logic129 VSS AND2_X1
Xg152 VDD COL19 logic124 logic129 VSS AND2_X1
Xg153 VDD COL20 logic121 logic130 VSS AND2_X1
Xg154 VDD COL21 logic122 logic130 VSS AND2_X1
Xg155 VDD COL22 logic123 logic130 VSS AND2_X1
Xg156 VDD COL23 logic124 logic130 VSS AND2_X1
Xg157 VDD COL24 logic121 logic131 VSS AND2_X1
Xg158 VDD COL25 logic122 logic131 VSS AND2_X1
Xg159 VDD COL26 logic123 logic131 VSS AND2_X1
Xg160 VDD COL27 logic124 logic131 VSS AND2_X1
Xg161 VDD COL28 logic121 logic132 VSS AND2_X1
Xg162 VDD COL29 logic122 logic132 VSS AND2_X1
Xg163 VDD COL30 logic123 logic132 VSS AND2_X1
Xg164 VDD COL31 logic124 logic132 VSS AND2_X1
Xg165 DIN WRITE_EN PD_Y PD_YB VDD VSS write_control
Xmemory BL0 BL1 BL10 BL11 BL12 BL13 BL14 BL15 BL16 BL17 BL18 BL19 BL2 BL20 BL21 BL22 BL23 BL24 BL25 BL26 BL27 BL28 BL29 BL3 BL30 BL31 BL4 BL5 BL6 BL7 BL8 BL9 BLB0 BLB1 BLB10 BLB11 BLB12 BLB13 BLB14 BLB15 BLB16 BLB17 BLB18 BLB19 BLB2 BLB20 BLB21 BLB22 BLB23 BLB24 BLB25 BLB26 BLB27 BLB28 BLB29 BLB3 BLB30 BLB31 BLB4 BLB5 BLB6 BLB7 BLB8 BLB9 VDD VSS WL0 WL1 WL10 WL11 WL12 WL13 WL14 WL15 WL2 WL3 WL4 WL5 WL6 WL7 WL8 WL9 compact_strap8_16x32
XP_BL0 BL0 PREB VDD VDD PMOS W=10.2u L=1u
XM_BL0 BL0 COL0 Y VSS NMOS W=3.4u L=1u
XP_BLB0 BLB0 PREB VDD VDD PMOS W=10.2u L=1u
XM_BLB0 BLB0 COL0 YB VSS NMOS W=3.4u L=1u
XP_BL1 BL1 PREB VDD VDD PMOS W=10.2u L=1u
XM_BL1 BL1 COL1 Y VSS NMOS W=3.4u L=1u
XP_BLB1 BLB1 PREB VDD VDD PMOS W=10.2u L=1u
XM_BLB1 BLB1 COL1 YB VSS NMOS W=3.4u L=1u
XP_BL2 BL2 PREB VDD VDD PMOS W=10.2u L=1u
XM_BL2 BL2 COL2 Y VSS NMOS W=3.4u L=1u
XP_BLB2 BLB2 PREB VDD VDD PMOS W=10.2u L=1u
XM_BLB2 BLB2 COL2 YB VSS NMOS W=3.4u L=1u
XP_BL3 BL3 PREB VDD VDD PMOS W=10.2u L=1u
XM_BL3 BL3 COL3 Y VSS NMOS W=3.4u L=1u
XP_BLB3 BLB3 PREB VDD VDD PMOS W=10.2u L=1u
XM_BLB3 BLB3 COL3 YB VSS NMOS W=3.4u L=1u
XP_BL4 BL4 PREB VDD VDD PMOS W=10.2u L=1u
XM_BL4 BL4 COL4 Y VSS NMOS W=3.4u L=1u
XP_BLB4 BLB4 PREB VDD VDD PMOS W=10.2u L=1u
XM_BLB4 BLB4 COL4 YB VSS NMOS W=3.4u L=1u
XP_BL5 BL5 PREB VDD VDD PMOS W=10.2u L=1u
XM_BL5 BL5 COL5 Y VSS NMOS W=3.4u L=1u
XP_BLB5 BLB5 PREB VDD VDD PMOS W=10.2u L=1u
XM_BLB5 BLB5 COL5 YB VSS NMOS W=3.4u L=1u
XP_BL6 BL6 PREB VDD VDD PMOS W=10.2u L=1u
XM_BL6 BL6 COL6 Y VSS NMOS W=3.4u L=1u
XP_BLB6 BLB6 PREB VDD VDD PMOS W=10.2u L=1u
XM_BLB6 BLB6 COL6 YB VSS NMOS W=3.4u L=1u
XP_BL7 BL7 PREB VDD VDD PMOS W=10.2u L=1u
XM_BL7 BL7 COL7 Y VSS NMOS W=3.4u L=1u
XP_BLB7 BLB7 PREB VDD VDD PMOS W=10.2u L=1u
XM_BLB7 BLB7 COL7 YB VSS NMOS W=3.4u L=1u
XP_BL8 BL8 PREB VDD VDD PMOS W=10.2u L=1u
XM_BL8 BL8 COL8 Y VSS NMOS W=3.4u L=1u
XP_BLB8 BLB8 PREB VDD VDD PMOS W=10.2u L=1u
XM_BLB8 BLB8 COL8 YB VSS NMOS W=3.4u L=1u
XP_BL9 BL9 PREB VDD VDD PMOS W=10.2u L=1u
XM_BL9 BL9 COL9 Y VSS NMOS W=3.4u L=1u
XP_BLB9 BLB9 PREB VDD VDD PMOS W=10.2u L=1u
XM_BLB9 BLB9 COL9 YB VSS NMOS W=3.4u L=1u
XP_BL10 BL10 PREB VDD VDD PMOS W=10.2u L=1u
XM_BL10 BL10 COL10 Y VSS NMOS W=3.4u L=1u
XP_BLB10 BLB10 PREB VDD VDD PMOS W=10.2u L=1u
XM_BLB10 BLB10 COL10 YB VSS NMOS W=3.4u L=1u
XP_BL11 BL11 PREB VDD VDD PMOS W=10.2u L=1u
XM_BL11 BL11 COL11 Y VSS NMOS W=3.4u L=1u
XP_BLB11 BLB11 PREB VDD VDD PMOS W=10.2u L=1u
XM_BLB11 BLB11 COL11 YB VSS NMOS W=3.4u L=1u
XP_BL12 BL12 PREB VDD VDD PMOS W=10.2u L=1u
XM_BL12 BL12 COL12 Y VSS NMOS W=3.4u L=1u
XP_BLB12 BLB12 PREB VDD VDD PMOS W=10.2u L=1u
XM_BLB12 BLB12 COL12 YB VSS NMOS W=3.4u L=1u
XP_BL13 BL13 PREB VDD VDD PMOS W=10.2u L=1u
XM_BL13 BL13 COL13 Y VSS NMOS W=3.4u L=1u
XP_BLB13 BLB13 PREB VDD VDD PMOS W=10.2u L=1u
XM_BLB13 BLB13 COL13 YB VSS NMOS W=3.4u L=1u
XP_BL14 BL14 PREB VDD VDD PMOS W=10.2u L=1u
XM_BL14 BL14 COL14 Y VSS NMOS W=3.4u L=1u
XP_BLB14 BLB14 PREB VDD VDD PMOS W=10.2u L=1u
XM_BLB14 BLB14 COL14 YB VSS NMOS W=3.4u L=1u
XP_BL15 BL15 PREB VDD VDD PMOS W=10.2u L=1u
XM_BL15 BL15 COL15 Y VSS NMOS W=3.4u L=1u
XP_BLB15 BLB15 PREB VDD VDD PMOS W=10.2u L=1u
XM_BLB15 BLB15 COL15 YB VSS NMOS W=3.4u L=1u
XP_BL16 BL16 PREB VDD VDD PMOS W=10.2u L=1u
XM_BL16 BL16 COL16 Y VSS NMOS W=3.4u L=1u
XP_BLB16 BLB16 PREB VDD VDD PMOS W=10.2u L=1u
XM_BLB16 BLB16 COL16 YB VSS NMOS W=3.4u L=1u
XP_BL17 BL17 PREB VDD VDD PMOS W=10.2u L=1u
XM_BL17 BL17 COL17 Y VSS NMOS W=3.4u L=1u
XP_BLB17 BLB17 PREB VDD VDD PMOS W=10.2u L=1u
XM_BLB17 BLB17 COL17 YB VSS NMOS W=3.4u L=1u
XP_BL18 BL18 PREB VDD VDD PMOS W=10.2u L=1u
XM_BL18 BL18 COL18 Y VSS NMOS W=3.4u L=1u
XP_BLB18 BLB18 PREB VDD VDD PMOS W=10.2u L=1u
XM_BLB18 BLB18 COL18 YB VSS NMOS W=3.4u L=1u
XP_BL19 BL19 PREB VDD VDD PMOS W=10.2u L=1u
XM_BL19 BL19 COL19 Y VSS NMOS W=3.4u L=1u
XP_BLB19 BLB19 PREB VDD VDD PMOS W=10.2u L=1u
XM_BLB19 BLB19 COL19 YB VSS NMOS W=3.4u L=1u
XP_BL20 BL20 PREB VDD VDD PMOS W=10.2u L=1u
XM_BL20 BL20 COL20 Y VSS NMOS W=3.4u L=1u
XP_BLB20 BLB20 PREB VDD VDD PMOS W=10.2u L=1u
XM_BLB20 BLB20 COL20 YB VSS NMOS W=3.4u L=1u
XP_BL21 BL21 PREB VDD VDD PMOS W=10.2u L=1u
XM_BL21 BL21 COL21 Y VSS NMOS W=3.4u L=1u
XP_BLB21 BLB21 PREB VDD VDD PMOS W=10.2u L=1u
XM_BLB21 BLB21 COL21 YB VSS NMOS W=3.4u L=1u
XP_BL22 BL22 PREB VDD VDD PMOS W=10.2u L=1u
XM_BL22 BL22 COL22 Y VSS NMOS W=3.4u L=1u
XP_BLB22 BLB22 PREB VDD VDD PMOS W=10.2u L=1u
XM_BLB22 BLB22 COL22 YB VSS NMOS W=3.4u L=1u
XP_BL23 BL23 PREB VDD VDD PMOS W=10.2u L=1u
XM_BL23 BL23 COL23 Y VSS NMOS W=3.4u L=1u
XP_BLB23 BLB23 PREB VDD VDD PMOS W=10.2u L=1u
XM_BLB23 BLB23 COL23 YB VSS NMOS W=3.4u L=1u
XP_BL24 BL24 PREB VDD VDD PMOS W=10.2u L=1u
XM_BL24 BL24 COL24 Y VSS NMOS W=3.4u L=1u
XP_BLB24 BLB24 PREB VDD VDD PMOS W=10.2u L=1u
XM_BLB24 BLB24 COL24 YB VSS NMOS W=3.4u L=1u
XP_BL25 BL25 PREB VDD VDD PMOS W=10.2u L=1u
XM_BL25 BL25 COL25 Y VSS NMOS W=3.4u L=1u
XP_BLB25 BLB25 PREB VDD VDD PMOS W=10.2u L=1u
XM_BLB25 BLB25 COL25 YB VSS NMOS W=3.4u L=1u
XP_BL26 BL26 PREB VDD VDD PMOS W=10.2u L=1u
XM_BL26 BL26 COL26 Y VSS NMOS W=3.4u L=1u
XP_BLB26 BLB26 PREB VDD VDD PMOS W=10.2u L=1u
XM_BLB26 BLB26 COL26 YB VSS NMOS W=3.4u L=1u
XP_BL27 BL27 PREB VDD VDD PMOS W=10.2u L=1u
XM_BL27 BL27 COL27 Y VSS NMOS W=3.4u L=1u
XP_BLB27 BLB27 PREB VDD VDD PMOS W=10.2u L=1u
XM_BLB27 BLB27 COL27 YB VSS NMOS W=3.4u L=1u
XP_BL28 BL28 PREB VDD VDD PMOS W=10.2u L=1u
XM_BL28 BL28 COL28 Y VSS NMOS W=3.4u L=1u
XP_BLB28 BLB28 PREB VDD VDD PMOS W=10.2u L=1u
XM_BLB28 BLB28 COL28 YB VSS NMOS W=3.4u L=1u
XP_BL29 BL29 PREB VDD VDD PMOS W=10.2u L=1u
XM_BL29 BL29 COL29 Y VSS NMOS W=3.4u L=1u
XP_BLB29 BLB29 PREB VDD VDD PMOS W=10.2u L=1u
XM_BLB29 BLB29 COL29 YB VSS NMOS W=3.4u L=1u
XP_BL30 BL30 PREB VDD VDD PMOS W=10.2u L=1u
XM_BL30 BL30 COL30 Y VSS NMOS W=3.4u L=1u
XP_BLB30 BLB30 PREB VDD VDD PMOS W=10.2u L=1u
XM_BLB30 BLB30 COL30 YB VSS NMOS W=3.4u L=1u
XP_BL31 BL31 PREB VDD VDD PMOS W=10.2u L=1u
XM_BL31 BL31 COL31 Y VSS NMOS W=3.4u L=1u
XP_BLB31 BLB31 PREB VDD VDD PMOS W=10.2u L=1u
XM_BLB31 BLB31 COL31 YB VSS NMOS W=3.4u L=1u
XP_Y Y PREB VDD VDD PMOS W=10.2u L=1u
XW_Y Y PD_Y VSS VSS NMOS W=3.4u L=1u
XP_YB YB PREB VDD VDD PMOS W=10.2u L=1u
XW_YB YB PD_YB VSS VSS NMOS W=3.4u L=1u
Xg166 Y YB SAE SOUT SOUTB VDD VSS sense_amp_7t
.ends
* Created by KLayout
*** My special header ***

* cell compact_strap8_16x32
* pin BL0
* pin BL1
* pin BL10
* pin BL11
* pin BL12
* pin BL13
* pin BL14
* pin BL15
* pin BL16
* pin BL17
* pin BL18
* pin BL19
* pin BL2
* pin BL20
* pin BL21
* pin BL22
* pin BL23
* pin BL24
* pin BL25
* pin BL26
* pin BL27
* pin BL28
* pin BL29
* pin BL3
* pin BL30
* pin BL31
* pin BL4
* pin BL5
* pin BL6
* pin BL7
* pin BL8
* pin BL9
* pin BLB0
* pin BLB1
* pin BLB10
* pin BLB11
* pin BLB12
* pin BLB13
* pin BLB14
* pin BLB15
* pin BLB16
* pin BLB17
* pin BLB18
* pin BLB19
* pin BLB2
* pin BLB20
* pin BLB21
* pin BLB22
* pin BLB23
* pin BLB24
* pin BLB25
* pin BLB26
* pin BLB27
* pin BLB28
* pin BLB29
* pin BLB3
* pin BLB30
* pin BLB31
* pin BLB4
* pin BLB5
* pin BLB6
* pin BLB7
* pin BLB8
* pin BLB9
* pin VDD
* pin VSS
* pin WL0
* pin WL1
* pin WL10
* pin WL11
* pin WL12
* pin WL13
* pin WL14
* pin WL15
* pin WL2
* pin WL3
* pin WL4
* pin WL5
* pin WL6
* pin WL7
* pin WL8
* pin WL9
.SUBCKT compact_strap8_16x32 BL0 BL1 BL10 BL11 BL12 BL13 BL14 BL15 BL16 BL17
+ BL18 BL19 BL2 BL20 BL21 BL22 BL23 BL24 BL25 BL26 BL27 BL28 BL29 BL3 BL30 BL31
+ BL4 BL5 BL6 BL7 BL8 BL9 BLB0 BLB1 BLB10 BLB11 BLB12 BLB13 BLB14 BLB15 BLB16
+ BLB17 BLB18 BLB19 BLB2 BLB20 BLB21 BLB22 BLB23 BLB24 BLB25 BLB26 BLB27 BLB28
+ BLB29 BLB3 BLB30 BLB31 BLB4 BLB5 BLB6 BLB7 BLB8 BLB9 VDD VSS WL0 WL1 WL10
+ WL11 WL12 WL13 WL14 WL15 WL2 WL3 WL4 WL5 WL6 WL7 WL8 WL9
* device instance $1 r0 *1 204.4,26.1 PMOS
XM$1 \$I3579 \$I3578 VDD VDD PMOS L=1u W=3.4u AS=10.88p AD=6.46p PS=13.2u
+ PD=7.2u
* device instance $2 r0 *1 209.2,26.1 PMOS
XM$2 VDD \$I3579 \$I3578 VDD PMOS L=1u W=3.4u AS=6.46p AD=10.88p PS=7.2u
+ PD=13.2u
* device instance $3 r0 *1 199.8,5.7 NMOS
XM$3 BL8 WL0 \$I3579 VSS NMOS L=1u W=3.4u AS=9.52p AD=6.12p PS=12.4u PD=7u
* device instance $4 r0 *1 204.4,5.7 NMOS
XM$4 \$I3579 \$I3578 VSS VSS NMOS L=1u W=3.4u AS=6.12p AD=6.46p PS=7u PD=7.2u
* device instance $5 r0 *1 209.2,5.7 NMOS
XM$5 VSS \$I3579 \$I3578 VSS NMOS L=1u W=3.4u AS=6.46p AD=6.12p PS=7.2u PD=7u
* device instance $6 r0 *1 213.8,5.7 NMOS
XM$6 \$I3578 WL0 BLB8 VSS NMOS L=1u W=3.4u AS=6.12p AD=9.52p PS=7u PD=12.4u
* device instance $7 r0 *1 226.4,26.1 PMOS
XM$7 \$I3581 \$I3580 VDD VDD PMOS L=1u W=3.4u AS=10.88p AD=6.46p PS=13.2u
+ PD=7.2u
* device instance $8 r0 *1 231.2,26.1 PMOS
XM$8 VDD \$I3581 \$I3580 VDD PMOS L=1u W=3.4u AS=6.46p AD=10.88p PS=7.2u
+ PD=13.2u
* device instance $9 r0 *1 221.8,5.7 NMOS
XM$9 BL9 WL0 \$I3581 VSS NMOS L=1u W=3.4u AS=9.52p AD=6.12p PS=12.4u PD=7u
* device instance $10 r0 *1 226.4,5.7 NMOS
XM$10 \$I3581 \$I3580 VSS VSS NMOS L=1u W=3.4u AS=6.12p AD=6.46p PS=7u PD=7.2u
* device instance $11 r0 *1 231.2,5.7 NMOS
XM$11 VSS \$I3581 \$I3580 VSS NMOS L=1u W=3.4u AS=6.46p AD=6.12p PS=7.2u PD=7u
* device instance $12 r0 *1 235.8,5.7 NMOS
XM$12 \$I3580 WL0 BLB9 VSS NMOS L=1u W=3.4u AS=6.12p AD=9.52p PS=7u PD=12.4u
* device instance $13 r0 *1 248.4,26.1 PMOS
XM$13 \$I3583 \$I3582 VDD VDD PMOS L=1u W=3.4u AS=10.88p AD=6.46p PS=13.2u
+ PD=7.2u
* device instance $14 r0 *1 253.2,26.1 PMOS
XM$14 VDD \$I3583 \$I3582 VDD PMOS L=1u W=3.4u AS=6.46p AD=10.88p PS=7.2u
+ PD=13.2u
* device instance $15 r0 *1 243.8,5.7 NMOS
XM$15 BL10 WL0 \$I3583 VSS NMOS L=1u W=3.4u AS=9.52p AD=6.12p PS=12.4u PD=7u
* device instance $16 r0 *1 248.4,5.7 NMOS
XM$16 \$I3583 \$I3582 VSS VSS NMOS L=1u W=3.4u AS=6.12p AD=6.46p PS=7u PD=7.2u
* device instance $17 r0 *1 253.2,5.7 NMOS
XM$17 VSS \$I3583 \$I3582 VSS NMOS L=1u W=3.4u AS=6.46p AD=6.12p PS=7.2u PD=7u
* device instance $18 r0 *1 257.8,5.7 NMOS
XM$18 \$I3582 WL0 BLB10 VSS NMOS L=1u W=3.4u AS=6.12p AD=9.52p PS=7u PD=12.4u
* device instance $19 r0 *1 270.4,26.1 PMOS
XM$19 \$I3585 \$I3584 VDD VDD PMOS L=1u W=3.4u AS=10.88p AD=6.46p PS=13.2u
+ PD=7.2u
* device instance $20 r0 *1 275.2,26.1 PMOS
XM$20 VDD \$I3585 \$I3584 VDD PMOS L=1u W=3.4u AS=6.46p AD=10.88p PS=7.2u
+ PD=13.2u
* device instance $21 r0 *1 265.8,5.7 NMOS
XM$21 BL11 WL0 \$I3585 VSS NMOS L=1u W=3.4u AS=9.52p AD=6.12p PS=12.4u PD=7u
* device instance $22 r0 *1 270.4,5.7 NMOS
XM$22 \$I3585 \$I3584 VSS VSS NMOS L=1u W=3.4u AS=6.12p AD=6.46p PS=7u PD=7.2u
* device instance $23 r0 *1 275.2,5.7 NMOS
XM$23 VSS \$I3585 \$I3584 VSS NMOS L=1u W=3.4u AS=6.46p AD=6.12p PS=7.2u PD=7u
* device instance $24 r0 *1 279.8,5.7 NMOS
XM$24 \$I3584 WL0 BLB11 VSS NMOS L=1u W=3.4u AS=6.12p AD=9.52p PS=7u PD=12.4u
* device instance $25 r0 *1 292.4,26.1 PMOS
XM$25 \$I3587 \$I3586 VDD VDD PMOS L=1u W=3.4u AS=10.88p AD=6.46p PS=13.2u
+ PD=7.2u
* device instance $26 r0 *1 297.2,26.1 PMOS
XM$26 VDD \$I3587 \$I3586 VDD PMOS L=1u W=3.4u AS=6.46p AD=10.88p PS=7.2u
+ PD=13.2u
* device instance $27 r0 *1 287.8,5.7 NMOS
XM$27 BL12 WL0 \$I3587 VSS NMOS L=1u W=3.4u AS=9.52p AD=6.12p PS=12.4u PD=7u
* device instance $28 r0 *1 292.4,5.7 NMOS
XM$28 \$I3587 \$I3586 VSS VSS NMOS L=1u W=3.4u AS=6.12p AD=6.46p PS=7u PD=7.2u
* device instance $29 r0 *1 297.2,5.7 NMOS
XM$29 VSS \$I3587 \$I3586 VSS NMOS L=1u W=3.4u AS=6.46p AD=6.12p PS=7.2u PD=7u
* device instance $30 r0 *1 301.8,5.7 NMOS
XM$30 \$I3586 WL0 BLB12 VSS NMOS L=1u W=3.4u AS=6.12p AD=9.52p PS=7u PD=12.4u
* device instance $31 r0 *1 314.4,26.1 PMOS
XM$31 \$I3589 \$I3588 VDD VDD PMOS L=1u W=3.4u AS=10.88p AD=6.46p PS=13.2u
+ PD=7.2u
* device instance $32 r0 *1 319.2,26.1 PMOS
XM$32 VDD \$I3589 \$I3588 VDD PMOS L=1u W=3.4u AS=6.46p AD=10.88p PS=7.2u
+ PD=13.2u
* device instance $33 r0 *1 309.8,5.7 NMOS
XM$33 BL13 WL0 \$I3589 VSS NMOS L=1u W=3.4u AS=9.52p AD=6.12p PS=12.4u PD=7u
* device instance $34 r0 *1 314.4,5.7 NMOS
XM$34 \$I3589 \$I3588 VSS VSS NMOS L=1u W=3.4u AS=6.12p AD=6.46p PS=7u PD=7.2u
* device instance $35 r0 *1 319.2,5.7 NMOS
XM$35 VSS \$I3589 \$I3588 VSS NMOS L=1u W=3.4u AS=6.46p AD=6.12p PS=7.2u PD=7u
* device instance $36 r0 *1 323.8,5.7 NMOS
XM$36 \$I3588 WL0 BLB13 VSS NMOS L=1u W=3.4u AS=6.12p AD=9.52p PS=7u PD=12.4u
* device instance $37 r0 *1 358.4,26.1 PMOS
XM$37 \$I3591 \$I3590 VDD VDD PMOS L=1u W=3.4u AS=10.88p AD=6.46p PS=13.2u
+ PD=7.2u
* device instance $38 r0 *1 363.2,26.1 PMOS
XM$38 VDD \$I3591 \$I3590 VDD PMOS L=1u W=3.4u AS=6.46p AD=10.88p PS=7.2u
+ PD=13.2u
* device instance $39 r0 *1 353.8,5.7 NMOS
XM$39 BL15 WL0 \$I3591 VSS NMOS L=1u W=3.4u AS=9.52p AD=6.12p PS=12.4u PD=7u
* device instance $40 r0 *1 358.4,5.7 NMOS
XM$40 \$I3591 \$I3590 VSS VSS NMOS L=1u W=3.4u AS=6.12p AD=6.46p PS=7u PD=7.2u
* device instance $41 r0 *1 363.2,5.7 NMOS
XM$41 VSS \$I3591 \$I3590 VSS NMOS L=1u W=3.4u AS=6.46p AD=6.12p PS=7.2u PD=7u
* device instance $42 r0 *1 367.8,5.7 NMOS
XM$42 \$I3590 WL0 BLB15 VSS NMOS L=1u W=3.4u AS=6.12p AD=9.52p PS=7u PD=12.4u
* device instance $43 r0 *1 336.4,26.1 PMOS
XM$43 \$I3593 \$I3592 VDD VDD PMOS L=1u W=3.4u AS=10.88p AD=6.46p PS=13.2u
+ PD=7.2u
* device instance $44 r0 *1 341.2,26.1 PMOS
XM$44 VDD \$I3593 \$I3592 VDD PMOS L=1u W=3.4u AS=6.46p AD=10.88p PS=7.2u
+ PD=13.2u
* device instance $45 r0 *1 331.8,5.7 NMOS
XM$45 BL14 WL0 \$I3593 VSS NMOS L=1u W=3.4u AS=9.52p AD=6.12p PS=12.4u PD=7u
* device instance $46 r0 *1 336.4,5.7 NMOS
XM$46 \$I3593 \$I3592 VSS VSS NMOS L=1u W=3.4u AS=6.12p AD=6.46p PS=7u PD=7.2u
* device instance $47 r0 *1 341.2,5.7 NMOS
XM$47 VSS \$I3593 \$I3592 VSS NMOS L=1u W=3.4u AS=6.46p AD=6.12p PS=7.2u PD=7u
* device instance $48 r0 *1 345.8,5.7 NMOS
XM$48 \$I3592 WL0 BLB14 VSS NMOS L=1u W=3.4u AS=6.12p AD=9.52p PS=7u PD=12.4u
* device instance $49 r0 *1 489.6,26.1 PMOS
XM$49 \$I3595 \$I3594 VDD VDD PMOS L=1u W=3.4u AS=10.88p AD=6.46p PS=13.2u
+ PD=7.2u
* device instance $50 r0 *1 494.4,26.1 PMOS
XM$50 VDD \$I3595 \$I3594 VDD PMOS L=1u W=3.4u AS=6.46p AD=10.88p PS=7.2u
+ PD=13.2u
* device instance $51 r0 *1 485,5.7 NMOS
XM$51 BL20 WL0 \$I3595 VSS NMOS L=1u W=3.4u AS=9.52p AD=6.12p PS=12.4u PD=7u
* device instance $52 r0 *1 489.6,5.7 NMOS
XM$52 \$I3595 \$I3594 VSS VSS NMOS L=1u W=3.4u AS=6.12p AD=6.46p PS=7u PD=7.2u
* device instance $53 r0 *1 494.4,5.7 NMOS
XM$53 VSS \$I3595 \$I3594 VSS NMOS L=1u W=3.4u AS=6.46p AD=6.12p PS=7.2u PD=7u
* device instance $54 r0 *1 499,5.7 NMOS
XM$54 \$I3594 WL0 BLB20 VSS NMOS L=1u W=3.4u AS=6.12p AD=9.52p PS=7u PD=12.4u
* device instance $55 r0 *1 511.6,26.1 PMOS
XM$55 \$I3597 \$I3596 VDD VDD PMOS L=1u W=3.4u AS=10.88p AD=6.46p PS=13.2u
+ PD=7.2u
* device instance $56 r0 *1 516.4,26.1 PMOS
XM$56 VDD \$I3597 \$I3596 VDD PMOS L=1u W=3.4u AS=6.46p AD=10.88p PS=7.2u
+ PD=13.2u
* device instance $57 r0 *1 507,5.7 NMOS
XM$57 BL21 WL0 \$I3597 VSS NMOS L=1u W=3.4u AS=9.52p AD=6.12p PS=12.4u PD=7u
* device instance $58 r0 *1 511.6,5.7 NMOS
XM$58 \$I3597 \$I3596 VSS VSS NMOS L=1u W=3.4u AS=6.12p AD=6.46p PS=7u PD=7.2u
* device instance $59 r0 *1 516.4,5.7 NMOS
XM$59 VSS \$I3597 \$I3596 VSS NMOS L=1u W=3.4u AS=6.46p AD=6.12p PS=7.2u PD=7u
* device instance $60 r0 *1 521,5.7 NMOS
XM$60 \$I3596 WL0 BLB21 VSS NMOS L=1u W=3.4u AS=6.12p AD=9.52p PS=7u PD=12.4u
* device instance $61 r0 *1 533.6,26.1 PMOS
XM$61 \$I3599 \$I3598 VDD VDD PMOS L=1u W=3.4u AS=10.88p AD=6.46p PS=13.2u
+ PD=7.2u
* device instance $62 r0 *1 538.4,26.1 PMOS
XM$62 VDD \$I3599 \$I3598 VDD PMOS L=1u W=3.4u AS=6.46p AD=10.88p PS=7.2u
+ PD=13.2u
* device instance $63 r0 *1 529,5.7 NMOS
XM$63 BL22 WL0 \$I3599 VSS NMOS L=1u W=3.4u AS=9.52p AD=6.12p PS=12.4u PD=7u
* device instance $64 r0 *1 533.6,5.7 NMOS
XM$64 \$I3599 \$I3598 VSS VSS NMOS L=1u W=3.4u AS=6.12p AD=6.46p PS=7u PD=7.2u
* device instance $65 r0 *1 538.4,5.7 NMOS
XM$65 VSS \$I3599 \$I3598 VSS NMOS L=1u W=3.4u AS=6.46p AD=6.12p PS=7.2u PD=7u
* device instance $66 r0 *1 543,5.7 NMOS
XM$66 \$I3598 WL0 BLB22 VSS NMOS L=1u W=3.4u AS=6.12p AD=9.52p PS=7u PD=12.4u
* device instance $67 r0 *1 555.6,26.1 PMOS
XM$67 \$I3601 \$I3600 VDD VDD PMOS L=1u W=3.4u AS=10.88p AD=6.46p PS=13.2u
+ PD=7.2u
* device instance $68 r0 *1 560.4,26.1 PMOS
XM$68 VDD \$I3601 \$I3600 VDD PMOS L=1u W=3.4u AS=6.46p AD=10.88p PS=7.2u
+ PD=13.2u
* device instance $69 r0 *1 551,5.7 NMOS
XM$69 BL23 WL0 \$I3601 VSS NMOS L=1u W=3.4u AS=9.52p AD=6.12p PS=12.4u PD=7u
* device instance $70 r0 *1 555.6,5.7 NMOS
XM$70 \$I3601 \$I3600 VSS VSS NMOS L=1u W=3.4u AS=6.12p AD=6.46p PS=7u PD=7.2u
* device instance $71 r0 *1 560.4,5.7 NMOS
XM$71 VSS \$I3601 \$I3600 VSS NMOS L=1u W=3.4u AS=6.46p AD=6.12p PS=7.2u PD=7u
* device instance $72 r0 *1 565,5.7 NMOS
XM$72 \$I3600 WL0 BLB23 VSS NMOS L=1u W=3.4u AS=6.12p AD=9.52p PS=7u PD=12.4u
* device instance $73 r0 *1 598.8,26.1 PMOS
XM$73 \$I3603 \$I3602 VDD VDD PMOS L=1u W=3.4u AS=10.88p AD=6.46p PS=13.2u
+ PD=7.2u
* device instance $74 r0 *1 603.6,26.1 PMOS
XM$74 VDD \$I3603 \$I3602 VDD PMOS L=1u W=3.4u AS=6.46p AD=10.88p PS=7.2u
+ PD=13.2u
* device instance $75 r0 *1 594.2,5.7 NMOS
XM$75 BL24 WL0 \$I3603 VSS NMOS L=1u W=3.4u AS=9.52p AD=6.12p PS=12.4u PD=7u
* device instance $76 r0 *1 598.8,5.7 NMOS
XM$76 \$I3603 \$I3602 VSS VSS NMOS L=1u W=3.4u AS=6.12p AD=6.46p PS=7u PD=7.2u
* device instance $77 r0 *1 603.6,5.7 NMOS
XM$77 VSS \$I3603 \$I3602 VSS NMOS L=1u W=3.4u AS=6.46p AD=6.12p PS=7.2u PD=7u
* device instance $78 r0 *1 608.2,5.7 NMOS
XM$78 \$I3602 WL0 BLB24 VSS NMOS L=1u W=3.4u AS=6.12p AD=9.52p PS=7u PD=12.4u
* device instance $79 r0 *1 620.8,26.1 PMOS
XM$79 \$I3605 \$I3604 VDD VDD PMOS L=1u W=3.4u AS=10.88p AD=6.46p PS=13.2u
+ PD=7.2u
* device instance $80 r0 *1 625.6,26.1 PMOS
XM$80 VDD \$I3605 \$I3604 VDD PMOS L=1u W=3.4u AS=6.46p AD=10.88p PS=7.2u
+ PD=13.2u
* device instance $81 r0 *1 616.2,5.7 NMOS
XM$81 BL25 WL0 \$I3605 VSS NMOS L=1u W=3.4u AS=9.52p AD=6.12p PS=12.4u PD=7u
* device instance $82 r0 *1 620.8,5.7 NMOS
XM$82 \$I3605 \$I3604 VSS VSS NMOS L=1u W=3.4u AS=6.12p AD=6.46p PS=7u PD=7.2u
* device instance $83 r0 *1 625.6,5.7 NMOS
XM$83 VSS \$I3605 \$I3604 VSS NMOS L=1u W=3.4u AS=6.46p AD=6.12p PS=7.2u PD=7u
* device instance $84 r0 *1 630.2,5.7 NMOS
XM$84 \$I3604 WL0 BLB25 VSS NMOS L=1u W=3.4u AS=6.12p AD=9.52p PS=7u PD=12.4u
* device instance $85 r0 *1 642.8,26.1 PMOS
XM$85 \$I3607 \$I3606 VDD VDD PMOS L=1u W=3.4u AS=10.88p AD=6.46p PS=13.2u
+ PD=7.2u
* device instance $86 r0 *1 647.6,26.1 PMOS
XM$86 VDD \$I3607 \$I3606 VDD PMOS L=1u W=3.4u AS=6.46p AD=10.88p PS=7.2u
+ PD=13.2u
* device instance $87 r0 *1 638.2,5.7 NMOS
XM$87 BL26 WL0 \$I3607 VSS NMOS L=1u W=3.4u AS=9.52p AD=6.12p PS=12.4u PD=7u
* device instance $88 r0 *1 642.8,5.7 NMOS
XM$88 \$I3607 \$I3606 VSS VSS NMOS L=1u W=3.4u AS=6.12p AD=6.46p PS=7u PD=7.2u
* device instance $89 r0 *1 647.6,5.7 NMOS
XM$89 VSS \$I3607 \$I3606 VSS NMOS L=1u W=3.4u AS=6.46p AD=6.12p PS=7.2u PD=7u
* device instance $90 r0 *1 652.2,5.7 NMOS
XM$90 \$I3606 WL0 BLB26 VSS NMOS L=1u W=3.4u AS=6.12p AD=9.52p PS=7u PD=12.4u
* device instance $91 r0 *1 664.8,26.1 PMOS
XM$91 \$I3609 \$I3608 VDD VDD PMOS L=1u W=3.4u AS=10.88p AD=6.46p PS=13.2u
+ PD=7.2u
* device instance $92 r0 *1 669.6,26.1 PMOS
XM$92 VDD \$I3609 \$I3608 VDD PMOS L=1u W=3.4u AS=6.46p AD=10.88p PS=7.2u
+ PD=13.2u
* device instance $93 r0 *1 660.2,5.7 NMOS
XM$93 BL27 WL0 \$I3609 VSS NMOS L=1u W=3.4u AS=9.52p AD=6.12p PS=12.4u PD=7u
* device instance $94 r0 *1 664.8,5.7 NMOS
XM$94 \$I3609 \$I3608 VSS VSS NMOS L=1u W=3.4u AS=6.12p AD=6.46p PS=7u PD=7.2u
* device instance $95 r0 *1 669.6,5.7 NMOS
XM$95 VSS \$I3609 \$I3608 VSS NMOS L=1u W=3.4u AS=6.46p AD=6.12p PS=7.2u PD=7u
* device instance $96 r0 *1 674.2,5.7 NMOS
XM$96 \$I3608 WL0 BLB27 VSS NMOS L=1u W=3.4u AS=6.12p AD=9.52p PS=7u PD=12.4u
* device instance $97 r0 *1 686.8,26.1 PMOS
XM$97 \$I3611 \$I3610 VDD VDD PMOS L=1u W=3.4u AS=10.88p AD=6.46p PS=13.2u
+ PD=7.2u
* device instance $98 r0 *1 691.6,26.1 PMOS
XM$98 VDD \$I3611 \$I3610 VDD PMOS L=1u W=3.4u AS=6.46p AD=10.88p PS=7.2u
+ PD=13.2u
* device instance $99 r0 *1 682.2,5.7 NMOS
XM$99 BL28 WL0 \$I3611 VSS NMOS L=1u W=3.4u AS=9.52p AD=6.12p PS=12.4u PD=7u
* device instance $100 r0 *1 686.8,5.7 NMOS
XM$100 \$I3611 \$I3610 VSS VSS NMOS L=1u W=3.4u AS=6.12p AD=6.46p PS=7u PD=7.2u
* device instance $101 r0 *1 691.6,5.7 NMOS
XM$101 VSS \$I3611 \$I3610 VSS NMOS L=1u W=3.4u AS=6.46p AD=6.12p PS=7.2u PD=7u
* device instance $102 r0 *1 696.2,5.7 NMOS
XM$102 \$I3610 WL0 BLB28 VSS NMOS L=1u W=3.4u AS=6.12p AD=9.52p PS=7u PD=12.4u
* device instance $103 r0 *1 708.8,26.1 PMOS
XM$103 \$I3613 \$I3612 VDD VDD PMOS L=1u W=3.4u AS=10.88p AD=6.46p PS=13.2u
+ PD=7.2u
* device instance $104 r0 *1 713.6,26.1 PMOS
XM$104 VDD \$I3613 \$I3612 VDD PMOS L=1u W=3.4u AS=6.46p AD=10.88p PS=7.2u
+ PD=13.2u
* device instance $105 r0 *1 704.2,5.7 NMOS
XM$105 BL29 WL0 \$I3613 VSS NMOS L=1u W=3.4u AS=9.52p AD=6.12p PS=12.4u PD=7u
* device instance $106 r0 *1 708.8,5.7 NMOS
XM$106 \$I3613 \$I3612 VSS VSS NMOS L=1u W=3.4u AS=6.12p AD=6.46p PS=7u PD=7.2u
* device instance $107 r0 *1 713.6,5.7 NMOS
XM$107 VSS \$I3613 \$I3612 VSS NMOS L=1u W=3.4u AS=6.46p AD=6.12p PS=7.2u PD=7u
* device instance $108 r0 *1 718.2,5.7 NMOS
XM$108 \$I3612 WL0 BLB29 VSS NMOS L=1u W=3.4u AS=6.12p AD=9.52p PS=7u PD=12.4u
* device instance $109 r0 *1 730.8,26.1 PMOS
XM$109 \$I3615 \$I3614 VDD VDD PMOS L=1u W=3.4u AS=10.88p AD=6.46p PS=13.2u
+ PD=7.2u
* device instance $110 r0 *1 735.6,26.1 PMOS
XM$110 VDD \$I3615 \$I3614 VDD PMOS L=1u W=3.4u AS=6.46p AD=10.88p PS=7.2u
+ PD=13.2u
* device instance $111 r0 *1 726.2,5.7 NMOS
XM$111 BL30 WL0 \$I3615 VSS NMOS L=1u W=3.4u AS=9.52p AD=6.12p PS=12.4u PD=7u
* device instance $112 r0 *1 730.8,5.7 NMOS
XM$112 \$I3615 \$I3614 VSS VSS NMOS L=1u W=3.4u AS=6.12p AD=6.46p PS=7u PD=7.2u
* device instance $113 r0 *1 735.6,5.7 NMOS
XM$113 VSS \$I3615 \$I3614 VSS NMOS L=1u W=3.4u AS=6.46p AD=6.12p PS=7.2u PD=7u
* device instance $114 r0 *1 740.2,5.7 NMOS
XM$114 \$I3614 WL0 BLB30 VSS NMOS L=1u W=3.4u AS=6.12p AD=9.52p PS=7u PD=12.4u
* device instance $115 r0 *1 752.8,26.1 PMOS
XM$115 \$I3617 \$I3616 VDD VDD PMOS L=1u W=3.4u AS=10.88p AD=6.46p PS=13.2u
+ PD=7.2u
* device instance $116 r0 *1 757.6,26.1 PMOS
XM$116 VDD \$I3617 \$I3616 VDD PMOS L=1u W=3.4u AS=6.46p AD=10.88p PS=7.2u
+ PD=13.2u
* device instance $117 r0 *1 748.2,5.7 NMOS
XM$117 BL31 WL0 \$I3617 VSS NMOS L=1u W=3.4u AS=9.52p AD=6.12p PS=12.4u PD=7u
* device instance $118 r0 *1 752.8,5.7 NMOS
XM$118 \$I3617 \$I3616 VSS VSS NMOS L=1u W=3.4u AS=6.12p AD=6.46p PS=7u PD=7.2u
* device instance $119 r0 *1 757.6,5.7 NMOS
XM$119 VSS \$I3617 \$I3616 VSS NMOS L=1u W=3.4u AS=6.46p AD=6.12p PS=7.2u PD=7u
* device instance $120 r0 *1 762.2,5.7 NMOS
XM$120 \$I3616 WL0 BLB31 VSS NMOS L=1u W=3.4u AS=6.12p AD=9.52p PS=7u PD=12.4u
* device instance $121 r0 *1 467.6,26.1 PMOS
XM$121 \$I3619 \$I3618 VDD VDD PMOS L=1u W=3.4u AS=10.88p AD=6.46p PS=13.2u
+ PD=7.2u
* device instance $122 r0 *1 472.4,26.1 PMOS
XM$122 VDD \$I3619 \$I3618 VDD PMOS L=1u W=3.4u AS=6.46p AD=10.88p PS=7.2u
+ PD=13.2u
* device instance $123 r0 *1 463,5.7 NMOS
XM$123 BL19 WL0 \$I3619 VSS NMOS L=1u W=3.4u AS=9.52p AD=6.12p PS=12.4u PD=7u
* device instance $124 r0 *1 467.6,5.7 NMOS
XM$124 \$I3619 \$I3618 VSS VSS NMOS L=1u W=3.4u AS=6.12p AD=6.46p PS=7u PD=7.2u
* device instance $125 r0 *1 472.4,5.7 NMOS
XM$125 VSS \$I3619 \$I3618 VSS NMOS L=1u W=3.4u AS=6.46p AD=6.12p PS=7.2u PD=7u
* device instance $126 r0 *1 477,5.7 NMOS
XM$126 \$I3618 WL0 BLB19 VSS NMOS L=1u W=3.4u AS=6.12p AD=9.52p PS=7u PD=12.4u
* device instance $127 r0 *1 401.6,26.1 PMOS
XM$127 \$I3621 \$I3620 VDD VDD PMOS L=1u W=3.4u AS=10.88p AD=6.46p PS=13.2u
+ PD=7.2u
* device instance $128 r0 *1 406.4,26.1 PMOS
XM$128 VDD \$I3621 \$I3620 VDD PMOS L=1u W=3.4u AS=6.46p AD=10.88p PS=7.2u
+ PD=13.2u
* device instance $129 r0 *1 397,5.7 NMOS
XM$129 BL16 WL0 \$I3621 VSS NMOS L=1u W=3.4u AS=9.52p AD=6.12p PS=12.4u PD=7u
* device instance $130 r0 *1 401.6,5.7 NMOS
XM$130 \$I3621 \$I3620 VSS VSS NMOS L=1u W=3.4u AS=6.12p AD=6.46p PS=7u PD=7.2u
* device instance $131 r0 *1 406.4,5.7 NMOS
XM$131 VSS \$I3621 \$I3620 VSS NMOS L=1u W=3.4u AS=6.46p AD=6.12p PS=7.2u PD=7u
* device instance $132 r0 *1 411,5.7 NMOS
XM$132 \$I3620 WL0 BLB16 VSS NMOS L=1u W=3.4u AS=6.12p AD=9.52p PS=7u PD=12.4u
* device instance $133 r0 *1 423.6,26.1 PMOS
XM$133 \$I3623 \$I3622 VDD VDD PMOS L=1u W=3.4u AS=10.88p AD=6.46p PS=13.2u
+ PD=7.2u
* device instance $134 r0 *1 428.4,26.1 PMOS
XM$134 VDD \$I3623 \$I3622 VDD PMOS L=1u W=3.4u AS=6.46p AD=10.88p PS=7.2u
+ PD=13.2u
* device instance $135 r0 *1 419,5.7 NMOS
XM$135 BL17 WL0 \$I3623 VSS NMOS L=1u W=3.4u AS=9.52p AD=6.12p PS=12.4u PD=7u
* device instance $136 r0 *1 423.6,5.7 NMOS
XM$136 \$I3623 \$I3622 VSS VSS NMOS L=1u W=3.4u AS=6.12p AD=6.46p PS=7u PD=7.2u
* device instance $137 r0 *1 428.4,5.7 NMOS
XM$137 VSS \$I3623 \$I3622 VSS NMOS L=1u W=3.4u AS=6.46p AD=6.12p PS=7.2u PD=7u
* device instance $138 r0 *1 433,5.7 NMOS
XM$138 \$I3622 WL0 BLB17 VSS NMOS L=1u W=3.4u AS=6.12p AD=9.52p PS=7u PD=12.4u
* device instance $139 r0 *1 445.6,26.1 PMOS
XM$139 \$I3625 \$I3624 VDD VDD PMOS L=1u W=3.4u AS=10.88p AD=6.46p PS=13.2u
+ PD=7.2u
* device instance $140 r0 *1 450.4,26.1 PMOS
XM$140 VDD \$I3625 \$I3624 VDD PMOS L=1u W=3.4u AS=6.46p AD=10.88p PS=7.2u
+ PD=13.2u
* device instance $141 r0 *1 441,5.7 NMOS
XM$141 BL18 WL0 \$I3625 VSS NMOS L=1u W=3.4u AS=9.52p AD=6.12p PS=12.4u PD=7u
* device instance $142 r0 *1 445.6,5.7 NMOS
XM$142 \$I3625 \$I3624 VSS VSS NMOS L=1u W=3.4u AS=6.12p AD=6.46p PS=7u PD=7.2u
* device instance $143 r0 *1 450.4,5.7 NMOS
XM$143 VSS \$I3625 \$I3624 VSS NMOS L=1u W=3.4u AS=6.46p AD=6.12p PS=7.2u PD=7u
* device instance $144 r0 *1 455,5.7 NMOS
XM$144 \$I3624 WL0 BLB18 VSS NMOS L=1u W=3.4u AS=6.12p AD=9.52p PS=7u PD=12.4u
* device instance $145 r0 *1 7.2,26.1 PMOS
XM$145 \$I3627 \$I3626 VDD VDD PMOS L=1u W=3.4u AS=10.88p AD=6.46p PS=13.2u
+ PD=7.2u
* device instance $146 r0 *1 12,26.1 PMOS
XM$146 VDD \$I3627 \$I3626 VDD PMOS L=1u W=3.4u AS=6.46p AD=10.88p PS=7.2u
+ PD=13.2u
* device instance $147 r0 *1 2.6,5.7 NMOS
XM$147 BL0 WL0 \$I3627 VSS NMOS L=1u W=3.4u AS=9.52p AD=6.12p PS=12.4u PD=7u
* device instance $148 r0 *1 7.2,5.7 NMOS
XM$148 \$I3627 \$I3626 VSS VSS NMOS L=1u W=3.4u AS=6.12p AD=6.46p PS=7u PD=7.2u
* device instance $149 r0 *1 12,5.7 NMOS
XM$149 VSS \$I3627 \$I3626 VSS NMOS L=1u W=3.4u AS=6.46p AD=6.12p PS=7.2u PD=7u
* device instance $150 r0 *1 16.6,5.7 NMOS
XM$150 \$I3626 WL0 BLB0 VSS NMOS L=1u W=3.4u AS=6.12p AD=9.52p PS=7u PD=12.4u
* device instance $151 r0 *1 29.2,26.1 PMOS
XM$151 \$I3629 \$I3628 VDD VDD PMOS L=1u W=3.4u AS=10.88p AD=6.46p PS=13.2u
+ PD=7.2u
* device instance $152 r0 *1 34,26.1 PMOS
XM$152 VDD \$I3629 \$I3628 VDD PMOS L=1u W=3.4u AS=6.46p AD=10.88p PS=7.2u
+ PD=13.2u
* device instance $153 r0 *1 24.6,5.7 NMOS
XM$153 BL1 WL0 \$I3629 VSS NMOS L=1u W=3.4u AS=9.52p AD=6.12p PS=12.4u PD=7u
* device instance $154 r0 *1 29.2,5.7 NMOS
XM$154 \$I3629 \$I3628 VSS VSS NMOS L=1u W=3.4u AS=6.12p AD=6.46p PS=7u PD=7.2u
* device instance $155 r0 *1 34,5.7 NMOS
XM$155 VSS \$I3629 \$I3628 VSS NMOS L=1u W=3.4u AS=6.46p AD=6.12p PS=7.2u PD=7u
* device instance $156 r0 *1 38.6,5.7 NMOS
XM$156 \$I3628 WL0 BLB1 VSS NMOS L=1u W=3.4u AS=6.12p AD=9.52p PS=7u PD=12.4u
* device instance $157 r0 *1 51.2,26.1 PMOS
XM$157 \$I3631 \$I3630 VDD VDD PMOS L=1u W=3.4u AS=10.88p AD=6.46p PS=13.2u
+ PD=7.2u
* device instance $158 r0 *1 56,26.1 PMOS
XM$158 VDD \$I3631 \$I3630 VDD PMOS L=1u W=3.4u AS=6.46p AD=10.88p PS=7.2u
+ PD=13.2u
* device instance $159 r0 *1 46.6,5.7 NMOS
XM$159 BL2 WL0 \$I3631 VSS NMOS L=1u W=3.4u AS=9.52p AD=6.12p PS=12.4u PD=7u
* device instance $160 r0 *1 51.2,5.7 NMOS
XM$160 \$I3631 \$I3630 VSS VSS NMOS L=1u W=3.4u AS=6.12p AD=6.46p PS=7u PD=7.2u
* device instance $161 r0 *1 56,5.7 NMOS
XM$161 VSS \$I3631 \$I3630 VSS NMOS L=1u W=3.4u AS=6.46p AD=6.12p PS=7.2u PD=7u
* device instance $162 r0 *1 60.6,5.7 NMOS
XM$162 \$I3630 WL0 BLB2 VSS NMOS L=1u W=3.4u AS=6.12p AD=9.52p PS=7u PD=12.4u
* device instance $163 r0 *1 73.2,26.1 PMOS
XM$163 \$I3633 \$I3632 VDD VDD PMOS L=1u W=3.4u AS=10.88p AD=6.46p PS=13.2u
+ PD=7.2u
* device instance $164 r0 *1 78,26.1 PMOS
XM$164 VDD \$I3633 \$I3632 VDD PMOS L=1u W=3.4u AS=6.46p AD=10.88p PS=7.2u
+ PD=13.2u
* device instance $165 r0 *1 68.6,5.7 NMOS
XM$165 BL3 WL0 \$I3633 VSS NMOS L=1u W=3.4u AS=9.52p AD=6.12p PS=12.4u PD=7u
* device instance $166 r0 *1 73.2,5.7 NMOS
XM$166 \$I3633 \$I3632 VSS VSS NMOS L=1u W=3.4u AS=6.12p AD=6.46p PS=7u PD=7.2u
* device instance $167 r0 *1 78,5.7 NMOS
XM$167 VSS \$I3633 \$I3632 VSS NMOS L=1u W=3.4u AS=6.46p AD=6.12p PS=7.2u PD=7u
* device instance $168 r0 *1 82.6,5.7 NMOS
XM$168 \$I3632 WL0 BLB3 VSS NMOS L=1u W=3.4u AS=6.12p AD=9.52p PS=7u PD=12.4u
* device instance $169 r0 *1 95.2,26.1 PMOS
XM$169 \$I3635 \$I3634 VDD VDD PMOS L=1u W=3.4u AS=10.88p AD=6.46p PS=13.2u
+ PD=7.2u
* device instance $170 r0 *1 100,26.1 PMOS
XM$170 VDD \$I3635 \$I3634 VDD PMOS L=1u W=3.4u AS=6.46p AD=10.88p PS=7.2u
+ PD=13.2u
* device instance $171 r0 *1 90.6,5.7 NMOS
XM$171 BL4 WL0 \$I3635 VSS NMOS L=1u W=3.4u AS=9.52p AD=6.12p PS=12.4u PD=7u
* device instance $172 r0 *1 95.2,5.7 NMOS
XM$172 \$I3635 \$I3634 VSS VSS NMOS L=1u W=3.4u AS=6.12p AD=6.46p PS=7u PD=7.2u
* device instance $173 r0 *1 100,5.7 NMOS
XM$173 VSS \$I3635 \$I3634 VSS NMOS L=1u W=3.4u AS=6.46p AD=6.12p PS=7.2u PD=7u
* device instance $174 r0 *1 104.6,5.7 NMOS
XM$174 \$I3634 WL0 BLB4 VSS NMOS L=1u W=3.4u AS=6.12p AD=9.52p PS=7u PD=12.4u
* device instance $175 r0 *1 117.2,26.1 PMOS
XM$175 \$I3637 \$I3636 VDD VDD PMOS L=1u W=3.4u AS=10.88p AD=6.46p PS=13.2u
+ PD=7.2u
* device instance $176 r0 *1 122,26.1 PMOS
XM$176 VDD \$I3637 \$I3636 VDD PMOS L=1u W=3.4u AS=6.46p AD=10.88p PS=7.2u
+ PD=13.2u
* device instance $177 r0 *1 112.6,5.7 NMOS
XM$177 BL5 WL0 \$I3637 VSS NMOS L=1u W=3.4u AS=9.52p AD=6.12p PS=12.4u PD=7u
* device instance $178 r0 *1 117.2,5.7 NMOS
XM$178 \$I3637 \$I3636 VSS VSS NMOS L=1u W=3.4u AS=6.12p AD=6.46p PS=7u PD=7.2u
* device instance $179 r0 *1 122,5.7 NMOS
XM$179 VSS \$I3637 \$I3636 VSS NMOS L=1u W=3.4u AS=6.46p AD=6.12p PS=7.2u PD=7u
* device instance $180 r0 *1 126.6,5.7 NMOS
XM$180 \$I3636 WL0 BLB5 VSS NMOS L=1u W=3.4u AS=6.12p AD=9.52p PS=7u PD=12.4u
* device instance $181 r0 *1 139.2,26.1 PMOS
XM$181 \$I3639 \$I3638 VDD VDD PMOS L=1u W=3.4u AS=10.88p AD=6.46p PS=13.2u
+ PD=7.2u
* device instance $182 r0 *1 144,26.1 PMOS
XM$182 VDD \$I3639 \$I3638 VDD PMOS L=1u W=3.4u AS=6.46p AD=10.88p PS=7.2u
+ PD=13.2u
* device instance $183 r0 *1 134.6,5.7 NMOS
XM$183 BL6 WL0 \$I3639 VSS NMOS L=1u W=3.4u AS=9.52p AD=6.12p PS=12.4u PD=7u
* device instance $184 r0 *1 139.2,5.7 NMOS
XM$184 \$I3639 \$I3638 VSS VSS NMOS L=1u W=3.4u AS=6.12p AD=6.46p PS=7u PD=7.2u
* device instance $185 r0 *1 144,5.7 NMOS
XM$185 VSS \$I3639 \$I3638 VSS NMOS L=1u W=3.4u AS=6.46p AD=6.12p PS=7.2u PD=7u
* device instance $186 r0 *1 148.6,5.7 NMOS
XM$186 \$I3638 WL0 BLB6 VSS NMOS L=1u W=3.4u AS=6.12p AD=9.52p PS=7u PD=12.4u
* device instance $187 r0 *1 161.2,26.1 PMOS
XM$187 \$I3641 \$I3640 VDD VDD PMOS L=1u W=3.4u AS=10.88p AD=6.46p PS=13.2u
+ PD=7.2u
* device instance $188 r0 *1 166,26.1 PMOS
XM$188 VDD \$I3641 \$I3640 VDD PMOS L=1u W=3.4u AS=6.46p AD=10.88p PS=7.2u
+ PD=13.2u
* device instance $189 r0 *1 156.6,5.7 NMOS
XM$189 BL7 WL0 \$I3641 VSS NMOS L=1u W=3.4u AS=9.52p AD=6.12p PS=12.4u PD=7u
* device instance $190 r0 *1 161.2,5.7 NMOS
XM$190 \$I3641 \$I3640 VSS VSS NMOS L=1u W=3.4u AS=6.12p AD=6.46p PS=7u PD=7.2u
* device instance $191 r0 *1 166,5.7 NMOS
XM$191 VSS \$I3641 \$I3640 VSS NMOS L=1u W=3.4u AS=6.46p AD=6.12p PS=7.2u PD=7u
* device instance $192 r0 *1 170.6,5.7 NMOS
XM$192 \$I3640 WL0 BLB7 VSS NMOS L=1u W=3.4u AS=6.12p AD=9.52p PS=7u PD=12.4u
* device instance $193 m0 *1 730.8,329.1 PMOS
XM$193 \$I3643 \$I3642 VDD VDD PMOS L=1u W=3.4u AS=10.88p AD=6.46p PS=13.2u
+ PD=7.2u
* device instance $194 m0 *1 735.6,329.1 PMOS
XM$194 VDD \$I3643 \$I3642 VDD PMOS L=1u W=3.4u AS=6.46p AD=10.88p PS=7.2u
+ PD=13.2u
* device instance $195 m0 *1 726.2,349.5 NMOS
XM$195 BL30 WL11 \$I3643 VSS NMOS L=1u W=3.4u AS=9.52p AD=6.12p PS=12.4u PD=7u
* device instance $196 m0 *1 730.8,349.5 NMOS
XM$196 \$I3643 \$I3642 VSS VSS NMOS L=1u W=3.4u AS=6.12p AD=6.46p PS=7u PD=7.2u
* device instance $197 m0 *1 735.6,349.5 NMOS
XM$197 VSS \$I3643 \$I3642 VSS NMOS L=1u W=3.4u AS=6.46p AD=6.12p PS=7.2u PD=7u
* device instance $198 m0 *1 740.2,349.5 NMOS
XM$198 \$I3642 WL11 BLB30 VSS NMOS L=1u W=3.4u AS=6.12p AD=9.52p PS=7u PD=12.4u
* device instance $199 m0 *1 730.8,269.9 PMOS
XM$199 \$I3645 \$I3644 VDD VDD PMOS L=1u W=3.4u AS=10.88p AD=6.46p PS=13.2u
+ PD=7.2u
* device instance $200 m0 *1 735.6,269.9 PMOS
XM$200 VDD \$I3645 \$I3644 VDD PMOS L=1u W=3.4u AS=6.46p AD=10.88p PS=7.2u
+ PD=13.2u
* device instance $201 m0 *1 726.2,290.3 NMOS
XM$201 BL30 WL9 \$I3645 VSS NMOS L=1u W=3.4u AS=9.52p AD=6.12p PS=12.4u PD=7u
* device instance $202 m0 *1 730.8,290.3 NMOS
XM$202 \$I3645 \$I3644 VSS VSS NMOS L=1u W=3.4u AS=6.12p AD=6.46p PS=7u PD=7.2u
* device instance $203 m0 *1 735.6,290.3 NMOS
XM$203 VSS \$I3645 \$I3644 VSS NMOS L=1u W=3.4u AS=6.46p AD=6.12p PS=7.2u PD=7u
* device instance $204 m0 *1 740.2,290.3 NMOS
XM$204 \$I3644 WL9 BLB30 VSS NMOS L=1u W=3.4u AS=6.12p AD=9.52p PS=7u PD=12.4u
* device instance $205 m0 *1 730.8,447.5 PMOS
XM$205 \$I3647 \$I3646 VDD VDD PMOS L=1u W=3.4u AS=10.88p AD=6.46p PS=13.2u
+ PD=7.2u
* device instance $206 m0 *1 735.6,447.5 PMOS
XM$206 VDD \$I3647 \$I3646 VDD PMOS L=1u W=3.4u AS=6.46p AD=10.88p PS=7.2u
+ PD=13.2u
* device instance $207 m0 *1 726.2,467.9 NMOS
XM$207 BL30 WL15 \$I3647 VSS NMOS L=1u W=3.4u AS=9.52p AD=6.12p PS=12.4u PD=7u
* device instance $208 m0 *1 730.8,467.9 NMOS
XM$208 \$I3647 \$I3646 VSS VSS NMOS L=1u W=3.4u AS=6.12p AD=6.46p PS=7u PD=7.2u
* device instance $209 m0 *1 735.6,467.9 NMOS
XM$209 VSS \$I3647 \$I3646 VSS NMOS L=1u W=3.4u AS=6.46p AD=6.12p PS=7.2u PD=7u
* device instance $210 m0 *1 740.2,467.9 NMOS
XM$210 \$I3646 WL15 BLB30 VSS NMOS L=1u W=3.4u AS=6.12p AD=9.52p PS=7u PD=12.4u
* device instance $211 m0 *1 730.8,388.3 PMOS
XM$211 \$I3649 \$I3648 VDD VDD PMOS L=1u W=3.4u AS=10.88p AD=6.46p PS=13.2u
+ PD=7.2u
* device instance $212 m0 *1 735.6,388.3 PMOS
XM$212 VDD \$I3649 \$I3648 VDD PMOS L=1u W=3.4u AS=6.46p AD=10.88p PS=7.2u
+ PD=13.2u
* device instance $213 m0 *1 726.2,408.7 NMOS
XM$213 BL30 WL13 \$I3649 VSS NMOS L=1u W=3.4u AS=9.52p AD=6.12p PS=12.4u PD=7u
* device instance $214 m0 *1 730.8,408.7 NMOS
XM$214 \$I3649 \$I3648 VSS VSS NMOS L=1u W=3.4u AS=6.12p AD=6.46p PS=7u PD=7.2u
* device instance $215 m0 *1 735.6,408.7 NMOS
XM$215 VSS \$I3649 \$I3648 VSS NMOS L=1u W=3.4u AS=6.46p AD=6.12p PS=7.2u PD=7u
* device instance $216 m0 *1 740.2,408.7 NMOS
XM$216 \$I3648 WL13 BLB30 VSS NMOS L=1u W=3.4u AS=6.12p AD=9.52p PS=7u PD=12.4u
* device instance $217 m0 *1 730.8,92.3 PMOS
XM$217 \$I3651 \$I3650 VDD VDD PMOS L=1u W=3.4u AS=10.88p AD=6.46p PS=13.2u
+ PD=7.2u
* device instance $218 m0 *1 735.6,92.3 PMOS
XM$218 VDD \$I3651 \$I3650 VDD PMOS L=1u W=3.4u AS=6.46p AD=10.88p PS=7.2u
+ PD=13.2u
* device instance $219 m0 *1 726.2,112.7 NMOS
XM$219 BL30 WL3 \$I3651 VSS NMOS L=1u W=3.4u AS=9.52p AD=6.12p PS=12.4u PD=7u
* device instance $220 m0 *1 730.8,112.7 NMOS
XM$220 \$I3651 \$I3650 VSS VSS NMOS L=1u W=3.4u AS=6.12p AD=6.46p PS=7u PD=7.2u
* device instance $221 m0 *1 735.6,112.7 NMOS
XM$221 VSS \$I3651 \$I3650 VSS NMOS L=1u W=3.4u AS=6.46p AD=6.12p PS=7.2u PD=7u
* device instance $222 m0 *1 740.2,112.7 NMOS
XM$222 \$I3650 WL3 BLB30 VSS NMOS L=1u W=3.4u AS=6.12p AD=9.52p PS=7u PD=12.4u
* device instance $223 m0 *1 730.8,33.1 PMOS
XM$223 \$I3653 \$I3652 VDD VDD PMOS L=1u W=3.4u AS=10.88p AD=6.46p PS=13.2u
+ PD=7.2u
* device instance $224 m0 *1 735.6,33.1 PMOS
XM$224 VDD \$I3653 \$I3652 VDD PMOS L=1u W=3.4u AS=6.46p AD=10.88p PS=7.2u
+ PD=13.2u
* device instance $225 m0 *1 726.2,53.5 NMOS
XM$225 BL30 WL1 \$I3653 VSS NMOS L=1u W=3.4u AS=9.52p AD=6.12p PS=12.4u PD=7u
* device instance $226 m0 *1 730.8,53.5 NMOS
XM$226 \$I3653 \$I3652 VSS VSS NMOS L=1u W=3.4u AS=6.12p AD=6.46p PS=7u PD=7.2u
* device instance $227 m0 *1 735.6,53.5 NMOS
XM$227 VSS \$I3653 \$I3652 VSS NMOS L=1u W=3.4u AS=6.46p AD=6.12p PS=7.2u PD=7u
* device instance $228 m0 *1 740.2,53.5 NMOS
XM$228 \$I3652 WL1 BLB30 VSS NMOS L=1u W=3.4u AS=6.12p AD=9.52p PS=7u PD=12.4u
* device instance $229 m0 *1 730.8,210.7 PMOS
XM$229 \$I3655 \$I3654 VDD VDD PMOS L=1u W=3.4u AS=10.88p AD=6.46p PS=13.2u
+ PD=7.2u
* device instance $230 m0 *1 735.6,210.7 PMOS
XM$230 VDD \$I3655 \$I3654 VDD PMOS L=1u W=3.4u AS=6.46p AD=10.88p PS=7.2u
+ PD=13.2u
* device instance $231 m0 *1 726.2,231.1 NMOS
XM$231 BL30 WL7 \$I3655 VSS NMOS L=1u W=3.4u AS=9.52p AD=6.12p PS=12.4u PD=7u
* device instance $232 m0 *1 730.8,231.1 NMOS
XM$232 \$I3655 \$I3654 VSS VSS NMOS L=1u W=3.4u AS=6.12p AD=6.46p PS=7u PD=7.2u
* device instance $233 m0 *1 735.6,231.1 NMOS
XM$233 VSS \$I3655 \$I3654 VSS NMOS L=1u W=3.4u AS=6.46p AD=6.12p PS=7.2u PD=7u
* device instance $234 m0 *1 740.2,231.1 NMOS
XM$234 \$I3654 WL7 BLB30 VSS NMOS L=1u W=3.4u AS=6.12p AD=9.52p PS=7u PD=12.4u
* device instance $235 m0 *1 730.8,151.5 PMOS
XM$235 \$I3657 \$I3656 VDD VDD PMOS L=1u W=3.4u AS=10.88p AD=6.46p PS=13.2u
+ PD=7.2u
* device instance $236 m0 *1 735.6,151.5 PMOS
XM$236 VDD \$I3657 \$I3656 VDD PMOS L=1u W=3.4u AS=6.46p AD=10.88p PS=7.2u
+ PD=13.2u
* device instance $237 m0 *1 726.2,171.9 NMOS
XM$237 BL30 WL5 \$I3657 VSS NMOS L=1u W=3.4u AS=9.52p AD=6.12p PS=12.4u PD=7u
* device instance $238 m0 *1 730.8,171.9 NMOS
XM$238 \$I3657 \$I3656 VSS VSS NMOS L=1u W=3.4u AS=6.12p AD=6.46p PS=7u PD=7.2u
* device instance $239 m0 *1 735.6,171.9 NMOS
XM$239 VSS \$I3657 \$I3656 VSS NMOS L=1u W=3.4u AS=6.46p AD=6.12p PS=7.2u PD=7u
* device instance $240 m0 *1 740.2,171.9 NMOS
XM$240 \$I3656 WL5 BLB30 VSS NMOS L=1u W=3.4u AS=6.12p AD=9.52p PS=7u PD=12.4u
* device instance $241 r0 *1 730.8,381.3 PMOS
XM$241 \$I3659 \$I3658 VDD VDD PMOS L=1u W=3.4u AS=10.88p AD=6.46p PS=13.2u
+ PD=7.2u
* device instance $242 r0 *1 735.6,381.3 PMOS
XM$242 VDD \$I3659 \$I3658 VDD PMOS L=1u W=3.4u AS=6.46p AD=10.88p PS=7.2u
+ PD=13.2u
* device instance $243 r0 *1 726.2,360.9 NMOS
XM$243 BL30 WL12 \$I3659 VSS NMOS L=1u W=3.4u AS=9.52p AD=6.12p PS=12.4u PD=7u
* device instance $244 r0 *1 730.8,360.9 NMOS
XM$244 \$I3659 \$I3658 VSS VSS NMOS L=1u W=3.4u AS=6.12p AD=6.46p PS=7u PD=7.2u
* device instance $245 r0 *1 735.6,360.9 NMOS
XM$245 VSS \$I3659 \$I3658 VSS NMOS L=1u W=3.4u AS=6.46p AD=6.12p PS=7.2u PD=7u
* device instance $246 r0 *1 740.2,360.9 NMOS
XM$246 \$I3658 WL12 BLB30 VSS NMOS L=1u W=3.4u AS=6.12p AD=9.52p PS=7u PD=12.4u
* device instance $247 r0 *1 730.8,440.5 PMOS
XM$247 \$I3661 \$I3660 VDD VDD PMOS L=1u W=3.4u AS=10.88p AD=6.46p PS=13.2u
+ PD=7.2u
* device instance $248 r0 *1 735.6,440.5 PMOS
XM$248 VDD \$I3661 \$I3660 VDD PMOS L=1u W=3.4u AS=6.46p AD=10.88p PS=7.2u
+ PD=13.2u
* device instance $249 r0 *1 726.2,420.1 NMOS
XM$249 BL30 WL14 \$I3661 VSS NMOS L=1u W=3.4u AS=9.52p AD=6.12p PS=12.4u PD=7u
* device instance $250 r0 *1 730.8,420.1 NMOS
XM$250 \$I3661 \$I3660 VSS VSS NMOS L=1u W=3.4u AS=6.12p AD=6.46p PS=7u PD=7.2u
* device instance $251 r0 *1 735.6,420.1 NMOS
XM$251 VSS \$I3661 \$I3660 VSS NMOS L=1u W=3.4u AS=6.46p AD=6.12p PS=7.2u PD=7u
* device instance $252 r0 *1 740.2,420.1 NMOS
XM$252 \$I3660 WL14 BLB30 VSS NMOS L=1u W=3.4u AS=6.12p AD=9.52p PS=7u PD=12.4u
* device instance $253 r0 *1 730.8,322.1 PMOS
XM$253 \$I3663 \$I3662 VDD VDD PMOS L=1u W=3.4u AS=10.88p AD=6.46p PS=13.2u
+ PD=7.2u
* device instance $254 r0 *1 735.6,322.1 PMOS
XM$254 VDD \$I3663 \$I3662 VDD PMOS L=1u W=3.4u AS=6.46p AD=10.88p PS=7.2u
+ PD=13.2u
* device instance $255 r0 *1 726.2,301.7 NMOS
XM$255 BL30 WL10 \$I3663 VSS NMOS L=1u W=3.4u AS=9.52p AD=6.12p PS=12.4u PD=7u
* device instance $256 r0 *1 730.8,301.7 NMOS
XM$256 \$I3663 \$I3662 VSS VSS NMOS L=1u W=3.4u AS=6.12p AD=6.46p PS=7u PD=7.2u
* device instance $257 r0 *1 735.6,301.7 NMOS
XM$257 VSS \$I3663 \$I3662 VSS NMOS L=1u W=3.4u AS=6.46p AD=6.12p PS=7.2u PD=7u
* device instance $258 r0 *1 740.2,301.7 NMOS
XM$258 \$I3662 WL10 BLB30 VSS NMOS L=1u W=3.4u AS=6.12p AD=9.52p PS=7u PD=12.4u
* device instance $259 r0 *1 730.8,262.9 PMOS
XM$259 \$I3665 \$I3664 VDD VDD PMOS L=1u W=3.4u AS=10.88p AD=6.46p PS=13.2u
+ PD=7.2u
* device instance $260 r0 *1 735.6,262.9 PMOS
XM$260 VDD \$I3665 \$I3664 VDD PMOS L=1u W=3.4u AS=6.46p AD=10.88p PS=7.2u
+ PD=13.2u
* device instance $261 r0 *1 726.2,242.5 NMOS
XM$261 BL30 WL8 \$I3665 VSS NMOS L=1u W=3.4u AS=9.52p AD=6.12p PS=12.4u PD=7u
* device instance $262 r0 *1 730.8,242.5 NMOS
XM$262 \$I3665 \$I3664 VSS VSS NMOS L=1u W=3.4u AS=6.12p AD=6.46p PS=7u PD=7.2u
* device instance $263 r0 *1 735.6,242.5 NMOS
XM$263 VSS \$I3665 \$I3664 VSS NMOS L=1u W=3.4u AS=6.46p AD=6.12p PS=7.2u PD=7u
* device instance $264 r0 *1 740.2,242.5 NMOS
XM$264 \$I3664 WL8 BLB30 VSS NMOS L=1u W=3.4u AS=6.12p AD=9.52p PS=7u PD=12.4u
* device instance $265 r0 *1 730.8,144.5 PMOS
XM$265 \$I3667 \$I3666 VDD VDD PMOS L=1u W=3.4u AS=10.88p AD=6.46p PS=13.2u
+ PD=7.2u
* device instance $266 r0 *1 735.6,144.5 PMOS
XM$266 VDD \$I3667 \$I3666 VDD PMOS L=1u W=3.4u AS=6.46p AD=10.88p PS=7.2u
+ PD=13.2u
* device instance $267 r0 *1 726.2,124.1 NMOS
XM$267 BL30 WL4 \$I3667 VSS NMOS L=1u W=3.4u AS=9.52p AD=6.12p PS=12.4u PD=7u
* device instance $268 r0 *1 730.8,124.1 NMOS
XM$268 \$I3667 \$I3666 VSS VSS NMOS L=1u W=3.4u AS=6.12p AD=6.46p PS=7u PD=7.2u
* device instance $269 r0 *1 735.6,124.1 NMOS
XM$269 VSS \$I3667 \$I3666 VSS NMOS L=1u W=3.4u AS=6.46p AD=6.12p PS=7.2u PD=7u
* device instance $270 r0 *1 740.2,124.1 NMOS
XM$270 \$I3666 WL4 BLB30 VSS NMOS L=1u W=3.4u AS=6.12p AD=9.52p PS=7u PD=12.4u
* device instance $271 r0 *1 730.8,203.7 PMOS
XM$271 \$I3669 \$I3668 VDD VDD PMOS L=1u W=3.4u AS=10.88p AD=6.46p PS=13.2u
+ PD=7.2u
* device instance $272 r0 *1 735.6,203.7 PMOS
XM$272 VDD \$I3669 \$I3668 VDD PMOS L=1u W=3.4u AS=6.46p AD=10.88p PS=7.2u
+ PD=13.2u
* device instance $273 r0 *1 726.2,183.3 NMOS
XM$273 BL30 WL6 \$I3669 VSS NMOS L=1u W=3.4u AS=9.52p AD=6.12p PS=12.4u PD=7u
* device instance $274 r0 *1 730.8,183.3 NMOS
XM$274 \$I3669 \$I3668 VSS VSS NMOS L=1u W=3.4u AS=6.12p AD=6.46p PS=7u PD=7.2u
* device instance $275 r0 *1 735.6,183.3 NMOS
XM$275 VSS \$I3669 \$I3668 VSS NMOS L=1u W=3.4u AS=6.46p AD=6.12p PS=7.2u PD=7u
* device instance $276 r0 *1 740.2,183.3 NMOS
XM$276 \$I3668 WL6 BLB30 VSS NMOS L=1u W=3.4u AS=6.12p AD=9.52p PS=7u PD=12.4u
* device instance $277 r0 *1 730.8,85.3 PMOS
XM$277 \$I3671 \$I3670 VDD VDD PMOS L=1u W=3.4u AS=10.88p AD=6.46p PS=13.2u
+ PD=7.2u
* device instance $278 r0 *1 735.6,85.3 PMOS
XM$278 VDD \$I3671 \$I3670 VDD PMOS L=1u W=3.4u AS=6.46p AD=10.88p PS=7.2u
+ PD=13.2u
* device instance $279 r0 *1 726.2,64.9 NMOS
XM$279 BL30 WL2 \$I3671 VSS NMOS L=1u W=3.4u AS=9.52p AD=6.12p PS=12.4u PD=7u
* device instance $280 r0 *1 730.8,64.9 NMOS
XM$280 \$I3671 \$I3670 VSS VSS NMOS L=1u W=3.4u AS=6.12p AD=6.46p PS=7u PD=7.2u
* device instance $281 r0 *1 735.6,64.9 NMOS
XM$281 VSS \$I3671 \$I3670 VSS NMOS L=1u W=3.4u AS=6.46p AD=6.12p PS=7.2u PD=7u
* device instance $282 r0 *1 740.2,64.9 NMOS
XM$282 \$I3670 WL2 BLB30 VSS NMOS L=1u W=3.4u AS=6.12p AD=9.52p PS=7u PD=12.4u
* device instance $283 m0 *1 708.8,329.1 PMOS
XM$283 \$I3673 \$I3672 VDD VDD PMOS L=1u W=3.4u AS=10.88p AD=6.46p PS=13.2u
+ PD=7.2u
* device instance $284 m0 *1 713.6,329.1 PMOS
XM$284 VDD \$I3673 \$I3672 VDD PMOS L=1u W=3.4u AS=6.46p AD=10.88p PS=7.2u
+ PD=13.2u
* device instance $285 m0 *1 704.2,349.5 NMOS
XM$285 BL29 WL11 \$I3673 VSS NMOS L=1u W=3.4u AS=9.52p AD=6.12p PS=12.4u PD=7u
* device instance $286 m0 *1 708.8,349.5 NMOS
XM$286 \$I3673 \$I3672 VSS VSS NMOS L=1u W=3.4u AS=6.12p AD=6.46p PS=7u PD=7.2u
* device instance $287 m0 *1 713.6,349.5 NMOS
XM$287 VSS \$I3673 \$I3672 VSS NMOS L=1u W=3.4u AS=6.46p AD=6.12p PS=7.2u PD=7u
* device instance $288 m0 *1 718.2,349.5 NMOS
XM$288 \$I3672 WL11 BLB29 VSS NMOS L=1u W=3.4u AS=6.12p AD=9.52p PS=7u PD=12.4u
* device instance $289 m0 *1 708.8,269.9 PMOS
XM$289 \$I3675 \$I3674 VDD VDD PMOS L=1u W=3.4u AS=10.88p AD=6.46p PS=13.2u
+ PD=7.2u
* device instance $290 m0 *1 713.6,269.9 PMOS
XM$290 VDD \$I3675 \$I3674 VDD PMOS L=1u W=3.4u AS=6.46p AD=10.88p PS=7.2u
+ PD=13.2u
* device instance $291 m0 *1 704.2,290.3 NMOS
XM$291 BL29 WL9 \$I3675 VSS NMOS L=1u W=3.4u AS=9.52p AD=6.12p PS=12.4u PD=7u
* device instance $292 m0 *1 708.8,290.3 NMOS
XM$292 \$I3675 \$I3674 VSS VSS NMOS L=1u W=3.4u AS=6.12p AD=6.46p PS=7u PD=7.2u
* device instance $293 m0 *1 713.6,290.3 NMOS
XM$293 VSS \$I3675 \$I3674 VSS NMOS L=1u W=3.4u AS=6.46p AD=6.12p PS=7.2u PD=7u
* device instance $294 m0 *1 718.2,290.3 NMOS
XM$294 \$I3674 WL9 BLB29 VSS NMOS L=1u W=3.4u AS=6.12p AD=9.52p PS=7u PD=12.4u
* device instance $295 m0 *1 708.8,447.5 PMOS
XM$295 \$I3677 \$I3676 VDD VDD PMOS L=1u W=3.4u AS=10.88p AD=6.46p PS=13.2u
+ PD=7.2u
* device instance $296 m0 *1 713.6,447.5 PMOS
XM$296 VDD \$I3677 \$I3676 VDD PMOS L=1u W=3.4u AS=6.46p AD=10.88p PS=7.2u
+ PD=13.2u
* device instance $297 m0 *1 704.2,467.9 NMOS
XM$297 BL29 WL15 \$I3677 VSS NMOS L=1u W=3.4u AS=9.52p AD=6.12p PS=12.4u PD=7u
* device instance $298 m0 *1 708.8,467.9 NMOS
XM$298 \$I3677 \$I3676 VSS VSS NMOS L=1u W=3.4u AS=6.12p AD=6.46p PS=7u PD=7.2u
* device instance $299 m0 *1 713.6,467.9 NMOS
XM$299 VSS \$I3677 \$I3676 VSS NMOS L=1u W=3.4u AS=6.46p AD=6.12p PS=7.2u PD=7u
* device instance $300 m0 *1 718.2,467.9 NMOS
XM$300 \$I3676 WL15 BLB29 VSS NMOS L=1u W=3.4u AS=6.12p AD=9.52p PS=7u PD=12.4u
* device instance $301 m0 *1 708.8,388.3 PMOS
XM$301 \$I3679 \$I3678 VDD VDD PMOS L=1u W=3.4u AS=10.88p AD=6.46p PS=13.2u
+ PD=7.2u
* device instance $302 m0 *1 713.6,388.3 PMOS
XM$302 VDD \$I3679 \$I3678 VDD PMOS L=1u W=3.4u AS=6.46p AD=10.88p PS=7.2u
+ PD=13.2u
* device instance $303 m0 *1 704.2,408.7 NMOS
XM$303 BL29 WL13 \$I3679 VSS NMOS L=1u W=3.4u AS=9.52p AD=6.12p PS=12.4u PD=7u
* device instance $304 m0 *1 708.8,408.7 NMOS
XM$304 \$I3679 \$I3678 VSS VSS NMOS L=1u W=3.4u AS=6.12p AD=6.46p PS=7u PD=7.2u
* device instance $305 m0 *1 713.6,408.7 NMOS
XM$305 VSS \$I3679 \$I3678 VSS NMOS L=1u W=3.4u AS=6.46p AD=6.12p PS=7.2u PD=7u
* device instance $306 m0 *1 718.2,408.7 NMOS
XM$306 \$I3678 WL13 BLB29 VSS NMOS L=1u W=3.4u AS=6.12p AD=9.52p PS=7u PD=12.4u
* device instance $307 m0 *1 708.8,92.3 PMOS
XM$307 \$I3681 \$I3680 VDD VDD PMOS L=1u W=3.4u AS=10.88p AD=6.46p PS=13.2u
+ PD=7.2u
* device instance $308 m0 *1 713.6,92.3 PMOS
XM$308 VDD \$I3681 \$I3680 VDD PMOS L=1u W=3.4u AS=6.46p AD=10.88p PS=7.2u
+ PD=13.2u
* device instance $309 m0 *1 704.2,112.7 NMOS
XM$309 BL29 WL3 \$I3681 VSS NMOS L=1u W=3.4u AS=9.52p AD=6.12p PS=12.4u PD=7u
* device instance $310 m0 *1 708.8,112.7 NMOS
XM$310 \$I3681 \$I3680 VSS VSS NMOS L=1u W=3.4u AS=6.12p AD=6.46p PS=7u PD=7.2u
* device instance $311 m0 *1 713.6,112.7 NMOS
XM$311 VSS \$I3681 \$I3680 VSS NMOS L=1u W=3.4u AS=6.46p AD=6.12p PS=7.2u PD=7u
* device instance $312 m0 *1 718.2,112.7 NMOS
XM$312 \$I3680 WL3 BLB29 VSS NMOS L=1u W=3.4u AS=6.12p AD=9.52p PS=7u PD=12.4u
* device instance $313 m0 *1 708.8,33.1 PMOS
XM$313 \$I3683 \$I3682 VDD VDD PMOS L=1u W=3.4u AS=10.88p AD=6.46p PS=13.2u
+ PD=7.2u
* device instance $314 m0 *1 713.6,33.1 PMOS
XM$314 VDD \$I3683 \$I3682 VDD PMOS L=1u W=3.4u AS=6.46p AD=10.88p PS=7.2u
+ PD=13.2u
* device instance $315 m0 *1 704.2,53.5 NMOS
XM$315 BL29 WL1 \$I3683 VSS NMOS L=1u W=3.4u AS=9.52p AD=6.12p PS=12.4u PD=7u
* device instance $316 m0 *1 708.8,53.5 NMOS
XM$316 \$I3683 \$I3682 VSS VSS NMOS L=1u W=3.4u AS=6.12p AD=6.46p PS=7u PD=7.2u
* device instance $317 m0 *1 713.6,53.5 NMOS
XM$317 VSS \$I3683 \$I3682 VSS NMOS L=1u W=3.4u AS=6.46p AD=6.12p PS=7.2u PD=7u
* device instance $318 m0 *1 718.2,53.5 NMOS
XM$318 \$I3682 WL1 BLB29 VSS NMOS L=1u W=3.4u AS=6.12p AD=9.52p PS=7u PD=12.4u
* device instance $319 m0 *1 708.8,210.7 PMOS
XM$319 \$I3685 \$I3684 VDD VDD PMOS L=1u W=3.4u AS=10.88p AD=6.46p PS=13.2u
+ PD=7.2u
* device instance $320 m0 *1 713.6,210.7 PMOS
XM$320 VDD \$I3685 \$I3684 VDD PMOS L=1u W=3.4u AS=6.46p AD=10.88p PS=7.2u
+ PD=13.2u
* device instance $321 m0 *1 704.2,231.1 NMOS
XM$321 BL29 WL7 \$I3685 VSS NMOS L=1u W=3.4u AS=9.52p AD=6.12p PS=12.4u PD=7u
* device instance $322 m0 *1 708.8,231.1 NMOS
XM$322 \$I3685 \$I3684 VSS VSS NMOS L=1u W=3.4u AS=6.12p AD=6.46p PS=7u PD=7.2u
* device instance $323 m0 *1 713.6,231.1 NMOS
XM$323 VSS \$I3685 \$I3684 VSS NMOS L=1u W=3.4u AS=6.46p AD=6.12p PS=7.2u PD=7u
* device instance $324 m0 *1 718.2,231.1 NMOS
XM$324 \$I3684 WL7 BLB29 VSS NMOS L=1u W=3.4u AS=6.12p AD=9.52p PS=7u PD=12.4u
* device instance $325 m0 *1 708.8,151.5 PMOS
XM$325 \$I3687 \$I3686 VDD VDD PMOS L=1u W=3.4u AS=10.88p AD=6.46p PS=13.2u
+ PD=7.2u
* device instance $326 m0 *1 713.6,151.5 PMOS
XM$326 VDD \$I3687 \$I3686 VDD PMOS L=1u W=3.4u AS=6.46p AD=10.88p PS=7.2u
+ PD=13.2u
* device instance $327 m0 *1 704.2,171.9 NMOS
XM$327 BL29 WL5 \$I3687 VSS NMOS L=1u W=3.4u AS=9.52p AD=6.12p PS=12.4u PD=7u
* device instance $328 m0 *1 708.8,171.9 NMOS
XM$328 \$I3687 \$I3686 VSS VSS NMOS L=1u W=3.4u AS=6.12p AD=6.46p PS=7u PD=7.2u
* device instance $329 m0 *1 713.6,171.9 NMOS
XM$329 VSS \$I3687 \$I3686 VSS NMOS L=1u W=3.4u AS=6.46p AD=6.12p PS=7.2u PD=7u
* device instance $330 m0 *1 718.2,171.9 NMOS
XM$330 \$I3686 WL5 BLB29 VSS NMOS L=1u W=3.4u AS=6.12p AD=9.52p PS=7u PD=12.4u
* device instance $331 r0 *1 708.8,381.3 PMOS
XM$331 \$I3689 \$I3688 VDD VDD PMOS L=1u W=3.4u AS=10.88p AD=6.46p PS=13.2u
+ PD=7.2u
* device instance $332 r0 *1 713.6,381.3 PMOS
XM$332 VDD \$I3689 \$I3688 VDD PMOS L=1u W=3.4u AS=6.46p AD=10.88p PS=7.2u
+ PD=13.2u
* device instance $333 r0 *1 704.2,360.9 NMOS
XM$333 BL29 WL12 \$I3689 VSS NMOS L=1u W=3.4u AS=9.52p AD=6.12p PS=12.4u PD=7u
* device instance $334 r0 *1 708.8,360.9 NMOS
XM$334 \$I3689 \$I3688 VSS VSS NMOS L=1u W=3.4u AS=6.12p AD=6.46p PS=7u PD=7.2u
* device instance $335 r0 *1 713.6,360.9 NMOS
XM$335 VSS \$I3689 \$I3688 VSS NMOS L=1u W=3.4u AS=6.46p AD=6.12p PS=7.2u PD=7u
* device instance $336 r0 *1 718.2,360.9 NMOS
XM$336 \$I3688 WL12 BLB29 VSS NMOS L=1u W=3.4u AS=6.12p AD=9.52p PS=7u PD=12.4u
* device instance $337 r0 *1 708.8,440.5 PMOS
XM$337 \$I3691 \$I3690 VDD VDD PMOS L=1u W=3.4u AS=10.88p AD=6.46p PS=13.2u
+ PD=7.2u
* device instance $338 r0 *1 713.6,440.5 PMOS
XM$338 VDD \$I3691 \$I3690 VDD PMOS L=1u W=3.4u AS=6.46p AD=10.88p PS=7.2u
+ PD=13.2u
* device instance $339 r0 *1 704.2,420.1 NMOS
XM$339 BL29 WL14 \$I3691 VSS NMOS L=1u W=3.4u AS=9.52p AD=6.12p PS=12.4u PD=7u
* device instance $340 r0 *1 708.8,420.1 NMOS
XM$340 \$I3691 \$I3690 VSS VSS NMOS L=1u W=3.4u AS=6.12p AD=6.46p PS=7u PD=7.2u
* device instance $341 r0 *1 713.6,420.1 NMOS
XM$341 VSS \$I3691 \$I3690 VSS NMOS L=1u W=3.4u AS=6.46p AD=6.12p PS=7.2u PD=7u
* device instance $342 r0 *1 718.2,420.1 NMOS
XM$342 \$I3690 WL14 BLB29 VSS NMOS L=1u W=3.4u AS=6.12p AD=9.52p PS=7u PD=12.4u
* device instance $343 r0 *1 708.8,322.1 PMOS
XM$343 \$I3693 \$I3692 VDD VDD PMOS L=1u W=3.4u AS=10.88p AD=6.46p PS=13.2u
+ PD=7.2u
* device instance $344 r0 *1 713.6,322.1 PMOS
XM$344 VDD \$I3693 \$I3692 VDD PMOS L=1u W=3.4u AS=6.46p AD=10.88p PS=7.2u
+ PD=13.2u
* device instance $345 r0 *1 704.2,301.7 NMOS
XM$345 BL29 WL10 \$I3693 VSS NMOS L=1u W=3.4u AS=9.52p AD=6.12p PS=12.4u PD=7u
* device instance $346 r0 *1 708.8,301.7 NMOS
XM$346 \$I3693 \$I3692 VSS VSS NMOS L=1u W=3.4u AS=6.12p AD=6.46p PS=7u PD=7.2u
* device instance $347 r0 *1 713.6,301.7 NMOS
XM$347 VSS \$I3693 \$I3692 VSS NMOS L=1u W=3.4u AS=6.46p AD=6.12p PS=7.2u PD=7u
* device instance $348 r0 *1 718.2,301.7 NMOS
XM$348 \$I3692 WL10 BLB29 VSS NMOS L=1u W=3.4u AS=6.12p AD=9.52p PS=7u PD=12.4u
* device instance $349 r0 *1 708.8,262.9 PMOS
XM$349 \$I3695 \$I3694 VDD VDD PMOS L=1u W=3.4u AS=10.88p AD=6.46p PS=13.2u
+ PD=7.2u
* device instance $350 r0 *1 713.6,262.9 PMOS
XM$350 VDD \$I3695 \$I3694 VDD PMOS L=1u W=3.4u AS=6.46p AD=10.88p PS=7.2u
+ PD=13.2u
* device instance $351 r0 *1 704.2,242.5 NMOS
XM$351 BL29 WL8 \$I3695 VSS NMOS L=1u W=3.4u AS=9.52p AD=6.12p PS=12.4u PD=7u
* device instance $352 r0 *1 708.8,242.5 NMOS
XM$352 \$I3695 \$I3694 VSS VSS NMOS L=1u W=3.4u AS=6.12p AD=6.46p PS=7u PD=7.2u
* device instance $353 r0 *1 713.6,242.5 NMOS
XM$353 VSS \$I3695 \$I3694 VSS NMOS L=1u W=3.4u AS=6.46p AD=6.12p PS=7.2u PD=7u
* device instance $354 r0 *1 718.2,242.5 NMOS
XM$354 \$I3694 WL8 BLB29 VSS NMOS L=1u W=3.4u AS=6.12p AD=9.52p PS=7u PD=12.4u
* device instance $355 r0 *1 708.8,144.5 PMOS
XM$355 \$I3697 \$I3696 VDD VDD PMOS L=1u W=3.4u AS=10.88p AD=6.46p PS=13.2u
+ PD=7.2u
* device instance $356 r0 *1 713.6,144.5 PMOS
XM$356 VDD \$I3697 \$I3696 VDD PMOS L=1u W=3.4u AS=6.46p AD=10.88p PS=7.2u
+ PD=13.2u
* device instance $357 r0 *1 704.2,124.1 NMOS
XM$357 BL29 WL4 \$I3697 VSS NMOS L=1u W=3.4u AS=9.52p AD=6.12p PS=12.4u PD=7u
* device instance $358 r0 *1 708.8,124.1 NMOS
XM$358 \$I3697 \$I3696 VSS VSS NMOS L=1u W=3.4u AS=6.12p AD=6.46p PS=7u PD=7.2u
* device instance $359 r0 *1 713.6,124.1 NMOS
XM$359 VSS \$I3697 \$I3696 VSS NMOS L=1u W=3.4u AS=6.46p AD=6.12p PS=7.2u PD=7u
* device instance $360 r0 *1 718.2,124.1 NMOS
XM$360 \$I3696 WL4 BLB29 VSS NMOS L=1u W=3.4u AS=6.12p AD=9.52p PS=7u PD=12.4u
* device instance $361 r0 *1 708.8,203.7 PMOS
XM$361 \$I3699 \$I3698 VDD VDD PMOS L=1u W=3.4u AS=10.88p AD=6.46p PS=13.2u
+ PD=7.2u
* device instance $362 r0 *1 713.6,203.7 PMOS
XM$362 VDD \$I3699 \$I3698 VDD PMOS L=1u W=3.4u AS=6.46p AD=10.88p PS=7.2u
+ PD=13.2u
* device instance $363 r0 *1 704.2,183.3 NMOS
XM$363 BL29 WL6 \$I3699 VSS NMOS L=1u W=3.4u AS=9.52p AD=6.12p PS=12.4u PD=7u
* device instance $364 r0 *1 708.8,183.3 NMOS
XM$364 \$I3699 \$I3698 VSS VSS NMOS L=1u W=3.4u AS=6.12p AD=6.46p PS=7u PD=7.2u
* device instance $365 r0 *1 713.6,183.3 NMOS
XM$365 VSS \$I3699 \$I3698 VSS NMOS L=1u W=3.4u AS=6.46p AD=6.12p PS=7.2u PD=7u
* device instance $366 r0 *1 718.2,183.3 NMOS
XM$366 \$I3698 WL6 BLB29 VSS NMOS L=1u W=3.4u AS=6.12p AD=9.52p PS=7u PD=12.4u
* device instance $367 r0 *1 708.8,85.3 PMOS
XM$367 \$I3701 \$I3700 VDD VDD PMOS L=1u W=3.4u AS=10.88p AD=6.46p PS=13.2u
+ PD=7.2u
* device instance $368 r0 *1 713.6,85.3 PMOS
XM$368 VDD \$I3701 \$I3700 VDD PMOS L=1u W=3.4u AS=6.46p AD=10.88p PS=7.2u
+ PD=13.2u
* device instance $369 r0 *1 704.2,64.9 NMOS
XM$369 BL29 WL2 \$I3701 VSS NMOS L=1u W=3.4u AS=9.52p AD=6.12p PS=12.4u PD=7u
* device instance $370 r0 *1 708.8,64.9 NMOS
XM$370 \$I3701 \$I3700 VSS VSS NMOS L=1u W=3.4u AS=6.12p AD=6.46p PS=7u PD=7.2u
* device instance $371 r0 *1 713.6,64.9 NMOS
XM$371 VSS \$I3701 \$I3700 VSS NMOS L=1u W=3.4u AS=6.46p AD=6.12p PS=7.2u PD=7u
* device instance $372 r0 *1 718.2,64.9 NMOS
XM$372 \$I3700 WL2 BLB29 VSS NMOS L=1u W=3.4u AS=6.12p AD=9.52p PS=7u PD=12.4u
* device instance $373 m0 *1 686.8,329.1 PMOS
XM$373 \$I3703 \$I3702 VDD VDD PMOS L=1u W=3.4u AS=10.88p AD=6.46p PS=13.2u
+ PD=7.2u
* device instance $374 m0 *1 691.6,329.1 PMOS
XM$374 VDD \$I3703 \$I3702 VDD PMOS L=1u W=3.4u AS=6.46p AD=10.88p PS=7.2u
+ PD=13.2u
* device instance $375 m0 *1 682.2,349.5 NMOS
XM$375 BL28 WL11 \$I3703 VSS NMOS L=1u W=3.4u AS=9.52p AD=6.12p PS=12.4u PD=7u
* device instance $376 m0 *1 686.8,349.5 NMOS
XM$376 \$I3703 \$I3702 VSS VSS NMOS L=1u W=3.4u AS=6.12p AD=6.46p PS=7u PD=7.2u
* device instance $377 m0 *1 691.6,349.5 NMOS
XM$377 VSS \$I3703 \$I3702 VSS NMOS L=1u W=3.4u AS=6.46p AD=6.12p PS=7.2u PD=7u
* device instance $378 m0 *1 696.2,349.5 NMOS
XM$378 \$I3702 WL11 BLB28 VSS NMOS L=1u W=3.4u AS=6.12p AD=9.52p PS=7u PD=12.4u
* device instance $379 m0 *1 686.8,269.9 PMOS
XM$379 \$I3705 \$I3704 VDD VDD PMOS L=1u W=3.4u AS=10.88p AD=6.46p PS=13.2u
+ PD=7.2u
* device instance $380 m0 *1 691.6,269.9 PMOS
XM$380 VDD \$I3705 \$I3704 VDD PMOS L=1u W=3.4u AS=6.46p AD=10.88p PS=7.2u
+ PD=13.2u
* device instance $381 m0 *1 682.2,290.3 NMOS
XM$381 BL28 WL9 \$I3705 VSS NMOS L=1u W=3.4u AS=9.52p AD=6.12p PS=12.4u PD=7u
* device instance $382 m0 *1 686.8,290.3 NMOS
XM$382 \$I3705 \$I3704 VSS VSS NMOS L=1u W=3.4u AS=6.12p AD=6.46p PS=7u PD=7.2u
* device instance $383 m0 *1 691.6,290.3 NMOS
XM$383 VSS \$I3705 \$I3704 VSS NMOS L=1u W=3.4u AS=6.46p AD=6.12p PS=7.2u PD=7u
* device instance $384 m0 *1 696.2,290.3 NMOS
XM$384 \$I3704 WL9 BLB28 VSS NMOS L=1u W=3.4u AS=6.12p AD=9.52p PS=7u PD=12.4u
* device instance $385 m0 *1 686.8,447.5 PMOS
XM$385 \$I3707 \$I3706 VDD VDD PMOS L=1u W=3.4u AS=10.88p AD=6.46p PS=13.2u
+ PD=7.2u
* device instance $386 m0 *1 691.6,447.5 PMOS
XM$386 VDD \$I3707 \$I3706 VDD PMOS L=1u W=3.4u AS=6.46p AD=10.88p PS=7.2u
+ PD=13.2u
* device instance $387 m0 *1 682.2,467.9 NMOS
XM$387 BL28 WL15 \$I3707 VSS NMOS L=1u W=3.4u AS=9.52p AD=6.12p PS=12.4u PD=7u
* device instance $388 m0 *1 686.8,467.9 NMOS
XM$388 \$I3707 \$I3706 VSS VSS NMOS L=1u W=3.4u AS=6.12p AD=6.46p PS=7u PD=7.2u
* device instance $389 m0 *1 691.6,467.9 NMOS
XM$389 VSS \$I3707 \$I3706 VSS NMOS L=1u W=3.4u AS=6.46p AD=6.12p PS=7.2u PD=7u
* device instance $390 m0 *1 696.2,467.9 NMOS
XM$390 \$I3706 WL15 BLB28 VSS NMOS L=1u W=3.4u AS=6.12p AD=9.52p PS=7u PD=12.4u
* device instance $391 m0 *1 686.8,388.3 PMOS
XM$391 \$I3709 \$I3708 VDD VDD PMOS L=1u W=3.4u AS=10.88p AD=6.46p PS=13.2u
+ PD=7.2u
* device instance $392 m0 *1 691.6,388.3 PMOS
XM$392 VDD \$I3709 \$I3708 VDD PMOS L=1u W=3.4u AS=6.46p AD=10.88p PS=7.2u
+ PD=13.2u
* device instance $393 m0 *1 682.2,408.7 NMOS
XM$393 BL28 WL13 \$I3709 VSS NMOS L=1u W=3.4u AS=9.52p AD=6.12p PS=12.4u PD=7u
* device instance $394 m0 *1 686.8,408.7 NMOS
XM$394 \$I3709 \$I3708 VSS VSS NMOS L=1u W=3.4u AS=6.12p AD=6.46p PS=7u PD=7.2u
* device instance $395 m0 *1 691.6,408.7 NMOS
XM$395 VSS \$I3709 \$I3708 VSS NMOS L=1u W=3.4u AS=6.46p AD=6.12p PS=7.2u PD=7u
* device instance $396 m0 *1 696.2,408.7 NMOS
XM$396 \$I3708 WL13 BLB28 VSS NMOS L=1u W=3.4u AS=6.12p AD=9.52p PS=7u PD=12.4u
* device instance $397 m0 *1 686.8,92.3 PMOS
XM$397 \$I3711 \$I3710 VDD VDD PMOS L=1u W=3.4u AS=10.88p AD=6.46p PS=13.2u
+ PD=7.2u
* device instance $398 m0 *1 691.6,92.3 PMOS
XM$398 VDD \$I3711 \$I3710 VDD PMOS L=1u W=3.4u AS=6.46p AD=10.88p PS=7.2u
+ PD=13.2u
* device instance $399 m0 *1 682.2,112.7 NMOS
XM$399 BL28 WL3 \$I3711 VSS NMOS L=1u W=3.4u AS=9.52p AD=6.12p PS=12.4u PD=7u
* device instance $400 m0 *1 686.8,112.7 NMOS
XM$400 \$I3711 \$I3710 VSS VSS NMOS L=1u W=3.4u AS=6.12p AD=6.46p PS=7u PD=7.2u
* device instance $401 m0 *1 691.6,112.7 NMOS
XM$401 VSS \$I3711 \$I3710 VSS NMOS L=1u W=3.4u AS=6.46p AD=6.12p PS=7.2u PD=7u
* device instance $402 m0 *1 696.2,112.7 NMOS
XM$402 \$I3710 WL3 BLB28 VSS NMOS L=1u W=3.4u AS=6.12p AD=9.52p PS=7u PD=12.4u
* device instance $403 m0 *1 686.8,33.1 PMOS
XM$403 \$I3713 \$I3712 VDD VDD PMOS L=1u W=3.4u AS=10.88p AD=6.46p PS=13.2u
+ PD=7.2u
* device instance $404 m0 *1 691.6,33.1 PMOS
XM$404 VDD \$I3713 \$I3712 VDD PMOS L=1u W=3.4u AS=6.46p AD=10.88p PS=7.2u
+ PD=13.2u
* device instance $405 m0 *1 682.2,53.5 NMOS
XM$405 BL28 WL1 \$I3713 VSS NMOS L=1u W=3.4u AS=9.52p AD=6.12p PS=12.4u PD=7u
* device instance $406 m0 *1 686.8,53.5 NMOS
XM$406 \$I3713 \$I3712 VSS VSS NMOS L=1u W=3.4u AS=6.12p AD=6.46p PS=7u PD=7.2u
* device instance $407 m0 *1 691.6,53.5 NMOS
XM$407 VSS \$I3713 \$I3712 VSS NMOS L=1u W=3.4u AS=6.46p AD=6.12p PS=7.2u PD=7u
* device instance $408 m0 *1 696.2,53.5 NMOS
XM$408 \$I3712 WL1 BLB28 VSS NMOS L=1u W=3.4u AS=6.12p AD=9.52p PS=7u PD=12.4u
* device instance $409 m0 *1 686.8,210.7 PMOS
XM$409 \$I3715 \$I3714 VDD VDD PMOS L=1u W=3.4u AS=10.88p AD=6.46p PS=13.2u
+ PD=7.2u
* device instance $410 m0 *1 691.6,210.7 PMOS
XM$410 VDD \$I3715 \$I3714 VDD PMOS L=1u W=3.4u AS=6.46p AD=10.88p PS=7.2u
+ PD=13.2u
* device instance $411 m0 *1 682.2,231.1 NMOS
XM$411 BL28 WL7 \$I3715 VSS NMOS L=1u W=3.4u AS=9.52p AD=6.12p PS=12.4u PD=7u
* device instance $412 m0 *1 686.8,231.1 NMOS
XM$412 \$I3715 \$I3714 VSS VSS NMOS L=1u W=3.4u AS=6.12p AD=6.46p PS=7u PD=7.2u
* device instance $413 m0 *1 691.6,231.1 NMOS
XM$413 VSS \$I3715 \$I3714 VSS NMOS L=1u W=3.4u AS=6.46p AD=6.12p PS=7.2u PD=7u
* device instance $414 m0 *1 696.2,231.1 NMOS
XM$414 \$I3714 WL7 BLB28 VSS NMOS L=1u W=3.4u AS=6.12p AD=9.52p PS=7u PD=12.4u
* device instance $415 m0 *1 686.8,151.5 PMOS
XM$415 \$I3717 \$I3716 VDD VDD PMOS L=1u W=3.4u AS=10.88p AD=6.46p PS=13.2u
+ PD=7.2u
* device instance $416 m0 *1 691.6,151.5 PMOS
XM$416 VDD \$I3717 \$I3716 VDD PMOS L=1u W=3.4u AS=6.46p AD=10.88p PS=7.2u
+ PD=13.2u
* device instance $417 m0 *1 682.2,171.9 NMOS
XM$417 BL28 WL5 \$I3717 VSS NMOS L=1u W=3.4u AS=9.52p AD=6.12p PS=12.4u PD=7u
* device instance $418 m0 *1 686.8,171.9 NMOS
XM$418 \$I3717 \$I3716 VSS VSS NMOS L=1u W=3.4u AS=6.12p AD=6.46p PS=7u PD=7.2u
* device instance $419 m0 *1 691.6,171.9 NMOS
XM$419 VSS \$I3717 \$I3716 VSS NMOS L=1u W=3.4u AS=6.46p AD=6.12p PS=7.2u PD=7u
* device instance $420 m0 *1 696.2,171.9 NMOS
XM$420 \$I3716 WL5 BLB28 VSS NMOS L=1u W=3.4u AS=6.12p AD=9.52p PS=7u PD=12.4u
* device instance $421 r0 *1 686.8,381.3 PMOS
XM$421 \$I3719 \$I3718 VDD VDD PMOS L=1u W=3.4u AS=10.88p AD=6.46p PS=13.2u
+ PD=7.2u
* device instance $422 r0 *1 691.6,381.3 PMOS
XM$422 VDD \$I3719 \$I3718 VDD PMOS L=1u W=3.4u AS=6.46p AD=10.88p PS=7.2u
+ PD=13.2u
* device instance $423 r0 *1 682.2,360.9 NMOS
XM$423 BL28 WL12 \$I3719 VSS NMOS L=1u W=3.4u AS=9.52p AD=6.12p PS=12.4u PD=7u
* device instance $424 r0 *1 686.8,360.9 NMOS
XM$424 \$I3719 \$I3718 VSS VSS NMOS L=1u W=3.4u AS=6.12p AD=6.46p PS=7u PD=7.2u
* device instance $425 r0 *1 691.6,360.9 NMOS
XM$425 VSS \$I3719 \$I3718 VSS NMOS L=1u W=3.4u AS=6.46p AD=6.12p PS=7.2u PD=7u
* device instance $426 r0 *1 696.2,360.9 NMOS
XM$426 \$I3718 WL12 BLB28 VSS NMOS L=1u W=3.4u AS=6.12p AD=9.52p PS=7u PD=12.4u
* device instance $427 r0 *1 686.8,440.5 PMOS
XM$427 \$I3721 \$I3720 VDD VDD PMOS L=1u W=3.4u AS=10.88p AD=6.46p PS=13.2u
+ PD=7.2u
* device instance $428 r0 *1 691.6,440.5 PMOS
XM$428 VDD \$I3721 \$I3720 VDD PMOS L=1u W=3.4u AS=6.46p AD=10.88p PS=7.2u
+ PD=13.2u
* device instance $429 r0 *1 682.2,420.1 NMOS
XM$429 BL28 WL14 \$I3721 VSS NMOS L=1u W=3.4u AS=9.52p AD=6.12p PS=12.4u PD=7u
* device instance $430 r0 *1 686.8,420.1 NMOS
XM$430 \$I3721 \$I3720 VSS VSS NMOS L=1u W=3.4u AS=6.12p AD=6.46p PS=7u PD=7.2u
* device instance $431 r0 *1 691.6,420.1 NMOS
XM$431 VSS \$I3721 \$I3720 VSS NMOS L=1u W=3.4u AS=6.46p AD=6.12p PS=7.2u PD=7u
* device instance $432 r0 *1 696.2,420.1 NMOS
XM$432 \$I3720 WL14 BLB28 VSS NMOS L=1u W=3.4u AS=6.12p AD=9.52p PS=7u PD=12.4u
* device instance $433 r0 *1 686.8,322.1 PMOS
XM$433 \$I3723 \$I3722 VDD VDD PMOS L=1u W=3.4u AS=10.88p AD=6.46p PS=13.2u
+ PD=7.2u
* device instance $434 r0 *1 691.6,322.1 PMOS
XM$434 VDD \$I3723 \$I3722 VDD PMOS L=1u W=3.4u AS=6.46p AD=10.88p PS=7.2u
+ PD=13.2u
* device instance $435 r0 *1 682.2,301.7 NMOS
XM$435 BL28 WL10 \$I3723 VSS NMOS L=1u W=3.4u AS=9.52p AD=6.12p PS=12.4u PD=7u
* device instance $436 r0 *1 686.8,301.7 NMOS
XM$436 \$I3723 \$I3722 VSS VSS NMOS L=1u W=3.4u AS=6.12p AD=6.46p PS=7u PD=7.2u
* device instance $437 r0 *1 691.6,301.7 NMOS
XM$437 VSS \$I3723 \$I3722 VSS NMOS L=1u W=3.4u AS=6.46p AD=6.12p PS=7.2u PD=7u
* device instance $438 r0 *1 696.2,301.7 NMOS
XM$438 \$I3722 WL10 BLB28 VSS NMOS L=1u W=3.4u AS=6.12p AD=9.52p PS=7u PD=12.4u
* device instance $439 r0 *1 686.8,262.9 PMOS
XM$439 \$I3725 \$I3724 VDD VDD PMOS L=1u W=3.4u AS=10.88p AD=6.46p PS=13.2u
+ PD=7.2u
* device instance $440 r0 *1 691.6,262.9 PMOS
XM$440 VDD \$I3725 \$I3724 VDD PMOS L=1u W=3.4u AS=6.46p AD=10.88p PS=7.2u
+ PD=13.2u
* device instance $441 r0 *1 682.2,242.5 NMOS
XM$441 BL28 WL8 \$I3725 VSS NMOS L=1u W=3.4u AS=9.52p AD=6.12p PS=12.4u PD=7u
* device instance $442 r0 *1 686.8,242.5 NMOS
XM$442 \$I3725 \$I3724 VSS VSS NMOS L=1u W=3.4u AS=6.12p AD=6.46p PS=7u PD=7.2u
* device instance $443 r0 *1 691.6,242.5 NMOS
XM$443 VSS \$I3725 \$I3724 VSS NMOS L=1u W=3.4u AS=6.46p AD=6.12p PS=7.2u PD=7u
* device instance $444 r0 *1 696.2,242.5 NMOS
XM$444 \$I3724 WL8 BLB28 VSS NMOS L=1u W=3.4u AS=6.12p AD=9.52p PS=7u PD=12.4u
* device instance $445 r0 *1 686.8,144.5 PMOS
XM$445 \$I3727 \$I3726 VDD VDD PMOS L=1u W=3.4u AS=10.88p AD=6.46p PS=13.2u
+ PD=7.2u
* device instance $446 r0 *1 691.6,144.5 PMOS
XM$446 VDD \$I3727 \$I3726 VDD PMOS L=1u W=3.4u AS=6.46p AD=10.88p PS=7.2u
+ PD=13.2u
* device instance $447 r0 *1 682.2,124.1 NMOS
XM$447 BL28 WL4 \$I3727 VSS NMOS L=1u W=3.4u AS=9.52p AD=6.12p PS=12.4u PD=7u
* device instance $448 r0 *1 686.8,124.1 NMOS
XM$448 \$I3727 \$I3726 VSS VSS NMOS L=1u W=3.4u AS=6.12p AD=6.46p PS=7u PD=7.2u
* device instance $449 r0 *1 691.6,124.1 NMOS
XM$449 VSS \$I3727 \$I3726 VSS NMOS L=1u W=3.4u AS=6.46p AD=6.12p PS=7.2u PD=7u
* device instance $450 r0 *1 696.2,124.1 NMOS
XM$450 \$I3726 WL4 BLB28 VSS NMOS L=1u W=3.4u AS=6.12p AD=9.52p PS=7u PD=12.4u
* device instance $451 r0 *1 686.8,203.7 PMOS
XM$451 \$I3729 \$I3728 VDD VDD PMOS L=1u W=3.4u AS=10.88p AD=6.46p PS=13.2u
+ PD=7.2u
* device instance $452 r0 *1 691.6,203.7 PMOS
XM$452 VDD \$I3729 \$I3728 VDD PMOS L=1u W=3.4u AS=6.46p AD=10.88p PS=7.2u
+ PD=13.2u
* device instance $453 r0 *1 682.2,183.3 NMOS
XM$453 BL28 WL6 \$I3729 VSS NMOS L=1u W=3.4u AS=9.52p AD=6.12p PS=12.4u PD=7u
* device instance $454 r0 *1 686.8,183.3 NMOS
XM$454 \$I3729 \$I3728 VSS VSS NMOS L=1u W=3.4u AS=6.12p AD=6.46p PS=7u PD=7.2u
* device instance $455 r0 *1 691.6,183.3 NMOS
XM$455 VSS \$I3729 \$I3728 VSS NMOS L=1u W=3.4u AS=6.46p AD=6.12p PS=7.2u PD=7u
* device instance $456 r0 *1 696.2,183.3 NMOS
XM$456 \$I3728 WL6 BLB28 VSS NMOS L=1u W=3.4u AS=6.12p AD=9.52p PS=7u PD=12.4u
* device instance $457 r0 *1 686.8,85.3 PMOS
XM$457 \$I3731 \$I3730 VDD VDD PMOS L=1u W=3.4u AS=10.88p AD=6.46p PS=13.2u
+ PD=7.2u
* device instance $458 r0 *1 691.6,85.3 PMOS
XM$458 VDD \$I3731 \$I3730 VDD PMOS L=1u W=3.4u AS=6.46p AD=10.88p PS=7.2u
+ PD=13.2u
* device instance $459 r0 *1 682.2,64.9 NMOS
XM$459 BL28 WL2 \$I3731 VSS NMOS L=1u W=3.4u AS=9.52p AD=6.12p PS=12.4u PD=7u
* device instance $460 r0 *1 686.8,64.9 NMOS
XM$460 \$I3731 \$I3730 VSS VSS NMOS L=1u W=3.4u AS=6.12p AD=6.46p PS=7u PD=7.2u
* device instance $461 r0 *1 691.6,64.9 NMOS
XM$461 VSS \$I3731 \$I3730 VSS NMOS L=1u W=3.4u AS=6.46p AD=6.12p PS=7.2u PD=7u
* device instance $462 r0 *1 696.2,64.9 NMOS
XM$462 \$I3730 WL2 BLB28 VSS NMOS L=1u W=3.4u AS=6.12p AD=9.52p PS=7u PD=12.4u
* device instance $463 m0 *1 752.8,269.9 PMOS
XM$463 \$I3733 \$I3732 VDD VDD PMOS L=1u W=3.4u AS=10.88p AD=6.46p PS=13.2u
+ PD=7.2u
* device instance $464 m0 *1 757.6,269.9 PMOS
XM$464 VDD \$I3733 \$I3732 VDD PMOS L=1u W=3.4u AS=6.46p AD=10.88p PS=7.2u
+ PD=13.2u
* device instance $465 m0 *1 748.2,290.3 NMOS
XM$465 BL31 WL9 \$I3733 VSS NMOS L=1u W=3.4u AS=9.52p AD=6.12p PS=12.4u PD=7u
* device instance $466 m0 *1 752.8,290.3 NMOS
XM$466 \$I3733 \$I3732 VSS VSS NMOS L=1u W=3.4u AS=6.12p AD=6.46p PS=7u PD=7.2u
* device instance $467 m0 *1 757.6,290.3 NMOS
XM$467 VSS \$I3733 \$I3732 VSS NMOS L=1u W=3.4u AS=6.46p AD=6.12p PS=7.2u PD=7u
* device instance $468 m0 *1 762.2,290.3 NMOS
XM$468 \$I3732 WL9 BLB31 VSS NMOS L=1u W=3.4u AS=6.12p AD=9.52p PS=7u PD=12.4u
* device instance $469 m0 *1 752.8,329.1 PMOS
XM$469 \$I3735 \$I3734 VDD VDD PMOS L=1u W=3.4u AS=10.88p AD=6.46p PS=13.2u
+ PD=7.2u
* device instance $470 m0 *1 757.6,329.1 PMOS
XM$470 VDD \$I3735 \$I3734 VDD PMOS L=1u W=3.4u AS=6.46p AD=10.88p PS=7.2u
+ PD=13.2u
* device instance $471 m0 *1 748.2,349.5 NMOS
XM$471 BL31 WL11 \$I3735 VSS NMOS L=1u W=3.4u AS=9.52p AD=6.12p PS=12.4u PD=7u
* device instance $472 m0 *1 752.8,349.5 NMOS
XM$472 \$I3735 \$I3734 VSS VSS NMOS L=1u W=3.4u AS=6.12p AD=6.46p PS=7u PD=7.2u
* device instance $473 m0 *1 757.6,349.5 NMOS
XM$473 VSS \$I3735 \$I3734 VSS NMOS L=1u W=3.4u AS=6.46p AD=6.12p PS=7.2u PD=7u
* device instance $474 m0 *1 762.2,349.5 NMOS
XM$474 \$I3734 WL11 BLB31 VSS NMOS L=1u W=3.4u AS=6.12p AD=9.52p PS=7u PD=12.4u
* device instance $475 m0 *1 752.8,447.5 PMOS
XM$475 \$I3737 \$I3736 VDD VDD PMOS L=1u W=3.4u AS=10.88p AD=6.46p PS=13.2u
+ PD=7.2u
* device instance $476 m0 *1 757.6,447.5 PMOS
XM$476 VDD \$I3737 \$I3736 VDD PMOS L=1u W=3.4u AS=6.46p AD=10.88p PS=7.2u
+ PD=13.2u
* device instance $477 m0 *1 748.2,467.9 NMOS
XM$477 BL31 WL15 \$I3737 VSS NMOS L=1u W=3.4u AS=9.52p AD=6.12p PS=12.4u PD=7u
* device instance $478 m0 *1 752.8,467.9 NMOS
XM$478 \$I3737 \$I3736 VSS VSS NMOS L=1u W=3.4u AS=6.12p AD=6.46p PS=7u PD=7.2u
* device instance $479 m0 *1 757.6,467.9 NMOS
XM$479 VSS \$I3737 \$I3736 VSS NMOS L=1u W=3.4u AS=6.46p AD=6.12p PS=7.2u PD=7u
* device instance $480 m0 *1 762.2,467.9 NMOS
XM$480 \$I3736 WL15 BLB31 VSS NMOS L=1u W=3.4u AS=6.12p AD=9.52p PS=7u PD=12.4u
* device instance $481 m0 *1 752.8,388.3 PMOS
XM$481 \$I3739 \$I3738 VDD VDD PMOS L=1u W=3.4u AS=10.88p AD=6.46p PS=13.2u
+ PD=7.2u
* device instance $482 m0 *1 757.6,388.3 PMOS
XM$482 VDD \$I3739 \$I3738 VDD PMOS L=1u W=3.4u AS=6.46p AD=10.88p PS=7.2u
+ PD=13.2u
* device instance $483 m0 *1 748.2,408.7 NMOS
XM$483 BL31 WL13 \$I3739 VSS NMOS L=1u W=3.4u AS=9.52p AD=6.12p PS=12.4u PD=7u
* device instance $484 m0 *1 752.8,408.7 NMOS
XM$484 \$I3739 \$I3738 VSS VSS NMOS L=1u W=3.4u AS=6.12p AD=6.46p PS=7u PD=7.2u
* device instance $485 m0 *1 757.6,408.7 NMOS
XM$485 VSS \$I3739 \$I3738 VSS NMOS L=1u W=3.4u AS=6.46p AD=6.12p PS=7.2u PD=7u
* device instance $486 m0 *1 762.2,408.7 NMOS
XM$486 \$I3738 WL13 BLB31 VSS NMOS L=1u W=3.4u AS=6.12p AD=9.52p PS=7u PD=12.4u
* device instance $487 m0 *1 752.8,92.3 PMOS
XM$487 \$I3741 \$I3740 VDD VDD PMOS L=1u W=3.4u AS=10.88p AD=6.46p PS=13.2u
+ PD=7.2u
* device instance $488 m0 *1 757.6,92.3 PMOS
XM$488 VDD \$I3741 \$I3740 VDD PMOS L=1u W=3.4u AS=6.46p AD=10.88p PS=7.2u
+ PD=13.2u
* device instance $489 m0 *1 748.2,112.7 NMOS
XM$489 BL31 WL3 \$I3741 VSS NMOS L=1u W=3.4u AS=9.52p AD=6.12p PS=12.4u PD=7u
* device instance $490 m0 *1 752.8,112.7 NMOS
XM$490 \$I3741 \$I3740 VSS VSS NMOS L=1u W=3.4u AS=6.12p AD=6.46p PS=7u PD=7.2u
* device instance $491 m0 *1 757.6,112.7 NMOS
XM$491 VSS \$I3741 \$I3740 VSS NMOS L=1u W=3.4u AS=6.46p AD=6.12p PS=7.2u PD=7u
* device instance $492 m0 *1 762.2,112.7 NMOS
XM$492 \$I3740 WL3 BLB31 VSS NMOS L=1u W=3.4u AS=6.12p AD=9.52p PS=7u PD=12.4u
* device instance $493 m0 *1 752.8,33.1 PMOS
XM$493 \$I3743 \$I3742 VDD VDD PMOS L=1u W=3.4u AS=10.88p AD=6.46p PS=13.2u
+ PD=7.2u
* device instance $494 m0 *1 757.6,33.1 PMOS
XM$494 VDD \$I3743 \$I3742 VDD PMOS L=1u W=3.4u AS=6.46p AD=10.88p PS=7.2u
+ PD=13.2u
* device instance $495 m0 *1 748.2,53.5 NMOS
XM$495 BL31 WL1 \$I3743 VSS NMOS L=1u W=3.4u AS=9.52p AD=6.12p PS=12.4u PD=7u
* device instance $496 m0 *1 752.8,53.5 NMOS
XM$496 \$I3743 \$I3742 VSS VSS NMOS L=1u W=3.4u AS=6.12p AD=6.46p PS=7u PD=7.2u
* device instance $497 m0 *1 757.6,53.5 NMOS
XM$497 VSS \$I3743 \$I3742 VSS NMOS L=1u W=3.4u AS=6.46p AD=6.12p PS=7.2u PD=7u
* device instance $498 m0 *1 762.2,53.5 NMOS
XM$498 \$I3742 WL1 BLB31 VSS NMOS L=1u W=3.4u AS=6.12p AD=9.52p PS=7u PD=12.4u
* device instance $499 m0 *1 752.8,210.7 PMOS
XM$499 \$I3745 \$I3744 VDD VDD PMOS L=1u W=3.4u AS=10.88p AD=6.46p PS=13.2u
+ PD=7.2u
* device instance $500 m0 *1 757.6,210.7 PMOS
XM$500 VDD \$I3745 \$I3744 VDD PMOS L=1u W=3.4u AS=6.46p AD=10.88p PS=7.2u
+ PD=13.2u
* device instance $501 m0 *1 748.2,231.1 NMOS
XM$501 BL31 WL7 \$I3745 VSS NMOS L=1u W=3.4u AS=9.52p AD=6.12p PS=12.4u PD=7u
* device instance $502 m0 *1 752.8,231.1 NMOS
XM$502 \$I3745 \$I3744 VSS VSS NMOS L=1u W=3.4u AS=6.12p AD=6.46p PS=7u PD=7.2u
* device instance $503 m0 *1 757.6,231.1 NMOS
XM$503 VSS \$I3745 \$I3744 VSS NMOS L=1u W=3.4u AS=6.46p AD=6.12p PS=7.2u PD=7u
* device instance $504 m0 *1 762.2,231.1 NMOS
XM$504 \$I3744 WL7 BLB31 VSS NMOS L=1u W=3.4u AS=6.12p AD=9.52p PS=7u PD=12.4u
* device instance $505 m0 *1 752.8,151.5 PMOS
XM$505 \$I3747 \$I3746 VDD VDD PMOS L=1u W=3.4u AS=10.88p AD=6.46p PS=13.2u
+ PD=7.2u
* device instance $506 m0 *1 757.6,151.5 PMOS
XM$506 VDD \$I3747 \$I3746 VDD PMOS L=1u W=3.4u AS=6.46p AD=10.88p PS=7.2u
+ PD=13.2u
* device instance $507 m0 *1 748.2,171.9 NMOS
XM$507 BL31 WL5 \$I3747 VSS NMOS L=1u W=3.4u AS=9.52p AD=6.12p PS=12.4u PD=7u
* device instance $508 m0 *1 752.8,171.9 NMOS
XM$508 \$I3747 \$I3746 VSS VSS NMOS L=1u W=3.4u AS=6.12p AD=6.46p PS=7u PD=7.2u
* device instance $509 m0 *1 757.6,171.9 NMOS
XM$509 VSS \$I3747 \$I3746 VSS NMOS L=1u W=3.4u AS=6.46p AD=6.12p PS=7.2u PD=7u
* device instance $510 m0 *1 762.2,171.9 NMOS
XM$510 \$I3746 WL5 BLB31 VSS NMOS L=1u W=3.4u AS=6.12p AD=9.52p PS=7u PD=12.4u
* device instance $511 r0 *1 752.8,381.3 PMOS
XM$511 \$I3749 \$I3748 VDD VDD PMOS L=1u W=3.4u AS=10.88p AD=6.46p PS=13.2u
+ PD=7.2u
* device instance $512 r0 *1 757.6,381.3 PMOS
XM$512 VDD \$I3749 \$I3748 VDD PMOS L=1u W=3.4u AS=6.46p AD=10.88p PS=7.2u
+ PD=13.2u
* device instance $513 r0 *1 748.2,360.9 NMOS
XM$513 BL31 WL12 \$I3749 VSS NMOS L=1u W=3.4u AS=9.52p AD=6.12p PS=12.4u PD=7u
* device instance $514 r0 *1 752.8,360.9 NMOS
XM$514 \$I3749 \$I3748 VSS VSS NMOS L=1u W=3.4u AS=6.12p AD=6.46p PS=7u PD=7.2u
* device instance $515 r0 *1 757.6,360.9 NMOS
XM$515 VSS \$I3749 \$I3748 VSS NMOS L=1u W=3.4u AS=6.46p AD=6.12p PS=7.2u PD=7u
* device instance $516 r0 *1 762.2,360.9 NMOS
XM$516 \$I3748 WL12 BLB31 VSS NMOS L=1u W=3.4u AS=6.12p AD=9.52p PS=7u PD=12.4u
* device instance $517 r0 *1 752.8,440.5 PMOS
XM$517 \$I3751 \$I3750 VDD VDD PMOS L=1u W=3.4u AS=10.88p AD=6.46p PS=13.2u
+ PD=7.2u
* device instance $518 r0 *1 757.6,440.5 PMOS
XM$518 VDD \$I3751 \$I3750 VDD PMOS L=1u W=3.4u AS=6.46p AD=10.88p PS=7.2u
+ PD=13.2u
* device instance $519 r0 *1 748.2,420.1 NMOS
XM$519 BL31 WL14 \$I3751 VSS NMOS L=1u W=3.4u AS=9.52p AD=6.12p PS=12.4u PD=7u
* device instance $520 r0 *1 752.8,420.1 NMOS
XM$520 \$I3751 \$I3750 VSS VSS NMOS L=1u W=3.4u AS=6.12p AD=6.46p PS=7u PD=7.2u
* device instance $521 r0 *1 757.6,420.1 NMOS
XM$521 VSS \$I3751 \$I3750 VSS NMOS L=1u W=3.4u AS=6.46p AD=6.12p PS=7.2u PD=7u
* device instance $522 r0 *1 762.2,420.1 NMOS
XM$522 \$I3750 WL14 BLB31 VSS NMOS L=1u W=3.4u AS=6.12p AD=9.52p PS=7u PD=12.4u
* device instance $523 r0 *1 752.8,262.9 PMOS
XM$523 \$I3753 \$I3752 VDD VDD PMOS L=1u W=3.4u AS=10.88p AD=6.46p PS=13.2u
+ PD=7.2u
* device instance $524 r0 *1 757.6,262.9 PMOS
XM$524 VDD \$I3753 \$I3752 VDD PMOS L=1u W=3.4u AS=6.46p AD=10.88p PS=7.2u
+ PD=13.2u
* device instance $525 r0 *1 748.2,242.5 NMOS
XM$525 BL31 WL8 \$I3753 VSS NMOS L=1u W=3.4u AS=9.52p AD=6.12p PS=12.4u PD=7u
* device instance $526 r0 *1 752.8,242.5 NMOS
XM$526 \$I3753 \$I3752 VSS VSS NMOS L=1u W=3.4u AS=6.12p AD=6.46p PS=7u PD=7.2u
* device instance $527 r0 *1 757.6,242.5 NMOS
XM$527 VSS \$I3753 \$I3752 VSS NMOS L=1u W=3.4u AS=6.46p AD=6.12p PS=7.2u PD=7u
* device instance $528 r0 *1 762.2,242.5 NMOS
XM$528 \$I3752 WL8 BLB31 VSS NMOS L=1u W=3.4u AS=6.12p AD=9.52p PS=7u PD=12.4u
* device instance $529 r0 *1 752.8,322.1 PMOS
XM$529 \$I3755 \$I3754 VDD VDD PMOS L=1u W=3.4u AS=10.88p AD=6.46p PS=13.2u
+ PD=7.2u
* device instance $530 r0 *1 757.6,322.1 PMOS
XM$530 VDD \$I3755 \$I3754 VDD PMOS L=1u W=3.4u AS=6.46p AD=10.88p PS=7.2u
+ PD=13.2u
* device instance $531 r0 *1 748.2,301.7 NMOS
XM$531 BL31 WL10 \$I3755 VSS NMOS L=1u W=3.4u AS=9.52p AD=6.12p PS=12.4u PD=7u
* device instance $532 r0 *1 752.8,301.7 NMOS
XM$532 \$I3755 \$I3754 VSS VSS NMOS L=1u W=3.4u AS=6.12p AD=6.46p PS=7u PD=7.2u
* device instance $533 r0 *1 757.6,301.7 NMOS
XM$533 VSS \$I3755 \$I3754 VSS NMOS L=1u W=3.4u AS=6.46p AD=6.12p PS=7.2u PD=7u
* device instance $534 r0 *1 762.2,301.7 NMOS
XM$534 \$I3754 WL10 BLB31 VSS NMOS L=1u W=3.4u AS=6.12p AD=9.52p PS=7u PD=12.4u
* device instance $535 r0 *1 752.8,144.5 PMOS
XM$535 \$I3757 \$I3756 VDD VDD PMOS L=1u W=3.4u AS=10.88p AD=6.46p PS=13.2u
+ PD=7.2u
* device instance $536 r0 *1 757.6,144.5 PMOS
XM$536 VDD \$I3757 \$I3756 VDD PMOS L=1u W=3.4u AS=6.46p AD=10.88p PS=7.2u
+ PD=13.2u
* device instance $537 r0 *1 748.2,124.1 NMOS
XM$537 BL31 WL4 \$I3757 VSS NMOS L=1u W=3.4u AS=9.52p AD=6.12p PS=12.4u PD=7u
* device instance $538 r0 *1 752.8,124.1 NMOS
XM$538 \$I3757 \$I3756 VSS VSS NMOS L=1u W=3.4u AS=6.12p AD=6.46p PS=7u PD=7.2u
* device instance $539 r0 *1 757.6,124.1 NMOS
XM$539 VSS \$I3757 \$I3756 VSS NMOS L=1u W=3.4u AS=6.46p AD=6.12p PS=7.2u PD=7u
* device instance $540 r0 *1 762.2,124.1 NMOS
XM$540 \$I3756 WL4 BLB31 VSS NMOS L=1u W=3.4u AS=6.12p AD=9.52p PS=7u PD=12.4u
* device instance $541 r0 *1 752.8,203.7 PMOS
XM$541 \$I3759 \$I3758 VDD VDD PMOS L=1u W=3.4u AS=10.88p AD=6.46p PS=13.2u
+ PD=7.2u
* device instance $542 r0 *1 757.6,203.7 PMOS
XM$542 VDD \$I3759 \$I3758 VDD PMOS L=1u W=3.4u AS=6.46p AD=10.88p PS=7.2u
+ PD=13.2u
* device instance $543 r0 *1 748.2,183.3 NMOS
XM$543 BL31 WL6 \$I3759 VSS NMOS L=1u W=3.4u AS=9.52p AD=6.12p PS=12.4u PD=7u
* device instance $544 r0 *1 752.8,183.3 NMOS
XM$544 \$I3759 \$I3758 VSS VSS NMOS L=1u W=3.4u AS=6.12p AD=6.46p PS=7u PD=7.2u
* device instance $545 r0 *1 757.6,183.3 NMOS
XM$545 VSS \$I3759 \$I3758 VSS NMOS L=1u W=3.4u AS=6.46p AD=6.12p PS=7.2u PD=7u
* device instance $546 r0 *1 762.2,183.3 NMOS
XM$546 \$I3758 WL6 BLB31 VSS NMOS L=1u W=3.4u AS=6.12p AD=9.52p PS=7u PD=12.4u
* device instance $547 r0 *1 752.8,85.3 PMOS
XM$547 \$I3761 \$I3760 VDD VDD PMOS L=1u W=3.4u AS=10.88p AD=6.46p PS=13.2u
+ PD=7.2u
* device instance $548 r0 *1 757.6,85.3 PMOS
XM$548 VDD \$I3761 \$I3760 VDD PMOS L=1u W=3.4u AS=6.46p AD=10.88p PS=7.2u
+ PD=13.2u
* device instance $549 r0 *1 748.2,64.9 NMOS
XM$549 BL31 WL2 \$I3761 VSS NMOS L=1u W=3.4u AS=9.52p AD=6.12p PS=12.4u PD=7u
* device instance $550 r0 *1 752.8,64.9 NMOS
XM$550 \$I3761 \$I3760 VSS VSS NMOS L=1u W=3.4u AS=6.12p AD=6.46p PS=7u PD=7.2u
* device instance $551 r0 *1 757.6,64.9 NMOS
XM$551 VSS \$I3761 \$I3760 VSS NMOS L=1u W=3.4u AS=6.46p AD=6.12p PS=7.2u PD=7u
* device instance $552 r0 *1 762.2,64.9 NMOS
XM$552 \$I3760 WL2 BLB31 VSS NMOS L=1u W=3.4u AS=6.12p AD=9.52p PS=7u PD=12.4u
* device instance $553 m0 *1 620.8,329.1 PMOS
XM$553 \$I3763 \$I3762 VDD VDD PMOS L=1u W=3.4u AS=10.88p AD=6.46p PS=13.2u
+ PD=7.2u
* device instance $554 m0 *1 625.6,329.1 PMOS
XM$554 VDD \$I3763 \$I3762 VDD PMOS L=1u W=3.4u AS=6.46p AD=10.88p PS=7.2u
+ PD=13.2u
* device instance $555 m0 *1 616.2,349.5 NMOS
XM$555 BL25 WL11 \$I3763 VSS NMOS L=1u W=3.4u AS=9.52p AD=6.12p PS=12.4u PD=7u
* device instance $556 m0 *1 620.8,349.5 NMOS
XM$556 \$I3763 \$I3762 VSS VSS NMOS L=1u W=3.4u AS=6.12p AD=6.46p PS=7u PD=7.2u
* device instance $557 m0 *1 625.6,349.5 NMOS
XM$557 VSS \$I3763 \$I3762 VSS NMOS L=1u W=3.4u AS=6.46p AD=6.12p PS=7.2u PD=7u
* device instance $558 m0 *1 630.2,349.5 NMOS
XM$558 \$I3762 WL11 BLB25 VSS NMOS L=1u W=3.4u AS=6.12p AD=9.52p PS=7u PD=12.4u
* device instance $559 m0 *1 620.8,269.9 PMOS
XM$559 \$I3765 \$I3764 VDD VDD PMOS L=1u W=3.4u AS=10.88p AD=6.46p PS=13.2u
+ PD=7.2u
* device instance $560 m0 *1 625.6,269.9 PMOS
XM$560 VDD \$I3765 \$I3764 VDD PMOS L=1u W=3.4u AS=6.46p AD=10.88p PS=7.2u
+ PD=13.2u
* device instance $561 m0 *1 616.2,290.3 NMOS
XM$561 BL25 WL9 \$I3765 VSS NMOS L=1u W=3.4u AS=9.52p AD=6.12p PS=12.4u PD=7u
* device instance $562 m0 *1 620.8,290.3 NMOS
XM$562 \$I3765 \$I3764 VSS VSS NMOS L=1u W=3.4u AS=6.12p AD=6.46p PS=7u PD=7.2u
* device instance $563 m0 *1 625.6,290.3 NMOS
XM$563 VSS \$I3765 \$I3764 VSS NMOS L=1u W=3.4u AS=6.46p AD=6.12p PS=7.2u PD=7u
* device instance $564 m0 *1 630.2,290.3 NMOS
XM$564 \$I3764 WL9 BLB25 VSS NMOS L=1u W=3.4u AS=6.12p AD=9.52p PS=7u PD=12.4u
* device instance $565 m0 *1 620.8,447.5 PMOS
XM$565 \$I3767 \$I3766 VDD VDD PMOS L=1u W=3.4u AS=10.88p AD=6.46p PS=13.2u
+ PD=7.2u
* device instance $566 m0 *1 625.6,447.5 PMOS
XM$566 VDD \$I3767 \$I3766 VDD PMOS L=1u W=3.4u AS=6.46p AD=10.88p PS=7.2u
+ PD=13.2u
* device instance $567 m0 *1 616.2,467.9 NMOS
XM$567 BL25 WL15 \$I3767 VSS NMOS L=1u W=3.4u AS=9.52p AD=6.12p PS=12.4u PD=7u
* device instance $568 m0 *1 620.8,467.9 NMOS
XM$568 \$I3767 \$I3766 VSS VSS NMOS L=1u W=3.4u AS=6.12p AD=6.46p PS=7u PD=7.2u
* device instance $569 m0 *1 625.6,467.9 NMOS
XM$569 VSS \$I3767 \$I3766 VSS NMOS L=1u W=3.4u AS=6.46p AD=6.12p PS=7.2u PD=7u
* device instance $570 m0 *1 630.2,467.9 NMOS
XM$570 \$I3766 WL15 BLB25 VSS NMOS L=1u W=3.4u AS=6.12p AD=9.52p PS=7u PD=12.4u
* device instance $571 m0 *1 620.8,388.3 PMOS
XM$571 \$I3769 \$I3768 VDD VDD PMOS L=1u W=3.4u AS=10.88p AD=6.46p PS=13.2u
+ PD=7.2u
* device instance $572 m0 *1 625.6,388.3 PMOS
XM$572 VDD \$I3769 \$I3768 VDD PMOS L=1u W=3.4u AS=6.46p AD=10.88p PS=7.2u
+ PD=13.2u
* device instance $573 m0 *1 616.2,408.7 NMOS
XM$573 BL25 WL13 \$I3769 VSS NMOS L=1u W=3.4u AS=9.52p AD=6.12p PS=12.4u PD=7u
* device instance $574 m0 *1 620.8,408.7 NMOS
XM$574 \$I3769 \$I3768 VSS VSS NMOS L=1u W=3.4u AS=6.12p AD=6.46p PS=7u PD=7.2u
* device instance $575 m0 *1 625.6,408.7 NMOS
XM$575 VSS \$I3769 \$I3768 VSS NMOS L=1u W=3.4u AS=6.46p AD=6.12p PS=7.2u PD=7u
* device instance $576 m0 *1 630.2,408.7 NMOS
XM$576 \$I3768 WL13 BLB25 VSS NMOS L=1u W=3.4u AS=6.12p AD=9.52p PS=7u PD=12.4u
* device instance $577 m0 *1 620.8,92.3 PMOS
XM$577 \$I3771 \$I3770 VDD VDD PMOS L=1u W=3.4u AS=10.88p AD=6.46p PS=13.2u
+ PD=7.2u
* device instance $578 m0 *1 625.6,92.3 PMOS
XM$578 VDD \$I3771 \$I3770 VDD PMOS L=1u W=3.4u AS=6.46p AD=10.88p PS=7.2u
+ PD=13.2u
* device instance $579 m0 *1 616.2,112.7 NMOS
XM$579 BL25 WL3 \$I3771 VSS NMOS L=1u W=3.4u AS=9.52p AD=6.12p PS=12.4u PD=7u
* device instance $580 m0 *1 620.8,112.7 NMOS
XM$580 \$I3771 \$I3770 VSS VSS NMOS L=1u W=3.4u AS=6.12p AD=6.46p PS=7u PD=7.2u
* device instance $581 m0 *1 625.6,112.7 NMOS
XM$581 VSS \$I3771 \$I3770 VSS NMOS L=1u W=3.4u AS=6.46p AD=6.12p PS=7.2u PD=7u
* device instance $582 m0 *1 630.2,112.7 NMOS
XM$582 \$I3770 WL3 BLB25 VSS NMOS L=1u W=3.4u AS=6.12p AD=9.52p PS=7u PD=12.4u
* device instance $583 m0 *1 620.8,33.1 PMOS
XM$583 \$I3773 \$I3772 VDD VDD PMOS L=1u W=3.4u AS=10.88p AD=6.46p PS=13.2u
+ PD=7.2u
* device instance $584 m0 *1 625.6,33.1 PMOS
XM$584 VDD \$I3773 \$I3772 VDD PMOS L=1u W=3.4u AS=6.46p AD=10.88p PS=7.2u
+ PD=13.2u
* device instance $585 m0 *1 616.2,53.5 NMOS
XM$585 BL25 WL1 \$I3773 VSS NMOS L=1u W=3.4u AS=9.52p AD=6.12p PS=12.4u PD=7u
* device instance $586 m0 *1 620.8,53.5 NMOS
XM$586 \$I3773 \$I3772 VSS VSS NMOS L=1u W=3.4u AS=6.12p AD=6.46p PS=7u PD=7.2u
* device instance $587 m0 *1 625.6,53.5 NMOS
XM$587 VSS \$I3773 \$I3772 VSS NMOS L=1u W=3.4u AS=6.46p AD=6.12p PS=7.2u PD=7u
* device instance $588 m0 *1 630.2,53.5 NMOS
XM$588 \$I3772 WL1 BLB25 VSS NMOS L=1u W=3.4u AS=6.12p AD=9.52p PS=7u PD=12.4u
* device instance $589 m0 *1 620.8,210.7 PMOS
XM$589 \$I3775 \$I3774 VDD VDD PMOS L=1u W=3.4u AS=10.88p AD=6.46p PS=13.2u
+ PD=7.2u
* device instance $590 m0 *1 625.6,210.7 PMOS
XM$590 VDD \$I3775 \$I3774 VDD PMOS L=1u W=3.4u AS=6.46p AD=10.88p PS=7.2u
+ PD=13.2u
* device instance $591 m0 *1 616.2,231.1 NMOS
XM$591 BL25 WL7 \$I3775 VSS NMOS L=1u W=3.4u AS=9.52p AD=6.12p PS=12.4u PD=7u
* device instance $592 m0 *1 620.8,231.1 NMOS
XM$592 \$I3775 \$I3774 VSS VSS NMOS L=1u W=3.4u AS=6.12p AD=6.46p PS=7u PD=7.2u
* device instance $593 m0 *1 625.6,231.1 NMOS
XM$593 VSS \$I3775 \$I3774 VSS NMOS L=1u W=3.4u AS=6.46p AD=6.12p PS=7.2u PD=7u
* device instance $594 m0 *1 630.2,231.1 NMOS
XM$594 \$I3774 WL7 BLB25 VSS NMOS L=1u W=3.4u AS=6.12p AD=9.52p PS=7u PD=12.4u
* device instance $595 m0 *1 620.8,151.5 PMOS
XM$595 \$I3777 \$I3776 VDD VDD PMOS L=1u W=3.4u AS=10.88p AD=6.46p PS=13.2u
+ PD=7.2u
* device instance $596 m0 *1 625.6,151.5 PMOS
XM$596 VDD \$I3777 \$I3776 VDD PMOS L=1u W=3.4u AS=6.46p AD=10.88p PS=7.2u
+ PD=13.2u
* device instance $597 m0 *1 616.2,171.9 NMOS
XM$597 BL25 WL5 \$I3777 VSS NMOS L=1u W=3.4u AS=9.52p AD=6.12p PS=12.4u PD=7u
* device instance $598 m0 *1 620.8,171.9 NMOS
XM$598 \$I3777 \$I3776 VSS VSS NMOS L=1u W=3.4u AS=6.12p AD=6.46p PS=7u PD=7.2u
* device instance $599 m0 *1 625.6,171.9 NMOS
XM$599 VSS \$I3777 \$I3776 VSS NMOS L=1u W=3.4u AS=6.46p AD=6.12p PS=7.2u PD=7u
* device instance $600 m0 *1 630.2,171.9 NMOS
XM$600 \$I3776 WL5 BLB25 VSS NMOS L=1u W=3.4u AS=6.12p AD=9.52p PS=7u PD=12.4u
* device instance $601 r0 *1 620.8,381.3 PMOS
XM$601 \$I3779 \$I3778 VDD VDD PMOS L=1u W=3.4u AS=10.88p AD=6.46p PS=13.2u
+ PD=7.2u
* device instance $602 r0 *1 625.6,381.3 PMOS
XM$602 VDD \$I3779 \$I3778 VDD PMOS L=1u W=3.4u AS=6.46p AD=10.88p PS=7.2u
+ PD=13.2u
* device instance $603 r0 *1 616.2,360.9 NMOS
XM$603 BL25 WL12 \$I3779 VSS NMOS L=1u W=3.4u AS=9.52p AD=6.12p PS=12.4u PD=7u
* device instance $604 r0 *1 620.8,360.9 NMOS
XM$604 \$I3779 \$I3778 VSS VSS NMOS L=1u W=3.4u AS=6.12p AD=6.46p PS=7u PD=7.2u
* device instance $605 r0 *1 625.6,360.9 NMOS
XM$605 VSS \$I3779 \$I3778 VSS NMOS L=1u W=3.4u AS=6.46p AD=6.12p PS=7.2u PD=7u
* device instance $606 r0 *1 630.2,360.9 NMOS
XM$606 \$I3778 WL12 BLB25 VSS NMOS L=1u W=3.4u AS=6.12p AD=9.52p PS=7u PD=12.4u
* device instance $607 r0 *1 620.8,440.5 PMOS
XM$607 \$I3781 \$I3780 VDD VDD PMOS L=1u W=3.4u AS=10.88p AD=6.46p PS=13.2u
+ PD=7.2u
* device instance $608 r0 *1 625.6,440.5 PMOS
XM$608 VDD \$I3781 \$I3780 VDD PMOS L=1u W=3.4u AS=6.46p AD=10.88p PS=7.2u
+ PD=13.2u
* device instance $609 r0 *1 616.2,420.1 NMOS
XM$609 BL25 WL14 \$I3781 VSS NMOS L=1u W=3.4u AS=9.52p AD=6.12p PS=12.4u PD=7u
* device instance $610 r0 *1 620.8,420.1 NMOS
XM$610 \$I3781 \$I3780 VSS VSS NMOS L=1u W=3.4u AS=6.12p AD=6.46p PS=7u PD=7.2u
* device instance $611 r0 *1 625.6,420.1 NMOS
XM$611 VSS \$I3781 \$I3780 VSS NMOS L=1u W=3.4u AS=6.46p AD=6.12p PS=7.2u PD=7u
* device instance $612 r0 *1 630.2,420.1 NMOS
XM$612 \$I3780 WL14 BLB25 VSS NMOS L=1u W=3.4u AS=6.12p AD=9.52p PS=7u PD=12.4u
* device instance $613 r0 *1 620.8,322.1 PMOS
XM$613 \$I3783 \$I3782 VDD VDD PMOS L=1u W=3.4u AS=10.88p AD=6.46p PS=13.2u
+ PD=7.2u
* device instance $614 r0 *1 625.6,322.1 PMOS
XM$614 VDD \$I3783 \$I3782 VDD PMOS L=1u W=3.4u AS=6.46p AD=10.88p PS=7.2u
+ PD=13.2u
* device instance $615 r0 *1 616.2,301.7 NMOS
XM$615 BL25 WL10 \$I3783 VSS NMOS L=1u W=3.4u AS=9.52p AD=6.12p PS=12.4u PD=7u
* device instance $616 r0 *1 620.8,301.7 NMOS
XM$616 \$I3783 \$I3782 VSS VSS NMOS L=1u W=3.4u AS=6.12p AD=6.46p PS=7u PD=7.2u
* device instance $617 r0 *1 625.6,301.7 NMOS
XM$617 VSS \$I3783 \$I3782 VSS NMOS L=1u W=3.4u AS=6.46p AD=6.12p PS=7.2u PD=7u
* device instance $618 r0 *1 630.2,301.7 NMOS
XM$618 \$I3782 WL10 BLB25 VSS NMOS L=1u W=3.4u AS=6.12p AD=9.52p PS=7u PD=12.4u
* device instance $619 r0 *1 620.8,262.9 PMOS
XM$619 \$I3785 \$I3784 VDD VDD PMOS L=1u W=3.4u AS=10.88p AD=6.46p PS=13.2u
+ PD=7.2u
* device instance $620 r0 *1 625.6,262.9 PMOS
XM$620 VDD \$I3785 \$I3784 VDD PMOS L=1u W=3.4u AS=6.46p AD=10.88p PS=7.2u
+ PD=13.2u
* device instance $621 r0 *1 616.2,242.5 NMOS
XM$621 BL25 WL8 \$I3785 VSS NMOS L=1u W=3.4u AS=9.52p AD=6.12p PS=12.4u PD=7u
* device instance $622 r0 *1 620.8,242.5 NMOS
XM$622 \$I3785 \$I3784 VSS VSS NMOS L=1u W=3.4u AS=6.12p AD=6.46p PS=7u PD=7.2u
* device instance $623 r0 *1 625.6,242.5 NMOS
XM$623 VSS \$I3785 \$I3784 VSS NMOS L=1u W=3.4u AS=6.46p AD=6.12p PS=7.2u PD=7u
* device instance $624 r0 *1 630.2,242.5 NMOS
XM$624 \$I3784 WL8 BLB25 VSS NMOS L=1u W=3.4u AS=6.12p AD=9.52p PS=7u PD=12.4u
* device instance $625 r0 *1 620.8,203.7 PMOS
XM$625 \$I3787 \$I3786 VDD VDD PMOS L=1u W=3.4u AS=10.88p AD=6.46p PS=13.2u
+ PD=7.2u
* device instance $626 r0 *1 625.6,203.7 PMOS
XM$626 VDD \$I3787 \$I3786 VDD PMOS L=1u W=3.4u AS=6.46p AD=10.88p PS=7.2u
+ PD=13.2u
* device instance $627 r0 *1 616.2,183.3 NMOS
XM$627 BL25 WL6 \$I3787 VSS NMOS L=1u W=3.4u AS=9.52p AD=6.12p PS=12.4u PD=7u
* device instance $628 r0 *1 620.8,183.3 NMOS
XM$628 \$I3787 \$I3786 VSS VSS NMOS L=1u W=3.4u AS=6.12p AD=6.46p PS=7u PD=7.2u
* device instance $629 r0 *1 625.6,183.3 NMOS
XM$629 VSS \$I3787 \$I3786 VSS NMOS L=1u W=3.4u AS=6.46p AD=6.12p PS=7.2u PD=7u
* device instance $630 r0 *1 630.2,183.3 NMOS
XM$630 \$I3786 WL6 BLB25 VSS NMOS L=1u W=3.4u AS=6.12p AD=9.52p PS=7u PD=12.4u
* device instance $631 r0 *1 620.8,144.5 PMOS
XM$631 \$I3789 \$I3788 VDD VDD PMOS L=1u W=3.4u AS=10.88p AD=6.46p PS=13.2u
+ PD=7.2u
* device instance $632 r0 *1 625.6,144.5 PMOS
XM$632 VDD \$I3789 \$I3788 VDD PMOS L=1u W=3.4u AS=6.46p AD=10.88p PS=7.2u
+ PD=13.2u
* device instance $633 r0 *1 616.2,124.1 NMOS
XM$633 BL25 WL4 \$I3789 VSS NMOS L=1u W=3.4u AS=9.52p AD=6.12p PS=12.4u PD=7u
* device instance $634 r0 *1 620.8,124.1 NMOS
XM$634 \$I3789 \$I3788 VSS VSS NMOS L=1u W=3.4u AS=6.12p AD=6.46p PS=7u PD=7.2u
* device instance $635 r0 *1 625.6,124.1 NMOS
XM$635 VSS \$I3789 \$I3788 VSS NMOS L=1u W=3.4u AS=6.46p AD=6.12p PS=7.2u PD=7u
* device instance $636 r0 *1 630.2,124.1 NMOS
XM$636 \$I3788 WL4 BLB25 VSS NMOS L=1u W=3.4u AS=6.12p AD=9.52p PS=7u PD=12.4u
* device instance $637 r0 *1 620.8,85.3 PMOS
XM$637 \$I3791 \$I3790 VDD VDD PMOS L=1u W=3.4u AS=10.88p AD=6.46p PS=13.2u
+ PD=7.2u
* device instance $638 r0 *1 625.6,85.3 PMOS
XM$638 VDD \$I3791 \$I3790 VDD PMOS L=1u W=3.4u AS=6.46p AD=10.88p PS=7.2u
+ PD=13.2u
* device instance $639 r0 *1 616.2,64.9 NMOS
XM$639 BL25 WL2 \$I3791 VSS NMOS L=1u W=3.4u AS=9.52p AD=6.12p PS=12.4u PD=7u
* device instance $640 r0 *1 620.8,64.9 NMOS
XM$640 \$I3791 \$I3790 VSS VSS NMOS L=1u W=3.4u AS=6.12p AD=6.46p PS=7u PD=7.2u
* device instance $641 r0 *1 625.6,64.9 NMOS
XM$641 VSS \$I3791 \$I3790 VSS NMOS L=1u W=3.4u AS=6.46p AD=6.12p PS=7.2u PD=7u
* device instance $642 r0 *1 630.2,64.9 NMOS
XM$642 \$I3790 WL2 BLB25 VSS NMOS L=1u W=3.4u AS=6.12p AD=9.52p PS=7u PD=12.4u
* device instance $643 m0 *1 598.8,329.1 PMOS
XM$643 \$I3793 \$I3792 VDD VDD PMOS L=1u W=3.4u AS=10.88p AD=6.46p PS=13.2u
+ PD=7.2u
* device instance $644 m0 *1 603.6,329.1 PMOS
XM$644 VDD \$I3793 \$I3792 VDD PMOS L=1u W=3.4u AS=6.46p AD=10.88p PS=7.2u
+ PD=13.2u
* device instance $645 m0 *1 594.2,349.5 NMOS
XM$645 BL24 WL11 \$I3793 VSS NMOS L=1u W=3.4u AS=9.52p AD=6.12p PS=12.4u PD=7u
* device instance $646 m0 *1 598.8,349.5 NMOS
XM$646 \$I3793 \$I3792 VSS VSS NMOS L=1u W=3.4u AS=6.12p AD=6.46p PS=7u PD=7.2u
* device instance $647 m0 *1 603.6,349.5 NMOS
XM$647 VSS \$I3793 \$I3792 VSS NMOS L=1u W=3.4u AS=6.46p AD=6.12p PS=7.2u PD=7u
* device instance $648 m0 *1 608.2,349.5 NMOS
XM$648 \$I3792 WL11 BLB24 VSS NMOS L=1u W=3.4u AS=6.12p AD=9.52p PS=7u PD=12.4u
* device instance $649 m0 *1 598.8,269.9 PMOS
XM$649 \$I3795 \$I3794 VDD VDD PMOS L=1u W=3.4u AS=10.88p AD=6.46p PS=13.2u
+ PD=7.2u
* device instance $650 m0 *1 603.6,269.9 PMOS
XM$650 VDD \$I3795 \$I3794 VDD PMOS L=1u W=3.4u AS=6.46p AD=10.88p PS=7.2u
+ PD=13.2u
* device instance $651 m0 *1 594.2,290.3 NMOS
XM$651 BL24 WL9 \$I3795 VSS NMOS L=1u W=3.4u AS=9.52p AD=6.12p PS=12.4u PD=7u
* device instance $652 m0 *1 598.8,290.3 NMOS
XM$652 \$I3795 \$I3794 VSS VSS NMOS L=1u W=3.4u AS=6.12p AD=6.46p PS=7u PD=7.2u
* device instance $653 m0 *1 603.6,290.3 NMOS
XM$653 VSS \$I3795 \$I3794 VSS NMOS L=1u W=3.4u AS=6.46p AD=6.12p PS=7.2u PD=7u
* device instance $654 m0 *1 608.2,290.3 NMOS
XM$654 \$I3794 WL9 BLB24 VSS NMOS L=1u W=3.4u AS=6.12p AD=9.52p PS=7u PD=12.4u
* device instance $655 m0 *1 598.8,447.5 PMOS
XM$655 \$I3797 \$I3796 VDD VDD PMOS L=1u W=3.4u AS=10.88p AD=6.46p PS=13.2u
+ PD=7.2u
* device instance $656 m0 *1 603.6,447.5 PMOS
XM$656 VDD \$I3797 \$I3796 VDD PMOS L=1u W=3.4u AS=6.46p AD=10.88p PS=7.2u
+ PD=13.2u
* device instance $657 m0 *1 594.2,467.9 NMOS
XM$657 BL24 WL15 \$I3797 VSS NMOS L=1u W=3.4u AS=9.52p AD=6.12p PS=12.4u PD=7u
* device instance $658 m0 *1 598.8,467.9 NMOS
XM$658 \$I3797 \$I3796 VSS VSS NMOS L=1u W=3.4u AS=6.12p AD=6.46p PS=7u PD=7.2u
* device instance $659 m0 *1 603.6,467.9 NMOS
XM$659 VSS \$I3797 \$I3796 VSS NMOS L=1u W=3.4u AS=6.46p AD=6.12p PS=7.2u PD=7u
* device instance $660 m0 *1 608.2,467.9 NMOS
XM$660 \$I3796 WL15 BLB24 VSS NMOS L=1u W=3.4u AS=6.12p AD=9.52p PS=7u PD=12.4u
* device instance $661 m0 *1 598.8,388.3 PMOS
XM$661 \$I3799 \$I3798 VDD VDD PMOS L=1u W=3.4u AS=10.88p AD=6.46p PS=13.2u
+ PD=7.2u
* device instance $662 m0 *1 603.6,388.3 PMOS
XM$662 VDD \$I3799 \$I3798 VDD PMOS L=1u W=3.4u AS=6.46p AD=10.88p PS=7.2u
+ PD=13.2u
* device instance $663 m0 *1 594.2,408.7 NMOS
XM$663 BL24 WL13 \$I3799 VSS NMOS L=1u W=3.4u AS=9.52p AD=6.12p PS=12.4u PD=7u
* device instance $664 m0 *1 598.8,408.7 NMOS
XM$664 \$I3799 \$I3798 VSS VSS NMOS L=1u W=3.4u AS=6.12p AD=6.46p PS=7u PD=7.2u
* device instance $665 m0 *1 603.6,408.7 NMOS
XM$665 VSS \$I3799 \$I3798 VSS NMOS L=1u W=3.4u AS=6.46p AD=6.12p PS=7.2u PD=7u
* device instance $666 m0 *1 608.2,408.7 NMOS
XM$666 \$I3798 WL13 BLB24 VSS NMOS L=1u W=3.4u AS=6.12p AD=9.52p PS=7u PD=12.4u
* device instance $667 m0 *1 598.8,33.1 PMOS
XM$667 \$I3801 \$I3800 VDD VDD PMOS L=1u W=3.4u AS=10.88p AD=6.46p PS=13.2u
+ PD=7.2u
* device instance $668 m0 *1 603.6,33.1 PMOS
XM$668 VDD \$I3801 \$I3800 VDD PMOS L=1u W=3.4u AS=6.46p AD=10.88p PS=7.2u
+ PD=13.2u
* device instance $669 m0 *1 594.2,53.5 NMOS
XM$669 BL24 WL1 \$I3801 VSS NMOS L=1u W=3.4u AS=9.52p AD=6.12p PS=12.4u PD=7u
* device instance $670 m0 *1 598.8,53.5 NMOS
XM$670 \$I3801 \$I3800 VSS VSS NMOS L=1u W=3.4u AS=6.12p AD=6.46p PS=7u PD=7.2u
* device instance $671 m0 *1 603.6,53.5 NMOS
XM$671 VSS \$I3801 \$I3800 VSS NMOS L=1u W=3.4u AS=6.46p AD=6.12p PS=7.2u PD=7u
* device instance $672 m0 *1 608.2,53.5 NMOS
XM$672 \$I3800 WL1 BLB24 VSS NMOS L=1u W=3.4u AS=6.12p AD=9.52p PS=7u PD=12.4u
* device instance $673 m0 *1 598.8,92.3 PMOS
XM$673 \$I3803 \$I3802 VDD VDD PMOS L=1u W=3.4u AS=10.88p AD=6.46p PS=13.2u
+ PD=7.2u
* device instance $674 m0 *1 603.6,92.3 PMOS
XM$674 VDD \$I3803 \$I3802 VDD PMOS L=1u W=3.4u AS=6.46p AD=10.88p PS=7.2u
+ PD=13.2u
* device instance $675 m0 *1 594.2,112.7 NMOS
XM$675 BL24 WL3 \$I3803 VSS NMOS L=1u W=3.4u AS=9.52p AD=6.12p PS=12.4u PD=7u
* device instance $676 m0 *1 598.8,112.7 NMOS
XM$676 \$I3803 \$I3802 VSS VSS NMOS L=1u W=3.4u AS=6.12p AD=6.46p PS=7u PD=7.2u
* device instance $677 m0 *1 603.6,112.7 NMOS
XM$677 VSS \$I3803 \$I3802 VSS NMOS L=1u W=3.4u AS=6.46p AD=6.12p PS=7.2u PD=7u
* device instance $678 m0 *1 608.2,112.7 NMOS
XM$678 \$I3802 WL3 BLB24 VSS NMOS L=1u W=3.4u AS=6.12p AD=9.52p PS=7u PD=12.4u
* device instance $679 m0 *1 598.8,210.7 PMOS
XM$679 \$I3805 \$I3804 VDD VDD PMOS L=1u W=3.4u AS=10.88p AD=6.46p PS=13.2u
+ PD=7.2u
* device instance $680 m0 *1 603.6,210.7 PMOS
XM$680 VDD \$I3805 \$I3804 VDD PMOS L=1u W=3.4u AS=6.46p AD=10.88p PS=7.2u
+ PD=13.2u
* device instance $681 m0 *1 594.2,231.1 NMOS
XM$681 BL24 WL7 \$I3805 VSS NMOS L=1u W=3.4u AS=9.52p AD=6.12p PS=12.4u PD=7u
* device instance $682 m0 *1 598.8,231.1 NMOS
XM$682 \$I3805 \$I3804 VSS VSS NMOS L=1u W=3.4u AS=6.12p AD=6.46p PS=7u PD=7.2u
* device instance $683 m0 *1 603.6,231.1 NMOS
XM$683 VSS \$I3805 \$I3804 VSS NMOS L=1u W=3.4u AS=6.46p AD=6.12p PS=7.2u PD=7u
* device instance $684 m0 *1 608.2,231.1 NMOS
XM$684 \$I3804 WL7 BLB24 VSS NMOS L=1u W=3.4u AS=6.12p AD=9.52p PS=7u PD=12.4u
* device instance $685 m0 *1 598.8,151.5 PMOS
XM$685 \$I3807 \$I3806 VDD VDD PMOS L=1u W=3.4u AS=10.88p AD=6.46p PS=13.2u
+ PD=7.2u
* device instance $686 m0 *1 603.6,151.5 PMOS
XM$686 VDD \$I3807 \$I3806 VDD PMOS L=1u W=3.4u AS=6.46p AD=10.88p PS=7.2u
+ PD=13.2u
* device instance $687 m0 *1 594.2,171.9 NMOS
XM$687 BL24 WL5 \$I3807 VSS NMOS L=1u W=3.4u AS=9.52p AD=6.12p PS=12.4u PD=7u
* device instance $688 m0 *1 598.8,171.9 NMOS
XM$688 \$I3807 \$I3806 VSS VSS NMOS L=1u W=3.4u AS=6.12p AD=6.46p PS=7u PD=7.2u
* device instance $689 m0 *1 603.6,171.9 NMOS
XM$689 VSS \$I3807 \$I3806 VSS NMOS L=1u W=3.4u AS=6.46p AD=6.12p PS=7.2u PD=7u
* device instance $690 m0 *1 608.2,171.9 NMOS
XM$690 \$I3806 WL5 BLB24 VSS NMOS L=1u W=3.4u AS=6.12p AD=9.52p PS=7u PD=12.4u
* device instance $691 r0 *1 598.8,440.5 PMOS
XM$691 \$I3809 \$I3808 VDD VDD PMOS L=1u W=3.4u AS=10.88p AD=6.46p PS=13.2u
+ PD=7.2u
* device instance $692 r0 *1 603.6,440.5 PMOS
XM$692 VDD \$I3809 \$I3808 VDD PMOS L=1u W=3.4u AS=6.46p AD=10.88p PS=7.2u
+ PD=13.2u
* device instance $693 r0 *1 594.2,420.1 NMOS
XM$693 BL24 WL14 \$I3809 VSS NMOS L=1u W=3.4u AS=9.52p AD=6.12p PS=12.4u PD=7u
* device instance $694 r0 *1 598.8,420.1 NMOS
XM$694 \$I3809 \$I3808 VSS VSS NMOS L=1u W=3.4u AS=6.12p AD=6.46p PS=7u PD=7.2u
* device instance $695 r0 *1 603.6,420.1 NMOS
XM$695 VSS \$I3809 \$I3808 VSS NMOS L=1u W=3.4u AS=6.46p AD=6.12p PS=7.2u PD=7u
* device instance $696 r0 *1 608.2,420.1 NMOS
XM$696 \$I3808 WL14 BLB24 VSS NMOS L=1u W=3.4u AS=6.12p AD=9.52p PS=7u PD=12.4u
* device instance $697 r0 *1 598.8,322.1 PMOS
XM$697 \$I3811 \$I3810 VDD VDD PMOS L=1u W=3.4u AS=10.88p AD=6.46p PS=13.2u
+ PD=7.2u
* device instance $698 r0 *1 603.6,322.1 PMOS
XM$698 VDD \$I3811 \$I3810 VDD PMOS L=1u W=3.4u AS=6.46p AD=10.88p PS=7.2u
+ PD=13.2u
* device instance $699 r0 *1 594.2,301.7 NMOS
XM$699 BL24 WL10 \$I3811 VSS NMOS L=1u W=3.4u AS=9.52p AD=6.12p PS=12.4u PD=7u
* device instance $700 r0 *1 598.8,301.7 NMOS
XM$700 \$I3811 \$I3810 VSS VSS NMOS L=1u W=3.4u AS=6.12p AD=6.46p PS=7u PD=7.2u
* device instance $701 r0 *1 603.6,301.7 NMOS
XM$701 VSS \$I3811 \$I3810 VSS NMOS L=1u W=3.4u AS=6.46p AD=6.12p PS=7.2u PD=7u
* device instance $702 r0 *1 608.2,301.7 NMOS
XM$702 \$I3810 WL10 BLB24 VSS NMOS L=1u W=3.4u AS=6.12p AD=9.52p PS=7u PD=12.4u
* device instance $703 r0 *1 598.8,262.9 PMOS
XM$703 \$I3813 \$I3812 VDD VDD PMOS L=1u W=3.4u AS=10.88p AD=6.46p PS=13.2u
+ PD=7.2u
* device instance $704 r0 *1 603.6,262.9 PMOS
XM$704 VDD \$I3813 \$I3812 VDD PMOS L=1u W=3.4u AS=6.46p AD=10.88p PS=7.2u
+ PD=13.2u
* device instance $705 r0 *1 594.2,242.5 NMOS
XM$705 BL24 WL8 \$I3813 VSS NMOS L=1u W=3.4u AS=9.52p AD=6.12p PS=12.4u PD=7u
* device instance $706 r0 *1 598.8,242.5 NMOS
XM$706 \$I3813 \$I3812 VSS VSS NMOS L=1u W=3.4u AS=6.12p AD=6.46p PS=7u PD=7.2u
* device instance $707 r0 *1 603.6,242.5 NMOS
XM$707 VSS \$I3813 \$I3812 VSS NMOS L=1u W=3.4u AS=6.46p AD=6.12p PS=7.2u PD=7u
* device instance $708 r0 *1 608.2,242.5 NMOS
XM$708 \$I3812 WL8 BLB24 VSS NMOS L=1u W=3.4u AS=6.12p AD=9.52p PS=7u PD=12.4u
* device instance $709 r0 *1 598.8,203.7 PMOS
XM$709 \$I3815 \$I3814 VDD VDD PMOS L=1u W=3.4u AS=10.88p AD=6.46p PS=13.2u
+ PD=7.2u
* device instance $710 r0 *1 603.6,203.7 PMOS
XM$710 VDD \$I3815 \$I3814 VDD PMOS L=1u W=3.4u AS=6.46p AD=10.88p PS=7.2u
+ PD=13.2u
* device instance $711 r0 *1 594.2,183.3 NMOS
XM$711 BL24 WL6 \$I3815 VSS NMOS L=1u W=3.4u AS=9.52p AD=6.12p PS=12.4u PD=7u
* device instance $712 r0 *1 598.8,183.3 NMOS
XM$712 \$I3815 \$I3814 VSS VSS NMOS L=1u W=3.4u AS=6.12p AD=6.46p PS=7u PD=7.2u
* device instance $713 r0 *1 603.6,183.3 NMOS
XM$713 VSS \$I3815 \$I3814 VSS NMOS L=1u W=3.4u AS=6.46p AD=6.12p PS=7.2u PD=7u
* device instance $714 r0 *1 608.2,183.3 NMOS
XM$714 \$I3814 WL6 BLB24 VSS NMOS L=1u W=3.4u AS=6.12p AD=9.52p PS=7u PD=12.4u
* device instance $715 r0 *1 598.8,144.5 PMOS
XM$715 \$I3817 \$I3816 VDD VDD PMOS L=1u W=3.4u AS=10.88p AD=6.46p PS=13.2u
+ PD=7.2u
* device instance $716 r0 *1 603.6,144.5 PMOS
XM$716 VDD \$I3817 \$I3816 VDD PMOS L=1u W=3.4u AS=6.46p AD=10.88p PS=7.2u
+ PD=13.2u
* device instance $717 r0 *1 594.2,124.1 NMOS
XM$717 BL24 WL4 \$I3817 VSS NMOS L=1u W=3.4u AS=9.52p AD=6.12p PS=12.4u PD=7u
* device instance $718 r0 *1 598.8,124.1 NMOS
XM$718 \$I3817 \$I3816 VSS VSS NMOS L=1u W=3.4u AS=6.12p AD=6.46p PS=7u PD=7.2u
* device instance $719 r0 *1 603.6,124.1 NMOS
XM$719 VSS \$I3817 \$I3816 VSS NMOS L=1u W=3.4u AS=6.46p AD=6.12p PS=7.2u PD=7u
* device instance $720 r0 *1 608.2,124.1 NMOS
XM$720 \$I3816 WL4 BLB24 VSS NMOS L=1u W=3.4u AS=6.12p AD=9.52p PS=7u PD=12.4u
* device instance $721 r0 *1 598.8,85.3 PMOS
XM$721 \$I3819 \$I3818 VDD VDD PMOS L=1u W=3.4u AS=10.88p AD=6.46p PS=13.2u
+ PD=7.2u
* device instance $722 r0 *1 603.6,85.3 PMOS
XM$722 VDD \$I3819 \$I3818 VDD PMOS L=1u W=3.4u AS=6.46p AD=10.88p PS=7.2u
+ PD=13.2u
* device instance $723 r0 *1 594.2,64.9 NMOS
XM$723 BL24 WL2 \$I3819 VSS NMOS L=1u W=3.4u AS=9.52p AD=6.12p PS=12.4u PD=7u
* device instance $724 r0 *1 598.8,64.9 NMOS
XM$724 \$I3819 \$I3818 VSS VSS NMOS L=1u W=3.4u AS=6.12p AD=6.46p PS=7u PD=7.2u
* device instance $725 r0 *1 603.6,64.9 NMOS
XM$725 VSS \$I3819 \$I3818 VSS NMOS L=1u W=3.4u AS=6.46p AD=6.12p PS=7.2u PD=7u
* device instance $726 r0 *1 608.2,64.9 NMOS
XM$726 \$I3818 WL2 BLB24 VSS NMOS L=1u W=3.4u AS=6.12p AD=9.52p PS=7u PD=12.4u
* device instance $727 r0 *1 598.8,381.3 PMOS
XM$727 \$I3821 \$I3820 VDD VDD PMOS L=1u W=3.4u AS=10.88p AD=6.46p PS=13.2u
+ PD=7.2u
* device instance $728 r0 *1 603.6,381.3 PMOS
XM$728 VDD \$I3821 \$I3820 VDD PMOS L=1u W=3.4u AS=6.46p AD=10.88p PS=7.2u
+ PD=13.2u
* device instance $729 r0 *1 594.2,360.9 NMOS
XM$729 BL24 WL12 \$I3821 VSS NMOS L=1u W=3.4u AS=9.52p AD=6.12p PS=12.4u PD=7u
* device instance $730 r0 *1 598.8,360.9 NMOS
XM$730 \$I3821 \$I3820 VSS VSS NMOS L=1u W=3.4u AS=6.12p AD=6.46p PS=7u PD=7.2u
* device instance $731 r0 *1 603.6,360.9 NMOS
XM$731 VSS \$I3821 \$I3820 VSS NMOS L=1u W=3.4u AS=6.46p AD=6.12p PS=7.2u PD=7u
* device instance $732 r0 *1 608.2,360.9 NMOS
XM$732 \$I3820 WL12 BLB24 VSS NMOS L=1u W=3.4u AS=6.12p AD=9.52p PS=7u PD=12.4u
* device instance $733 m0 *1 642.8,329.1 PMOS
XM$733 \$I3823 \$I3822 VDD VDD PMOS L=1u W=3.4u AS=10.88p AD=6.46p PS=13.2u
+ PD=7.2u
* device instance $734 m0 *1 647.6,329.1 PMOS
XM$734 VDD \$I3823 \$I3822 VDD PMOS L=1u W=3.4u AS=6.46p AD=10.88p PS=7.2u
+ PD=13.2u
* device instance $735 m0 *1 638.2,349.5 NMOS
XM$735 BL26 WL11 \$I3823 VSS NMOS L=1u W=3.4u AS=9.52p AD=6.12p PS=12.4u PD=7u
* device instance $736 m0 *1 642.8,349.5 NMOS
XM$736 \$I3823 \$I3822 VSS VSS NMOS L=1u W=3.4u AS=6.12p AD=6.46p PS=7u PD=7.2u
* device instance $737 m0 *1 647.6,349.5 NMOS
XM$737 VSS \$I3823 \$I3822 VSS NMOS L=1u W=3.4u AS=6.46p AD=6.12p PS=7.2u PD=7u
* device instance $738 m0 *1 652.2,349.5 NMOS
XM$738 \$I3822 WL11 BLB26 VSS NMOS L=1u W=3.4u AS=6.12p AD=9.52p PS=7u PD=12.4u
* device instance $739 m0 *1 642.8,269.9 PMOS
XM$739 \$I3825 \$I3824 VDD VDD PMOS L=1u W=3.4u AS=10.88p AD=6.46p PS=13.2u
+ PD=7.2u
* device instance $740 m0 *1 647.6,269.9 PMOS
XM$740 VDD \$I3825 \$I3824 VDD PMOS L=1u W=3.4u AS=6.46p AD=10.88p PS=7.2u
+ PD=13.2u
* device instance $741 m0 *1 638.2,290.3 NMOS
XM$741 BL26 WL9 \$I3825 VSS NMOS L=1u W=3.4u AS=9.52p AD=6.12p PS=12.4u PD=7u
* device instance $742 m0 *1 642.8,290.3 NMOS
XM$742 \$I3825 \$I3824 VSS VSS NMOS L=1u W=3.4u AS=6.12p AD=6.46p PS=7u PD=7.2u
* device instance $743 m0 *1 647.6,290.3 NMOS
XM$743 VSS \$I3825 \$I3824 VSS NMOS L=1u W=3.4u AS=6.46p AD=6.12p PS=7.2u PD=7u
* device instance $744 m0 *1 652.2,290.3 NMOS
XM$744 \$I3824 WL9 BLB26 VSS NMOS L=1u W=3.4u AS=6.12p AD=9.52p PS=7u PD=12.4u
* device instance $745 m0 *1 642.8,447.5 PMOS
XM$745 \$I3827 \$I3826 VDD VDD PMOS L=1u W=3.4u AS=10.88p AD=6.46p PS=13.2u
+ PD=7.2u
* device instance $746 m0 *1 647.6,447.5 PMOS
XM$746 VDD \$I3827 \$I3826 VDD PMOS L=1u W=3.4u AS=6.46p AD=10.88p PS=7.2u
+ PD=13.2u
* device instance $747 m0 *1 638.2,467.9 NMOS
XM$747 BL26 WL15 \$I3827 VSS NMOS L=1u W=3.4u AS=9.52p AD=6.12p PS=12.4u PD=7u
* device instance $748 m0 *1 642.8,467.9 NMOS
XM$748 \$I3827 \$I3826 VSS VSS NMOS L=1u W=3.4u AS=6.12p AD=6.46p PS=7u PD=7.2u
* device instance $749 m0 *1 647.6,467.9 NMOS
XM$749 VSS \$I3827 \$I3826 VSS NMOS L=1u W=3.4u AS=6.46p AD=6.12p PS=7.2u PD=7u
* device instance $750 m0 *1 652.2,467.9 NMOS
XM$750 \$I3826 WL15 BLB26 VSS NMOS L=1u W=3.4u AS=6.12p AD=9.52p PS=7u PD=12.4u
* device instance $751 m0 *1 642.8,388.3 PMOS
XM$751 \$I3829 \$I3828 VDD VDD PMOS L=1u W=3.4u AS=10.88p AD=6.46p PS=13.2u
+ PD=7.2u
* device instance $752 m0 *1 647.6,388.3 PMOS
XM$752 VDD \$I3829 \$I3828 VDD PMOS L=1u W=3.4u AS=6.46p AD=10.88p PS=7.2u
+ PD=13.2u
* device instance $753 m0 *1 638.2,408.7 NMOS
XM$753 BL26 WL13 \$I3829 VSS NMOS L=1u W=3.4u AS=9.52p AD=6.12p PS=12.4u PD=7u
* device instance $754 m0 *1 642.8,408.7 NMOS
XM$754 \$I3829 \$I3828 VSS VSS NMOS L=1u W=3.4u AS=6.12p AD=6.46p PS=7u PD=7.2u
* device instance $755 m0 *1 647.6,408.7 NMOS
XM$755 VSS \$I3829 \$I3828 VSS NMOS L=1u W=3.4u AS=6.46p AD=6.12p PS=7.2u PD=7u
* device instance $756 m0 *1 652.2,408.7 NMOS
XM$756 \$I3828 WL13 BLB26 VSS NMOS L=1u W=3.4u AS=6.12p AD=9.52p PS=7u PD=12.4u
* device instance $757 m0 *1 642.8,92.3 PMOS
XM$757 \$I3831 \$I3830 VDD VDD PMOS L=1u W=3.4u AS=10.88p AD=6.46p PS=13.2u
+ PD=7.2u
* device instance $758 m0 *1 647.6,92.3 PMOS
XM$758 VDD \$I3831 \$I3830 VDD PMOS L=1u W=3.4u AS=6.46p AD=10.88p PS=7.2u
+ PD=13.2u
* device instance $759 m0 *1 638.2,112.7 NMOS
XM$759 BL26 WL3 \$I3831 VSS NMOS L=1u W=3.4u AS=9.52p AD=6.12p PS=12.4u PD=7u
* device instance $760 m0 *1 642.8,112.7 NMOS
XM$760 \$I3831 \$I3830 VSS VSS NMOS L=1u W=3.4u AS=6.12p AD=6.46p PS=7u PD=7.2u
* device instance $761 m0 *1 647.6,112.7 NMOS
XM$761 VSS \$I3831 \$I3830 VSS NMOS L=1u W=3.4u AS=6.46p AD=6.12p PS=7.2u PD=7u
* device instance $762 m0 *1 652.2,112.7 NMOS
XM$762 \$I3830 WL3 BLB26 VSS NMOS L=1u W=3.4u AS=6.12p AD=9.52p PS=7u PD=12.4u
* device instance $763 m0 *1 642.8,33.1 PMOS
XM$763 \$I3833 \$I3832 VDD VDD PMOS L=1u W=3.4u AS=10.88p AD=6.46p PS=13.2u
+ PD=7.2u
* device instance $764 m0 *1 647.6,33.1 PMOS
XM$764 VDD \$I3833 \$I3832 VDD PMOS L=1u W=3.4u AS=6.46p AD=10.88p PS=7.2u
+ PD=13.2u
* device instance $765 m0 *1 638.2,53.5 NMOS
XM$765 BL26 WL1 \$I3833 VSS NMOS L=1u W=3.4u AS=9.52p AD=6.12p PS=12.4u PD=7u
* device instance $766 m0 *1 642.8,53.5 NMOS
XM$766 \$I3833 \$I3832 VSS VSS NMOS L=1u W=3.4u AS=6.12p AD=6.46p PS=7u PD=7.2u
* device instance $767 m0 *1 647.6,53.5 NMOS
XM$767 VSS \$I3833 \$I3832 VSS NMOS L=1u W=3.4u AS=6.46p AD=6.12p PS=7.2u PD=7u
* device instance $768 m0 *1 652.2,53.5 NMOS
XM$768 \$I3832 WL1 BLB26 VSS NMOS L=1u W=3.4u AS=6.12p AD=9.52p PS=7u PD=12.4u
* device instance $769 m0 *1 642.8,210.7 PMOS
XM$769 \$I3835 \$I3834 VDD VDD PMOS L=1u W=3.4u AS=10.88p AD=6.46p PS=13.2u
+ PD=7.2u
* device instance $770 m0 *1 647.6,210.7 PMOS
XM$770 VDD \$I3835 \$I3834 VDD PMOS L=1u W=3.4u AS=6.46p AD=10.88p PS=7.2u
+ PD=13.2u
* device instance $771 m0 *1 638.2,231.1 NMOS
XM$771 BL26 WL7 \$I3835 VSS NMOS L=1u W=3.4u AS=9.52p AD=6.12p PS=12.4u PD=7u
* device instance $772 m0 *1 642.8,231.1 NMOS
XM$772 \$I3835 \$I3834 VSS VSS NMOS L=1u W=3.4u AS=6.12p AD=6.46p PS=7u PD=7.2u
* device instance $773 m0 *1 647.6,231.1 NMOS
XM$773 VSS \$I3835 \$I3834 VSS NMOS L=1u W=3.4u AS=6.46p AD=6.12p PS=7.2u PD=7u
* device instance $774 m0 *1 652.2,231.1 NMOS
XM$774 \$I3834 WL7 BLB26 VSS NMOS L=1u W=3.4u AS=6.12p AD=9.52p PS=7u PD=12.4u
* device instance $775 m0 *1 642.8,151.5 PMOS
XM$775 \$I3837 \$I3836 VDD VDD PMOS L=1u W=3.4u AS=10.88p AD=6.46p PS=13.2u
+ PD=7.2u
* device instance $776 m0 *1 647.6,151.5 PMOS
XM$776 VDD \$I3837 \$I3836 VDD PMOS L=1u W=3.4u AS=6.46p AD=10.88p PS=7.2u
+ PD=13.2u
* device instance $777 m0 *1 638.2,171.9 NMOS
XM$777 BL26 WL5 \$I3837 VSS NMOS L=1u W=3.4u AS=9.52p AD=6.12p PS=12.4u PD=7u
* device instance $778 m0 *1 642.8,171.9 NMOS
XM$778 \$I3837 \$I3836 VSS VSS NMOS L=1u W=3.4u AS=6.12p AD=6.46p PS=7u PD=7.2u
* device instance $779 m0 *1 647.6,171.9 NMOS
XM$779 VSS \$I3837 \$I3836 VSS NMOS L=1u W=3.4u AS=6.46p AD=6.12p PS=7.2u PD=7u
* device instance $780 m0 *1 652.2,171.9 NMOS
XM$780 \$I3836 WL5 BLB26 VSS NMOS L=1u W=3.4u AS=6.12p AD=9.52p PS=7u PD=12.4u
* device instance $781 r0 *1 642.8,381.3 PMOS
XM$781 \$I3839 \$I3838 VDD VDD PMOS L=1u W=3.4u AS=10.88p AD=6.46p PS=13.2u
+ PD=7.2u
* device instance $782 r0 *1 647.6,381.3 PMOS
XM$782 VDD \$I3839 \$I3838 VDD PMOS L=1u W=3.4u AS=6.46p AD=10.88p PS=7.2u
+ PD=13.2u
* device instance $783 r0 *1 638.2,360.9 NMOS
XM$783 BL26 WL12 \$I3839 VSS NMOS L=1u W=3.4u AS=9.52p AD=6.12p PS=12.4u PD=7u
* device instance $784 r0 *1 642.8,360.9 NMOS
XM$784 \$I3839 \$I3838 VSS VSS NMOS L=1u W=3.4u AS=6.12p AD=6.46p PS=7u PD=7.2u
* device instance $785 r0 *1 647.6,360.9 NMOS
XM$785 VSS \$I3839 \$I3838 VSS NMOS L=1u W=3.4u AS=6.46p AD=6.12p PS=7.2u PD=7u
* device instance $786 r0 *1 652.2,360.9 NMOS
XM$786 \$I3838 WL12 BLB26 VSS NMOS L=1u W=3.4u AS=6.12p AD=9.52p PS=7u PD=12.4u
* device instance $787 r0 *1 642.8,440.5 PMOS
XM$787 \$I3841 \$I3840 VDD VDD PMOS L=1u W=3.4u AS=10.88p AD=6.46p PS=13.2u
+ PD=7.2u
* device instance $788 r0 *1 647.6,440.5 PMOS
XM$788 VDD \$I3841 \$I3840 VDD PMOS L=1u W=3.4u AS=6.46p AD=10.88p PS=7.2u
+ PD=13.2u
* device instance $789 r0 *1 638.2,420.1 NMOS
XM$789 BL26 WL14 \$I3841 VSS NMOS L=1u W=3.4u AS=9.52p AD=6.12p PS=12.4u PD=7u
* device instance $790 r0 *1 642.8,420.1 NMOS
XM$790 \$I3841 \$I3840 VSS VSS NMOS L=1u W=3.4u AS=6.12p AD=6.46p PS=7u PD=7.2u
* device instance $791 r0 *1 647.6,420.1 NMOS
XM$791 VSS \$I3841 \$I3840 VSS NMOS L=1u W=3.4u AS=6.46p AD=6.12p PS=7.2u PD=7u
* device instance $792 r0 *1 652.2,420.1 NMOS
XM$792 \$I3840 WL14 BLB26 VSS NMOS L=1u W=3.4u AS=6.12p AD=9.52p PS=7u PD=12.4u
* device instance $793 r0 *1 642.8,322.1 PMOS
XM$793 \$I3843 \$I3842 VDD VDD PMOS L=1u W=3.4u AS=10.88p AD=6.46p PS=13.2u
+ PD=7.2u
* device instance $794 r0 *1 647.6,322.1 PMOS
XM$794 VDD \$I3843 \$I3842 VDD PMOS L=1u W=3.4u AS=6.46p AD=10.88p PS=7.2u
+ PD=13.2u
* device instance $795 r0 *1 638.2,301.7 NMOS
XM$795 BL26 WL10 \$I3843 VSS NMOS L=1u W=3.4u AS=9.52p AD=6.12p PS=12.4u PD=7u
* device instance $796 r0 *1 642.8,301.7 NMOS
XM$796 \$I3843 \$I3842 VSS VSS NMOS L=1u W=3.4u AS=6.12p AD=6.46p PS=7u PD=7.2u
* device instance $797 r0 *1 647.6,301.7 NMOS
XM$797 VSS \$I3843 \$I3842 VSS NMOS L=1u W=3.4u AS=6.46p AD=6.12p PS=7.2u PD=7u
* device instance $798 r0 *1 652.2,301.7 NMOS
XM$798 \$I3842 WL10 BLB26 VSS NMOS L=1u W=3.4u AS=6.12p AD=9.52p PS=7u PD=12.4u
* device instance $799 r0 *1 642.8,262.9 PMOS
XM$799 \$I3845 \$I3844 VDD VDD PMOS L=1u W=3.4u AS=10.88p AD=6.46p PS=13.2u
+ PD=7.2u
* device instance $800 r0 *1 647.6,262.9 PMOS
XM$800 VDD \$I3845 \$I3844 VDD PMOS L=1u W=3.4u AS=6.46p AD=10.88p PS=7.2u
+ PD=13.2u
* device instance $801 r0 *1 638.2,242.5 NMOS
XM$801 BL26 WL8 \$I3845 VSS NMOS L=1u W=3.4u AS=9.52p AD=6.12p PS=12.4u PD=7u
* device instance $802 r0 *1 642.8,242.5 NMOS
XM$802 \$I3845 \$I3844 VSS VSS NMOS L=1u W=3.4u AS=6.12p AD=6.46p PS=7u PD=7.2u
* device instance $803 r0 *1 647.6,242.5 NMOS
XM$803 VSS \$I3845 \$I3844 VSS NMOS L=1u W=3.4u AS=6.46p AD=6.12p PS=7.2u PD=7u
* device instance $804 r0 *1 652.2,242.5 NMOS
XM$804 \$I3844 WL8 BLB26 VSS NMOS L=1u W=3.4u AS=6.12p AD=9.52p PS=7u PD=12.4u
* device instance $805 r0 *1 642.8,144.5 PMOS
XM$805 \$I3847 \$I3846 VDD VDD PMOS L=1u W=3.4u AS=10.88p AD=6.46p PS=13.2u
+ PD=7.2u
* device instance $806 r0 *1 647.6,144.5 PMOS
XM$806 VDD \$I3847 \$I3846 VDD PMOS L=1u W=3.4u AS=6.46p AD=10.88p PS=7.2u
+ PD=13.2u
* device instance $807 r0 *1 638.2,124.1 NMOS
XM$807 BL26 WL4 \$I3847 VSS NMOS L=1u W=3.4u AS=9.52p AD=6.12p PS=12.4u PD=7u
* device instance $808 r0 *1 642.8,124.1 NMOS
XM$808 \$I3847 \$I3846 VSS VSS NMOS L=1u W=3.4u AS=6.12p AD=6.46p PS=7u PD=7.2u
* device instance $809 r0 *1 647.6,124.1 NMOS
XM$809 VSS \$I3847 \$I3846 VSS NMOS L=1u W=3.4u AS=6.46p AD=6.12p PS=7.2u PD=7u
* device instance $810 r0 *1 652.2,124.1 NMOS
XM$810 \$I3846 WL4 BLB26 VSS NMOS L=1u W=3.4u AS=6.12p AD=9.52p PS=7u PD=12.4u
* device instance $811 r0 *1 642.8,203.7 PMOS
XM$811 \$I3849 \$I3848 VDD VDD PMOS L=1u W=3.4u AS=10.88p AD=6.46p PS=13.2u
+ PD=7.2u
* device instance $812 r0 *1 647.6,203.7 PMOS
XM$812 VDD \$I3849 \$I3848 VDD PMOS L=1u W=3.4u AS=6.46p AD=10.88p PS=7.2u
+ PD=13.2u
* device instance $813 r0 *1 638.2,183.3 NMOS
XM$813 BL26 WL6 \$I3849 VSS NMOS L=1u W=3.4u AS=9.52p AD=6.12p PS=12.4u PD=7u
* device instance $814 r0 *1 642.8,183.3 NMOS
XM$814 \$I3849 \$I3848 VSS VSS NMOS L=1u W=3.4u AS=6.12p AD=6.46p PS=7u PD=7.2u
* device instance $815 r0 *1 647.6,183.3 NMOS
XM$815 VSS \$I3849 \$I3848 VSS NMOS L=1u W=3.4u AS=6.46p AD=6.12p PS=7.2u PD=7u
* device instance $816 r0 *1 652.2,183.3 NMOS
XM$816 \$I3848 WL6 BLB26 VSS NMOS L=1u W=3.4u AS=6.12p AD=9.52p PS=7u PD=12.4u
* device instance $817 r0 *1 642.8,85.3 PMOS
XM$817 \$I3851 \$I3850 VDD VDD PMOS L=1u W=3.4u AS=10.88p AD=6.46p PS=13.2u
+ PD=7.2u
* device instance $818 r0 *1 647.6,85.3 PMOS
XM$818 VDD \$I3851 \$I3850 VDD PMOS L=1u W=3.4u AS=6.46p AD=10.88p PS=7.2u
+ PD=13.2u
* device instance $819 r0 *1 638.2,64.9 NMOS
XM$819 BL26 WL2 \$I3851 VSS NMOS L=1u W=3.4u AS=9.52p AD=6.12p PS=12.4u PD=7u
* device instance $820 r0 *1 642.8,64.9 NMOS
XM$820 \$I3851 \$I3850 VSS VSS NMOS L=1u W=3.4u AS=6.12p AD=6.46p PS=7u PD=7.2u
* device instance $821 r0 *1 647.6,64.9 NMOS
XM$821 VSS \$I3851 \$I3850 VSS NMOS L=1u W=3.4u AS=6.46p AD=6.12p PS=7.2u PD=7u
* device instance $822 r0 *1 652.2,64.9 NMOS
XM$822 \$I3850 WL2 BLB26 VSS NMOS L=1u W=3.4u AS=6.12p AD=9.52p PS=7u PD=12.4u
* device instance $823 m0 *1 51.2,92.3 PMOS
XM$823 \$I3853 \$I3852 VDD VDD PMOS L=1u W=3.4u AS=10.88p AD=6.46p PS=13.2u
+ PD=7.2u
* device instance $824 m0 *1 56,92.3 PMOS
XM$824 VDD \$I3853 \$I3852 VDD PMOS L=1u W=3.4u AS=6.46p AD=10.88p PS=7.2u
+ PD=13.2u
* device instance $825 m0 *1 46.6,112.7 NMOS
XM$825 BL2 WL3 \$I3853 VSS NMOS L=1u W=3.4u AS=9.52p AD=6.12p PS=12.4u PD=7u
* device instance $826 m0 *1 51.2,112.7 NMOS
XM$826 \$I3853 \$I3852 VSS VSS NMOS L=1u W=3.4u AS=6.12p AD=6.46p PS=7u PD=7.2u
* device instance $827 m0 *1 56,112.7 NMOS
XM$827 VSS \$I3853 \$I3852 VSS NMOS L=1u W=3.4u AS=6.46p AD=6.12p PS=7.2u PD=7u
* device instance $828 m0 *1 60.6,112.7 NMOS
XM$828 \$I3852 WL3 BLB2 VSS NMOS L=1u W=3.4u AS=6.12p AD=9.52p PS=7u PD=12.4u
* device instance $829 m0 *1 51.2,269.9 PMOS
XM$829 \$I3855 \$I3854 VDD VDD PMOS L=1u W=3.4u AS=10.88p AD=6.46p PS=13.2u
+ PD=7.2u
* device instance $830 m0 *1 56,269.9 PMOS
XM$830 VDD \$I3855 \$I3854 VDD PMOS L=1u W=3.4u AS=6.46p AD=10.88p PS=7.2u
+ PD=13.2u
* device instance $831 m0 *1 46.6,290.3 NMOS
XM$831 BL2 WL9 \$I3855 VSS NMOS L=1u W=3.4u AS=9.52p AD=6.12p PS=12.4u PD=7u
* device instance $832 m0 *1 51.2,290.3 NMOS
XM$832 \$I3855 \$I3854 VSS VSS NMOS L=1u W=3.4u AS=6.12p AD=6.46p PS=7u PD=7.2u
* device instance $833 m0 *1 56,290.3 NMOS
XM$833 VSS \$I3855 \$I3854 VSS NMOS L=1u W=3.4u AS=6.46p AD=6.12p PS=7.2u PD=7u
* device instance $834 m0 *1 60.6,290.3 NMOS
XM$834 \$I3854 WL9 BLB2 VSS NMOS L=1u W=3.4u AS=6.12p AD=9.52p PS=7u PD=12.4u
* device instance $835 m0 *1 51.2,33.1 PMOS
XM$835 \$I3857 \$I3856 VDD VDD PMOS L=1u W=3.4u AS=10.88p AD=6.46p PS=13.2u
+ PD=7.2u
* device instance $836 m0 *1 56,33.1 PMOS
XM$836 VDD \$I3857 \$I3856 VDD PMOS L=1u W=3.4u AS=6.46p AD=10.88p PS=7.2u
+ PD=13.2u
* device instance $837 m0 *1 46.6,53.5 NMOS
XM$837 BL2 WL1 \$I3857 VSS NMOS L=1u W=3.4u AS=9.52p AD=6.12p PS=12.4u PD=7u
* device instance $838 m0 *1 51.2,53.5 NMOS
XM$838 \$I3857 \$I3856 VSS VSS NMOS L=1u W=3.4u AS=6.12p AD=6.46p PS=7u PD=7.2u
* device instance $839 m0 *1 56,53.5 NMOS
XM$839 VSS \$I3857 \$I3856 VSS NMOS L=1u W=3.4u AS=6.46p AD=6.12p PS=7.2u PD=7u
* device instance $840 m0 *1 60.6,53.5 NMOS
XM$840 \$I3856 WL1 BLB2 VSS NMOS L=1u W=3.4u AS=6.12p AD=9.52p PS=7u PD=12.4u
* device instance $841 m0 *1 51.2,210.7 PMOS
XM$841 \$I3859 \$I3858 VDD VDD PMOS L=1u W=3.4u AS=10.88p AD=6.46p PS=13.2u
+ PD=7.2u
* device instance $842 m0 *1 56,210.7 PMOS
XM$842 VDD \$I3859 \$I3858 VDD PMOS L=1u W=3.4u AS=6.46p AD=10.88p PS=7.2u
+ PD=13.2u
* device instance $843 m0 *1 46.6,231.1 NMOS
XM$843 BL2 WL7 \$I3859 VSS NMOS L=1u W=3.4u AS=9.52p AD=6.12p PS=12.4u PD=7u
* device instance $844 m0 *1 51.2,231.1 NMOS
XM$844 \$I3859 \$I3858 VSS VSS NMOS L=1u W=3.4u AS=6.12p AD=6.46p PS=7u PD=7.2u
* device instance $845 m0 *1 56,231.1 NMOS
XM$845 VSS \$I3859 \$I3858 VSS NMOS L=1u W=3.4u AS=6.46p AD=6.12p PS=7.2u PD=7u
* device instance $846 m0 *1 60.6,231.1 NMOS
XM$846 \$I3858 WL7 BLB2 VSS NMOS L=1u W=3.4u AS=6.12p AD=9.52p PS=7u PD=12.4u
* device instance $847 m0 *1 51.2,151.5 PMOS
XM$847 \$I3861 \$I3860 VDD VDD PMOS L=1u W=3.4u AS=10.88p AD=6.46p PS=13.2u
+ PD=7.2u
* device instance $848 m0 *1 56,151.5 PMOS
XM$848 VDD \$I3861 \$I3860 VDD PMOS L=1u W=3.4u AS=6.46p AD=10.88p PS=7.2u
+ PD=13.2u
* device instance $849 m0 *1 46.6,171.9 NMOS
XM$849 BL2 WL5 \$I3861 VSS NMOS L=1u W=3.4u AS=9.52p AD=6.12p PS=12.4u PD=7u
* device instance $850 m0 *1 51.2,171.9 NMOS
XM$850 \$I3861 \$I3860 VSS VSS NMOS L=1u W=3.4u AS=6.12p AD=6.46p PS=7u PD=7.2u
* device instance $851 m0 *1 56,171.9 NMOS
XM$851 VSS \$I3861 \$I3860 VSS NMOS L=1u W=3.4u AS=6.46p AD=6.12p PS=7.2u PD=7u
* device instance $852 m0 *1 60.6,171.9 NMOS
XM$852 \$I3860 WL5 BLB2 VSS NMOS L=1u W=3.4u AS=6.12p AD=9.52p PS=7u PD=12.4u
* device instance $853 m0 *1 51.2,447.5 PMOS
XM$853 \$I3863 \$I3862 VDD VDD PMOS L=1u W=3.4u AS=10.88p AD=6.46p PS=13.2u
+ PD=7.2u
* device instance $854 m0 *1 56,447.5 PMOS
XM$854 VDD \$I3863 \$I3862 VDD PMOS L=1u W=3.4u AS=6.46p AD=10.88p PS=7.2u
+ PD=13.2u
* device instance $855 m0 *1 46.6,467.9 NMOS
XM$855 BL2 WL15 \$I3863 VSS NMOS L=1u W=3.4u AS=9.52p AD=6.12p PS=12.4u PD=7u
* device instance $856 m0 *1 51.2,467.9 NMOS
XM$856 \$I3863 \$I3862 VSS VSS NMOS L=1u W=3.4u AS=6.12p AD=6.46p PS=7u PD=7.2u
* device instance $857 m0 *1 56,467.9 NMOS
XM$857 VSS \$I3863 \$I3862 VSS NMOS L=1u W=3.4u AS=6.46p AD=6.12p PS=7.2u PD=7u
* device instance $858 m0 *1 60.6,467.9 NMOS
XM$858 \$I3862 WL15 BLB2 VSS NMOS L=1u W=3.4u AS=6.12p AD=9.52p PS=7u PD=12.4u
* device instance $859 m0 *1 51.2,388.3 PMOS
XM$859 \$I3865 \$I3864 VDD VDD PMOS L=1u W=3.4u AS=10.88p AD=6.46p PS=13.2u
+ PD=7.2u
* device instance $860 m0 *1 56,388.3 PMOS
XM$860 VDD \$I3865 \$I3864 VDD PMOS L=1u W=3.4u AS=6.46p AD=10.88p PS=7.2u
+ PD=13.2u
* device instance $861 m0 *1 46.6,408.7 NMOS
XM$861 BL2 WL13 \$I3865 VSS NMOS L=1u W=3.4u AS=9.52p AD=6.12p PS=12.4u PD=7u
* device instance $862 m0 *1 51.2,408.7 NMOS
XM$862 \$I3865 \$I3864 VSS VSS NMOS L=1u W=3.4u AS=6.12p AD=6.46p PS=7u PD=7.2u
* device instance $863 m0 *1 56,408.7 NMOS
XM$863 VSS \$I3865 \$I3864 VSS NMOS L=1u W=3.4u AS=6.46p AD=6.12p PS=7.2u PD=7u
* device instance $864 m0 *1 60.6,408.7 NMOS
XM$864 \$I3864 WL13 BLB2 VSS NMOS L=1u W=3.4u AS=6.12p AD=9.52p PS=7u PD=12.4u
* device instance $865 m0 *1 51.2,329.1 PMOS
XM$865 \$I3867 \$I3866 VDD VDD PMOS L=1u W=3.4u AS=10.88p AD=6.46p PS=13.2u
+ PD=7.2u
* device instance $866 m0 *1 56,329.1 PMOS
XM$866 VDD \$I3867 \$I3866 VDD PMOS L=1u W=3.4u AS=6.46p AD=10.88p PS=7.2u
+ PD=13.2u
* device instance $867 m0 *1 46.6,349.5 NMOS
XM$867 BL2 WL11 \$I3867 VSS NMOS L=1u W=3.4u AS=9.52p AD=6.12p PS=12.4u PD=7u
* device instance $868 m0 *1 51.2,349.5 NMOS
XM$868 \$I3867 \$I3866 VSS VSS NMOS L=1u W=3.4u AS=6.12p AD=6.46p PS=7u PD=7.2u
* device instance $869 m0 *1 56,349.5 NMOS
XM$869 VSS \$I3867 \$I3866 VSS NMOS L=1u W=3.4u AS=6.46p AD=6.12p PS=7.2u PD=7u
* device instance $870 m0 *1 60.6,349.5 NMOS
XM$870 \$I3866 WL11 BLB2 VSS NMOS L=1u W=3.4u AS=6.12p AD=9.52p PS=7u PD=12.4u
* device instance $871 r0 *1 51.2,440.5 PMOS
XM$871 \$I3869 \$I3868 VDD VDD PMOS L=1u W=3.4u AS=10.88p AD=6.46p PS=13.2u
+ PD=7.2u
* device instance $872 r0 *1 56,440.5 PMOS
XM$872 VDD \$I3869 \$I3868 VDD PMOS L=1u W=3.4u AS=6.46p AD=10.88p PS=7.2u
+ PD=13.2u
* device instance $873 r0 *1 46.6,420.1 NMOS
XM$873 BL2 WL14 \$I3869 VSS NMOS L=1u W=3.4u AS=9.52p AD=6.12p PS=12.4u PD=7u
* device instance $874 r0 *1 51.2,420.1 NMOS
XM$874 \$I3869 \$I3868 VSS VSS NMOS L=1u W=3.4u AS=6.12p AD=6.46p PS=7u PD=7.2u
* device instance $875 r0 *1 56,420.1 NMOS
XM$875 VSS \$I3869 \$I3868 VSS NMOS L=1u W=3.4u AS=6.46p AD=6.12p PS=7.2u PD=7u
* device instance $876 r0 *1 60.6,420.1 NMOS
XM$876 \$I3868 WL14 BLB2 VSS NMOS L=1u W=3.4u AS=6.12p AD=9.52p PS=7u PD=12.4u
* device instance $877 r0 *1 51.2,381.3 PMOS
XM$877 \$I3871 \$I3870 VDD VDD PMOS L=1u W=3.4u AS=10.88p AD=6.46p PS=13.2u
+ PD=7.2u
* device instance $878 r0 *1 56,381.3 PMOS
XM$878 VDD \$I3871 \$I3870 VDD PMOS L=1u W=3.4u AS=6.46p AD=10.88p PS=7.2u
+ PD=13.2u
* device instance $879 r0 *1 46.6,360.9 NMOS
XM$879 BL2 WL12 \$I3871 VSS NMOS L=1u W=3.4u AS=9.52p AD=6.12p PS=12.4u PD=7u
* device instance $880 r0 *1 51.2,360.9 NMOS
XM$880 \$I3871 \$I3870 VSS VSS NMOS L=1u W=3.4u AS=6.12p AD=6.46p PS=7u PD=7.2u
* device instance $881 r0 *1 56,360.9 NMOS
XM$881 VSS \$I3871 \$I3870 VSS NMOS L=1u W=3.4u AS=6.46p AD=6.12p PS=7.2u PD=7u
* device instance $882 r0 *1 60.6,360.9 NMOS
XM$882 \$I3870 WL12 BLB2 VSS NMOS L=1u W=3.4u AS=6.12p AD=9.52p PS=7u PD=12.4u
* device instance $883 r0 *1 51.2,322.1 PMOS
XM$883 \$I3873 \$I3872 VDD VDD PMOS L=1u W=3.4u AS=10.88p AD=6.46p PS=13.2u
+ PD=7.2u
* device instance $884 r0 *1 56,322.1 PMOS
XM$884 VDD \$I3873 \$I3872 VDD PMOS L=1u W=3.4u AS=6.46p AD=10.88p PS=7.2u
+ PD=13.2u
* device instance $885 r0 *1 46.6,301.7 NMOS
XM$885 BL2 WL10 \$I3873 VSS NMOS L=1u W=3.4u AS=9.52p AD=6.12p PS=12.4u PD=7u
* device instance $886 r0 *1 51.2,301.7 NMOS
XM$886 \$I3873 \$I3872 VSS VSS NMOS L=1u W=3.4u AS=6.12p AD=6.46p PS=7u PD=7.2u
* device instance $887 r0 *1 56,301.7 NMOS
XM$887 VSS \$I3873 \$I3872 VSS NMOS L=1u W=3.4u AS=6.46p AD=6.12p PS=7.2u PD=7u
* device instance $888 r0 *1 60.6,301.7 NMOS
XM$888 \$I3872 WL10 BLB2 VSS NMOS L=1u W=3.4u AS=6.12p AD=9.52p PS=7u PD=12.4u
* device instance $889 r0 *1 51.2,262.9 PMOS
XM$889 \$I3875 \$I3874 VDD VDD PMOS L=1u W=3.4u AS=10.88p AD=6.46p PS=13.2u
+ PD=7.2u
* device instance $890 r0 *1 56,262.9 PMOS
XM$890 VDD \$I3875 \$I3874 VDD PMOS L=1u W=3.4u AS=6.46p AD=10.88p PS=7.2u
+ PD=13.2u
* device instance $891 r0 *1 46.6,242.5 NMOS
XM$891 BL2 WL8 \$I3875 VSS NMOS L=1u W=3.4u AS=9.52p AD=6.12p PS=12.4u PD=7u
* device instance $892 r0 *1 51.2,242.5 NMOS
XM$892 \$I3875 \$I3874 VSS VSS NMOS L=1u W=3.4u AS=6.12p AD=6.46p PS=7u PD=7.2u
* device instance $893 r0 *1 56,242.5 NMOS
XM$893 VSS \$I3875 \$I3874 VSS NMOS L=1u W=3.4u AS=6.46p AD=6.12p PS=7.2u PD=7u
* device instance $894 r0 *1 60.6,242.5 NMOS
XM$894 \$I3874 WL8 BLB2 VSS NMOS L=1u W=3.4u AS=6.12p AD=9.52p PS=7u PD=12.4u
* device instance $895 r0 *1 51.2,144.5 PMOS
XM$895 \$I3877 \$I3876 VDD VDD PMOS L=1u W=3.4u AS=10.88p AD=6.46p PS=13.2u
+ PD=7.2u
* device instance $896 r0 *1 56,144.5 PMOS
XM$896 VDD \$I3877 \$I3876 VDD PMOS L=1u W=3.4u AS=6.46p AD=10.88p PS=7.2u
+ PD=13.2u
* device instance $897 r0 *1 46.6,124.1 NMOS
XM$897 BL2 WL4 \$I3877 VSS NMOS L=1u W=3.4u AS=9.52p AD=6.12p PS=12.4u PD=7u
* device instance $898 r0 *1 51.2,124.1 NMOS
XM$898 \$I3877 \$I3876 VSS VSS NMOS L=1u W=3.4u AS=6.12p AD=6.46p PS=7u PD=7.2u
* device instance $899 r0 *1 56,124.1 NMOS
XM$899 VSS \$I3877 \$I3876 VSS NMOS L=1u W=3.4u AS=6.46p AD=6.12p PS=7.2u PD=7u
* device instance $900 r0 *1 60.6,124.1 NMOS
XM$900 \$I3876 WL4 BLB2 VSS NMOS L=1u W=3.4u AS=6.12p AD=9.52p PS=7u PD=12.4u
* device instance $901 r0 *1 51.2,85.3 PMOS
XM$901 \$I3879 \$I3878 VDD VDD PMOS L=1u W=3.4u AS=10.88p AD=6.46p PS=13.2u
+ PD=7.2u
* device instance $902 r0 *1 56,85.3 PMOS
XM$902 VDD \$I3879 \$I3878 VDD PMOS L=1u W=3.4u AS=6.46p AD=10.88p PS=7.2u
+ PD=13.2u
* device instance $903 r0 *1 46.6,64.9 NMOS
XM$903 BL2 WL2 \$I3879 VSS NMOS L=1u W=3.4u AS=9.52p AD=6.12p PS=12.4u PD=7u
* device instance $904 r0 *1 51.2,64.9 NMOS
XM$904 \$I3879 \$I3878 VSS VSS NMOS L=1u W=3.4u AS=6.12p AD=6.46p PS=7u PD=7.2u
* device instance $905 r0 *1 56,64.9 NMOS
XM$905 VSS \$I3879 \$I3878 VSS NMOS L=1u W=3.4u AS=6.46p AD=6.12p PS=7.2u PD=7u
* device instance $906 r0 *1 60.6,64.9 NMOS
XM$906 \$I3878 WL2 BLB2 VSS NMOS L=1u W=3.4u AS=6.12p AD=9.52p PS=7u PD=12.4u
* device instance $907 r0 *1 51.2,203.7 PMOS
XM$907 \$I3881 \$I3880 VDD VDD PMOS L=1u W=3.4u AS=10.88p AD=6.46p PS=13.2u
+ PD=7.2u
* device instance $908 r0 *1 56,203.7 PMOS
XM$908 VDD \$I3881 \$I3880 VDD PMOS L=1u W=3.4u AS=6.46p AD=10.88p PS=7.2u
+ PD=13.2u
* device instance $909 r0 *1 46.6,183.3 NMOS
XM$909 BL2 WL6 \$I3881 VSS NMOS L=1u W=3.4u AS=9.52p AD=6.12p PS=12.4u PD=7u
* device instance $910 r0 *1 51.2,183.3 NMOS
XM$910 \$I3881 \$I3880 VSS VSS NMOS L=1u W=3.4u AS=6.12p AD=6.46p PS=7u PD=7.2u
* device instance $911 r0 *1 56,183.3 NMOS
XM$911 VSS \$I3881 \$I3880 VSS NMOS L=1u W=3.4u AS=6.46p AD=6.12p PS=7.2u PD=7u
* device instance $912 r0 *1 60.6,183.3 NMOS
XM$912 \$I3880 WL6 BLB2 VSS NMOS L=1u W=3.4u AS=6.12p AD=9.52p PS=7u PD=12.4u
* device instance $913 m0 *1 29.2,92.3 PMOS
XM$913 \$I3883 \$I3882 VDD VDD PMOS L=1u W=3.4u AS=10.88p AD=6.46p PS=13.2u
+ PD=7.2u
* device instance $914 m0 *1 34,92.3 PMOS
XM$914 VDD \$I3883 \$I3882 VDD PMOS L=1u W=3.4u AS=6.46p AD=10.88p PS=7.2u
+ PD=13.2u
* device instance $915 m0 *1 24.6,112.7 NMOS
XM$915 BL1 WL3 \$I3883 VSS NMOS L=1u W=3.4u AS=9.52p AD=6.12p PS=12.4u PD=7u
* device instance $916 m0 *1 29.2,112.7 NMOS
XM$916 \$I3883 \$I3882 VSS VSS NMOS L=1u W=3.4u AS=6.12p AD=6.46p PS=7u PD=7.2u
* device instance $917 m0 *1 34,112.7 NMOS
XM$917 VSS \$I3883 \$I3882 VSS NMOS L=1u W=3.4u AS=6.46p AD=6.12p PS=7.2u PD=7u
* device instance $918 m0 *1 38.6,112.7 NMOS
XM$918 \$I3882 WL3 BLB1 VSS NMOS L=1u W=3.4u AS=6.12p AD=9.52p PS=7u PD=12.4u
* device instance $919 m0 *1 29.2,388.3 PMOS
XM$919 \$I3885 \$I3884 VDD VDD PMOS L=1u W=3.4u AS=10.88p AD=6.46p PS=13.2u
+ PD=7.2u
* device instance $920 m0 *1 34,388.3 PMOS
XM$920 VDD \$I3885 \$I3884 VDD PMOS L=1u W=3.4u AS=6.46p AD=10.88p PS=7.2u
+ PD=13.2u
* device instance $921 m0 *1 24.6,408.7 NMOS
XM$921 BL1 WL13 \$I3885 VSS NMOS L=1u W=3.4u AS=9.52p AD=6.12p PS=12.4u PD=7u
* device instance $922 m0 *1 29.2,408.7 NMOS
XM$922 \$I3885 \$I3884 VSS VSS NMOS L=1u W=3.4u AS=6.12p AD=6.46p PS=7u PD=7.2u
* device instance $923 m0 *1 34,408.7 NMOS
XM$923 VSS \$I3885 \$I3884 VSS NMOS L=1u W=3.4u AS=6.46p AD=6.12p PS=7.2u PD=7u
* device instance $924 m0 *1 38.6,408.7 NMOS
XM$924 \$I3884 WL13 BLB1 VSS NMOS L=1u W=3.4u AS=6.12p AD=9.52p PS=7u PD=12.4u
* device instance $925 m0 *1 29.2,33.1 PMOS
XM$925 \$I3887 \$I3886 VDD VDD PMOS L=1u W=3.4u AS=10.88p AD=6.46p PS=13.2u
+ PD=7.2u
* device instance $926 m0 *1 34,33.1 PMOS
XM$926 VDD \$I3887 \$I3886 VDD PMOS L=1u W=3.4u AS=6.46p AD=10.88p PS=7.2u
+ PD=13.2u
* device instance $927 m0 *1 24.6,53.5 NMOS
XM$927 BL1 WL1 \$I3887 VSS NMOS L=1u W=3.4u AS=9.52p AD=6.12p PS=12.4u PD=7u
* device instance $928 m0 *1 29.2,53.5 NMOS
XM$928 \$I3887 \$I3886 VSS VSS NMOS L=1u W=3.4u AS=6.12p AD=6.46p PS=7u PD=7.2u
* device instance $929 m0 *1 34,53.5 NMOS
XM$929 VSS \$I3887 \$I3886 VSS NMOS L=1u W=3.4u AS=6.46p AD=6.12p PS=7.2u PD=7u
* device instance $930 m0 *1 38.6,53.5 NMOS
XM$930 \$I3886 WL1 BLB1 VSS NMOS L=1u W=3.4u AS=6.12p AD=9.52p PS=7u PD=12.4u
* device instance $931 m0 *1 29.2,269.9 PMOS
XM$931 \$I3889 \$I3888 VDD VDD PMOS L=1u W=3.4u AS=10.88p AD=6.46p PS=13.2u
+ PD=7.2u
* device instance $932 m0 *1 34,269.9 PMOS
XM$932 VDD \$I3889 \$I3888 VDD PMOS L=1u W=3.4u AS=6.46p AD=10.88p PS=7.2u
+ PD=13.2u
* device instance $933 m0 *1 24.6,290.3 NMOS
XM$933 BL1 WL9 \$I3889 VSS NMOS L=1u W=3.4u AS=9.52p AD=6.12p PS=12.4u PD=7u
* device instance $934 m0 *1 29.2,290.3 NMOS
XM$934 \$I3889 \$I3888 VSS VSS NMOS L=1u W=3.4u AS=6.12p AD=6.46p PS=7u PD=7.2u
* device instance $935 m0 *1 34,290.3 NMOS
XM$935 VSS \$I3889 \$I3888 VSS NMOS L=1u W=3.4u AS=6.46p AD=6.12p PS=7.2u PD=7u
* device instance $936 m0 *1 38.6,290.3 NMOS
XM$936 \$I3888 WL9 BLB1 VSS NMOS L=1u W=3.4u AS=6.12p AD=9.52p PS=7u PD=12.4u
* device instance $937 m0 *1 29.2,210.7 PMOS
XM$937 \$I3891 \$I3890 VDD VDD PMOS L=1u W=3.4u AS=10.88p AD=6.46p PS=13.2u
+ PD=7.2u
* device instance $938 m0 *1 34,210.7 PMOS
XM$938 VDD \$I3891 \$I3890 VDD PMOS L=1u W=3.4u AS=6.46p AD=10.88p PS=7.2u
+ PD=13.2u
* device instance $939 m0 *1 24.6,231.1 NMOS
XM$939 BL1 WL7 \$I3891 VSS NMOS L=1u W=3.4u AS=9.52p AD=6.12p PS=12.4u PD=7u
* device instance $940 m0 *1 29.2,231.1 NMOS
XM$940 \$I3891 \$I3890 VSS VSS NMOS L=1u W=3.4u AS=6.12p AD=6.46p PS=7u PD=7.2u
* device instance $941 m0 *1 34,231.1 NMOS
XM$941 VSS \$I3891 \$I3890 VSS NMOS L=1u W=3.4u AS=6.46p AD=6.12p PS=7.2u PD=7u
* device instance $942 m0 *1 38.6,231.1 NMOS
XM$942 \$I3890 WL7 BLB1 VSS NMOS L=1u W=3.4u AS=6.12p AD=9.52p PS=7u PD=12.4u
* device instance $943 m0 *1 29.2,151.5 PMOS
XM$943 \$I3893 \$I3892 VDD VDD PMOS L=1u W=3.4u AS=10.88p AD=6.46p PS=13.2u
+ PD=7.2u
* device instance $944 m0 *1 34,151.5 PMOS
XM$944 VDD \$I3893 \$I3892 VDD PMOS L=1u W=3.4u AS=6.46p AD=10.88p PS=7.2u
+ PD=13.2u
* device instance $945 m0 *1 24.6,171.9 NMOS
XM$945 BL1 WL5 \$I3893 VSS NMOS L=1u W=3.4u AS=9.52p AD=6.12p PS=12.4u PD=7u
* device instance $946 m0 *1 29.2,171.9 NMOS
XM$946 \$I3893 \$I3892 VSS VSS NMOS L=1u W=3.4u AS=6.12p AD=6.46p PS=7u PD=7.2u
* device instance $947 m0 *1 34,171.9 NMOS
XM$947 VSS \$I3893 \$I3892 VSS NMOS L=1u W=3.4u AS=6.46p AD=6.12p PS=7.2u PD=7u
* device instance $948 m0 *1 38.6,171.9 NMOS
XM$948 \$I3892 WL5 BLB1 VSS NMOS L=1u W=3.4u AS=6.12p AD=9.52p PS=7u PD=12.4u
* device instance $949 m0 *1 29.2,447.5 PMOS
XM$949 \$I3895 \$I3894 VDD VDD PMOS L=1u W=3.4u AS=10.88p AD=6.46p PS=13.2u
+ PD=7.2u
* device instance $950 m0 *1 34,447.5 PMOS
XM$950 VDD \$I3895 \$I3894 VDD PMOS L=1u W=3.4u AS=6.46p AD=10.88p PS=7.2u
+ PD=13.2u
* device instance $951 m0 *1 24.6,467.9 NMOS
XM$951 BL1 WL15 \$I3895 VSS NMOS L=1u W=3.4u AS=9.52p AD=6.12p PS=12.4u PD=7u
* device instance $952 m0 *1 29.2,467.9 NMOS
XM$952 \$I3895 \$I3894 VSS VSS NMOS L=1u W=3.4u AS=6.12p AD=6.46p PS=7u PD=7.2u
* device instance $953 m0 *1 34,467.9 NMOS
XM$953 VSS \$I3895 \$I3894 VSS NMOS L=1u W=3.4u AS=6.46p AD=6.12p PS=7.2u PD=7u
* device instance $954 m0 *1 38.6,467.9 NMOS
XM$954 \$I3894 WL15 BLB1 VSS NMOS L=1u W=3.4u AS=6.12p AD=9.52p PS=7u PD=12.4u
* device instance $955 m0 *1 29.2,329.1 PMOS
XM$955 \$I3897 \$I3896 VDD VDD PMOS L=1u W=3.4u AS=10.88p AD=6.46p PS=13.2u
+ PD=7.2u
* device instance $956 m0 *1 34,329.1 PMOS
XM$956 VDD \$I3897 \$I3896 VDD PMOS L=1u W=3.4u AS=6.46p AD=10.88p PS=7.2u
+ PD=13.2u
* device instance $957 m0 *1 24.6,349.5 NMOS
XM$957 BL1 WL11 \$I3897 VSS NMOS L=1u W=3.4u AS=9.52p AD=6.12p PS=12.4u PD=7u
* device instance $958 m0 *1 29.2,349.5 NMOS
XM$958 \$I3897 \$I3896 VSS VSS NMOS L=1u W=3.4u AS=6.12p AD=6.46p PS=7u PD=7.2u
* device instance $959 m0 *1 34,349.5 NMOS
XM$959 VSS \$I3897 \$I3896 VSS NMOS L=1u W=3.4u AS=6.46p AD=6.12p PS=7.2u PD=7u
* device instance $960 m0 *1 38.6,349.5 NMOS
XM$960 \$I3896 WL11 BLB1 VSS NMOS L=1u W=3.4u AS=6.12p AD=9.52p PS=7u PD=12.4u
* device instance $961 r0 *1 29.2,440.5 PMOS
XM$961 \$I3899 \$I3898 VDD VDD PMOS L=1u W=3.4u AS=10.88p AD=6.46p PS=13.2u
+ PD=7.2u
* device instance $962 r0 *1 34,440.5 PMOS
XM$962 VDD \$I3899 \$I3898 VDD PMOS L=1u W=3.4u AS=6.46p AD=10.88p PS=7.2u
+ PD=13.2u
* device instance $963 r0 *1 24.6,420.1 NMOS
XM$963 BL1 WL14 \$I3899 VSS NMOS L=1u W=3.4u AS=9.52p AD=6.12p PS=12.4u PD=7u
* device instance $964 r0 *1 29.2,420.1 NMOS
XM$964 \$I3899 \$I3898 VSS VSS NMOS L=1u W=3.4u AS=6.12p AD=6.46p PS=7u PD=7.2u
* device instance $965 r0 *1 34,420.1 NMOS
XM$965 VSS \$I3899 \$I3898 VSS NMOS L=1u W=3.4u AS=6.46p AD=6.12p PS=7.2u PD=7u
* device instance $966 r0 *1 38.6,420.1 NMOS
XM$966 \$I3898 WL14 BLB1 VSS NMOS L=1u W=3.4u AS=6.12p AD=9.52p PS=7u PD=12.4u
* device instance $967 r0 *1 29.2,381.3 PMOS
XM$967 \$I3901 \$I3900 VDD VDD PMOS L=1u W=3.4u AS=10.88p AD=6.46p PS=13.2u
+ PD=7.2u
* device instance $968 r0 *1 34,381.3 PMOS
XM$968 VDD \$I3901 \$I3900 VDD PMOS L=1u W=3.4u AS=6.46p AD=10.88p PS=7.2u
+ PD=13.2u
* device instance $969 r0 *1 24.6,360.9 NMOS
XM$969 BL1 WL12 \$I3901 VSS NMOS L=1u W=3.4u AS=9.52p AD=6.12p PS=12.4u PD=7u
* device instance $970 r0 *1 29.2,360.9 NMOS
XM$970 \$I3901 \$I3900 VSS VSS NMOS L=1u W=3.4u AS=6.12p AD=6.46p PS=7u PD=7.2u
* device instance $971 r0 *1 34,360.9 NMOS
XM$971 VSS \$I3901 \$I3900 VSS NMOS L=1u W=3.4u AS=6.46p AD=6.12p PS=7.2u PD=7u
* device instance $972 r0 *1 38.6,360.9 NMOS
XM$972 \$I3900 WL12 BLB1 VSS NMOS L=1u W=3.4u AS=6.12p AD=9.52p PS=7u PD=12.4u
* device instance $973 r0 *1 29.2,262.9 PMOS
XM$973 \$I3903 \$I3902 VDD VDD PMOS L=1u W=3.4u AS=10.88p AD=6.46p PS=13.2u
+ PD=7.2u
* device instance $974 r0 *1 34,262.9 PMOS
XM$974 VDD \$I3903 \$I3902 VDD PMOS L=1u W=3.4u AS=6.46p AD=10.88p PS=7.2u
+ PD=13.2u
* device instance $975 r0 *1 24.6,242.5 NMOS
XM$975 BL1 WL8 \$I3903 VSS NMOS L=1u W=3.4u AS=9.52p AD=6.12p PS=12.4u PD=7u
* device instance $976 r0 *1 29.2,242.5 NMOS
XM$976 \$I3903 \$I3902 VSS VSS NMOS L=1u W=3.4u AS=6.12p AD=6.46p PS=7u PD=7.2u
* device instance $977 r0 *1 34,242.5 NMOS
XM$977 VSS \$I3903 \$I3902 VSS NMOS L=1u W=3.4u AS=6.46p AD=6.12p PS=7.2u PD=7u
* device instance $978 r0 *1 38.6,242.5 NMOS
XM$978 \$I3902 WL8 BLB1 VSS NMOS L=1u W=3.4u AS=6.12p AD=9.52p PS=7u PD=12.4u
* device instance $979 r0 *1 29.2,322.1 PMOS
XM$979 \$I3905 \$I3904 VDD VDD PMOS L=1u W=3.4u AS=10.88p AD=6.46p PS=13.2u
+ PD=7.2u
* device instance $980 r0 *1 34,322.1 PMOS
XM$980 VDD \$I3905 \$I3904 VDD PMOS L=1u W=3.4u AS=6.46p AD=10.88p PS=7.2u
+ PD=13.2u
* device instance $981 r0 *1 24.6,301.7 NMOS
XM$981 BL1 WL10 \$I3905 VSS NMOS L=1u W=3.4u AS=9.52p AD=6.12p PS=12.4u PD=7u
* device instance $982 r0 *1 29.2,301.7 NMOS
XM$982 \$I3905 \$I3904 VSS VSS NMOS L=1u W=3.4u AS=6.12p AD=6.46p PS=7u PD=7.2u
* device instance $983 r0 *1 34,301.7 NMOS
XM$983 VSS \$I3905 \$I3904 VSS NMOS L=1u W=3.4u AS=6.46p AD=6.12p PS=7.2u PD=7u
* device instance $984 r0 *1 38.6,301.7 NMOS
XM$984 \$I3904 WL10 BLB1 VSS NMOS L=1u W=3.4u AS=6.12p AD=9.52p PS=7u PD=12.4u
* device instance $985 r0 *1 29.2,144.5 PMOS
XM$985 \$I3907 \$I3906 VDD VDD PMOS L=1u W=3.4u AS=10.88p AD=6.46p PS=13.2u
+ PD=7.2u
* device instance $986 r0 *1 34,144.5 PMOS
XM$986 VDD \$I3907 \$I3906 VDD PMOS L=1u W=3.4u AS=6.46p AD=10.88p PS=7.2u
+ PD=13.2u
* device instance $987 r0 *1 24.6,124.1 NMOS
XM$987 BL1 WL4 \$I3907 VSS NMOS L=1u W=3.4u AS=9.52p AD=6.12p PS=12.4u PD=7u
* device instance $988 r0 *1 29.2,124.1 NMOS
XM$988 \$I3907 \$I3906 VSS VSS NMOS L=1u W=3.4u AS=6.12p AD=6.46p PS=7u PD=7.2u
* device instance $989 r0 *1 34,124.1 NMOS
XM$989 VSS \$I3907 \$I3906 VSS NMOS L=1u W=3.4u AS=6.46p AD=6.12p PS=7.2u PD=7u
* device instance $990 r0 *1 38.6,124.1 NMOS
XM$990 \$I3906 WL4 BLB1 VSS NMOS L=1u W=3.4u AS=6.12p AD=9.52p PS=7u PD=12.4u
* device instance $991 r0 *1 29.2,85.3 PMOS
XM$991 \$I3909 \$I3908 VDD VDD PMOS L=1u W=3.4u AS=10.88p AD=6.46p PS=13.2u
+ PD=7.2u
* device instance $992 r0 *1 34,85.3 PMOS
XM$992 VDD \$I3909 \$I3908 VDD PMOS L=1u W=3.4u AS=6.46p AD=10.88p PS=7.2u
+ PD=13.2u
* device instance $993 r0 *1 24.6,64.9 NMOS
XM$993 BL1 WL2 \$I3909 VSS NMOS L=1u W=3.4u AS=9.52p AD=6.12p PS=12.4u PD=7u
* device instance $994 r0 *1 29.2,64.9 NMOS
XM$994 \$I3909 \$I3908 VSS VSS NMOS L=1u W=3.4u AS=6.12p AD=6.46p PS=7u PD=7.2u
* device instance $995 r0 *1 34,64.9 NMOS
XM$995 VSS \$I3909 \$I3908 VSS NMOS L=1u W=3.4u AS=6.46p AD=6.12p PS=7.2u PD=7u
* device instance $996 r0 *1 38.6,64.9 NMOS
XM$996 \$I3908 WL2 BLB1 VSS NMOS L=1u W=3.4u AS=6.12p AD=9.52p PS=7u PD=12.4u
* device instance $997 r0 *1 29.2,203.7 PMOS
XM$997 \$I3911 \$I3910 VDD VDD PMOS L=1u W=3.4u AS=10.88p AD=6.46p PS=13.2u
+ PD=7.2u
* device instance $998 r0 *1 34,203.7 PMOS
XM$998 VDD \$I3911 \$I3910 VDD PMOS L=1u W=3.4u AS=6.46p AD=10.88p PS=7.2u
+ PD=13.2u
* device instance $999 r0 *1 24.6,183.3 NMOS
XM$999 BL1 WL6 \$I3911 VSS NMOS L=1u W=3.4u AS=9.52p AD=6.12p PS=12.4u PD=7u
* device instance $1000 r0 *1 29.2,183.3 NMOS
XM$1000 \$I3911 \$I3910 VSS VSS NMOS L=1u W=3.4u AS=6.12p AD=6.46p PS=7u PD=7.2u
* device instance $1001 r0 *1 34,183.3 NMOS
XM$1001 VSS \$I3911 \$I3910 VSS NMOS L=1u W=3.4u AS=6.46p AD=6.12p PS=7.2u PD=7u
* device instance $1002 r0 *1 38.6,183.3 NMOS
XM$1002 \$I3910 WL6 BLB1 VSS NMOS L=1u W=3.4u AS=6.12p AD=9.52p PS=7u PD=12.4u
* device instance $1003 m0 *1 7.2,92.3 PMOS
XM$1003 \$I3913 \$I3912 VDD VDD PMOS L=1u W=3.4u AS=10.88p AD=6.46p PS=13.2u
+ PD=7.2u
* device instance $1004 m0 *1 12,92.3 PMOS
XM$1004 VDD \$I3913 \$I3912 VDD PMOS L=1u W=3.4u AS=6.46p AD=10.88p PS=7.2u
+ PD=13.2u
* device instance $1005 m0 *1 2.6,112.7 NMOS
XM$1005 BL0 WL3 \$I3913 VSS NMOS L=1u W=3.4u AS=9.52p AD=6.12p PS=12.4u PD=7u
* device instance $1006 m0 *1 7.2,112.7 NMOS
XM$1006 \$I3913 \$I3912 VSS VSS NMOS L=1u W=3.4u AS=6.12p AD=6.46p PS=7u PD=7.2u
* device instance $1007 m0 *1 12,112.7 NMOS
XM$1007 VSS \$I3913 \$I3912 VSS NMOS L=1u W=3.4u AS=6.46p AD=6.12p PS=7.2u PD=7u
* device instance $1008 m0 *1 16.6,112.7 NMOS
XM$1008 \$I3912 WL3 BLB0 VSS NMOS L=1u W=3.4u AS=6.12p AD=9.52p PS=7u PD=12.4u
* device instance $1009 m0 *1 7.2,269.9 PMOS
XM$1009 \$I3915 \$I3914 VDD VDD PMOS L=1u W=3.4u AS=10.88p AD=6.46p PS=13.2u
+ PD=7.2u
* device instance $1010 m0 *1 12,269.9 PMOS
XM$1010 VDD \$I3915 \$I3914 VDD PMOS L=1u W=3.4u AS=6.46p AD=10.88p PS=7.2u
+ PD=13.2u
* device instance $1011 m0 *1 2.6,290.3 NMOS
XM$1011 BL0 WL9 \$I3915 VSS NMOS L=1u W=3.4u AS=9.52p AD=6.12p PS=12.4u PD=7u
* device instance $1012 m0 *1 7.2,290.3 NMOS
XM$1012 \$I3915 \$I3914 VSS VSS NMOS L=1u W=3.4u AS=6.12p AD=6.46p PS=7u PD=7.2u
* device instance $1013 m0 *1 12,290.3 NMOS
XM$1013 VSS \$I3915 \$I3914 VSS NMOS L=1u W=3.4u AS=6.46p AD=6.12p PS=7.2u PD=7u
* device instance $1014 m0 *1 16.6,290.3 NMOS
XM$1014 \$I3914 WL9 BLB0 VSS NMOS L=1u W=3.4u AS=6.12p AD=9.52p PS=7u PD=12.4u
* device instance $1015 m0 *1 7.2,210.7 PMOS
XM$1015 \$I3917 \$I3916 VDD VDD PMOS L=1u W=3.4u AS=10.88p AD=6.46p PS=13.2u
+ PD=7.2u
* device instance $1016 m0 *1 12,210.7 PMOS
XM$1016 VDD \$I3917 \$I3916 VDD PMOS L=1u W=3.4u AS=6.46p AD=10.88p PS=7.2u
+ PD=13.2u
* device instance $1017 m0 *1 2.6,231.1 NMOS
XM$1017 BL0 WL7 \$I3917 VSS NMOS L=1u W=3.4u AS=9.52p AD=6.12p PS=12.4u PD=7u
* device instance $1018 m0 *1 7.2,231.1 NMOS
XM$1018 \$I3917 \$I3916 VSS VSS NMOS L=1u W=3.4u AS=6.12p AD=6.46p PS=7u PD=7.2u
* device instance $1019 m0 *1 12,231.1 NMOS
XM$1019 VSS \$I3917 \$I3916 VSS NMOS L=1u W=3.4u AS=6.46p AD=6.12p PS=7.2u PD=7u
* device instance $1020 m0 *1 16.6,231.1 NMOS
XM$1020 \$I3916 WL7 BLB0 VSS NMOS L=1u W=3.4u AS=6.12p AD=9.52p PS=7u PD=12.4u
* device instance $1021 m0 *1 7.2,151.5 PMOS
XM$1021 \$I3919 \$I3918 VDD VDD PMOS L=1u W=3.4u AS=10.88p AD=6.46p PS=13.2u
+ PD=7.2u
* device instance $1022 m0 *1 12,151.5 PMOS
XM$1022 VDD \$I3919 \$I3918 VDD PMOS L=1u W=3.4u AS=6.46p AD=10.88p PS=7.2u
+ PD=13.2u
* device instance $1023 m0 *1 2.6,171.9 NMOS
XM$1023 BL0 WL5 \$I3919 VSS NMOS L=1u W=3.4u AS=9.52p AD=6.12p PS=12.4u PD=7u
* device instance $1024 m0 *1 7.2,171.9 NMOS
XM$1024 \$I3919 \$I3918 VSS VSS NMOS L=1u W=3.4u AS=6.12p AD=6.46p PS=7u PD=7.2u
* device instance $1025 m0 *1 12,171.9 NMOS
XM$1025 VSS \$I3919 \$I3918 VSS NMOS L=1u W=3.4u AS=6.46p AD=6.12p PS=7.2u PD=7u
* device instance $1026 m0 *1 16.6,171.9 NMOS
XM$1026 \$I3918 WL5 BLB0 VSS NMOS L=1u W=3.4u AS=6.12p AD=9.52p PS=7u PD=12.4u
* device instance $1027 m0 *1 7.2,388.3 PMOS
XM$1027 \$I3921 \$I3920 VDD VDD PMOS L=1u W=3.4u AS=10.88p AD=6.46p PS=13.2u
+ PD=7.2u
* device instance $1028 m0 *1 12,388.3 PMOS
XM$1028 VDD \$I3921 \$I3920 VDD PMOS L=1u W=3.4u AS=6.46p AD=10.88p PS=7.2u
+ PD=13.2u
* device instance $1029 m0 *1 2.6,408.7 NMOS
XM$1029 BL0 WL13 \$I3921 VSS NMOS L=1u W=3.4u AS=9.52p AD=6.12p PS=12.4u PD=7u
* device instance $1030 m0 *1 7.2,408.7 NMOS
XM$1030 \$I3921 \$I3920 VSS VSS NMOS L=1u W=3.4u AS=6.12p AD=6.46p PS=7u PD=7.2u
* device instance $1031 m0 *1 12,408.7 NMOS
XM$1031 VSS \$I3921 \$I3920 VSS NMOS L=1u W=3.4u AS=6.46p AD=6.12p PS=7.2u PD=7u
* device instance $1032 m0 *1 16.6,408.7 NMOS
XM$1032 \$I3920 WL13 BLB0 VSS NMOS L=1u W=3.4u AS=6.12p AD=9.52p PS=7u PD=12.4u
* device instance $1033 m0 *1 7.2,329.1 PMOS
XM$1033 \$I3923 \$I3922 VDD VDD PMOS L=1u W=3.4u AS=10.88p AD=6.46p PS=13.2u
+ PD=7.2u
* device instance $1034 m0 *1 12,329.1 PMOS
XM$1034 VDD \$I3923 \$I3922 VDD PMOS L=1u W=3.4u AS=6.46p AD=10.88p PS=7.2u
+ PD=13.2u
* device instance $1035 m0 *1 2.6,349.5 NMOS
XM$1035 BL0 WL11 \$I3923 VSS NMOS L=1u W=3.4u AS=9.52p AD=6.12p PS=12.4u PD=7u
* device instance $1036 m0 *1 7.2,349.5 NMOS
XM$1036 \$I3923 \$I3922 VSS VSS NMOS L=1u W=3.4u AS=6.12p AD=6.46p PS=7u PD=7.2u
* device instance $1037 m0 *1 12,349.5 NMOS
XM$1037 VSS \$I3923 \$I3922 VSS NMOS L=1u W=3.4u AS=6.46p AD=6.12p PS=7.2u PD=7u
* device instance $1038 m0 *1 16.6,349.5 NMOS
XM$1038 \$I3922 WL11 BLB0 VSS NMOS L=1u W=3.4u AS=6.12p AD=9.52p PS=7u PD=12.4u
* device instance $1039 m0 *1 7.2,447.5 PMOS
XM$1039 \$I3925 \$I3924 VDD VDD PMOS L=1u W=3.4u AS=10.88p AD=6.46p PS=13.2u
+ PD=7.2u
* device instance $1040 m0 *1 12,447.5 PMOS
XM$1040 VDD \$I3925 \$I3924 VDD PMOS L=1u W=3.4u AS=6.46p AD=10.88p PS=7.2u
+ PD=13.2u
* device instance $1041 m0 *1 2.6,467.9 NMOS
XM$1041 BL0 WL15 \$I3925 VSS NMOS L=1u W=3.4u AS=9.52p AD=6.12p PS=12.4u PD=7u
* device instance $1042 m0 *1 7.2,467.9 NMOS
XM$1042 \$I3925 \$I3924 VSS VSS NMOS L=1u W=3.4u AS=6.12p AD=6.46p PS=7u PD=7.2u
* device instance $1043 m0 *1 12,467.9 NMOS
XM$1043 VSS \$I3925 \$I3924 VSS NMOS L=1u W=3.4u AS=6.46p AD=6.12p PS=7.2u PD=7u
* device instance $1044 m0 *1 16.6,467.9 NMOS
XM$1044 \$I3924 WL15 BLB0 VSS NMOS L=1u W=3.4u AS=6.12p AD=9.52p PS=7u PD=12.4u
* device instance $1045 r0 *1 7.2,440.5 PMOS
XM$1045 \$I3927 \$I3926 VDD VDD PMOS L=1u W=3.4u AS=10.88p AD=6.46p PS=13.2u
+ PD=7.2u
* device instance $1046 r0 *1 12,440.5 PMOS
XM$1046 VDD \$I3927 \$I3926 VDD PMOS L=1u W=3.4u AS=6.46p AD=10.88p PS=7.2u
+ PD=13.2u
* device instance $1047 r0 *1 2.6,420.1 NMOS
XM$1047 BL0 WL14 \$I3927 VSS NMOS L=1u W=3.4u AS=9.52p AD=6.12p PS=12.4u PD=7u
* device instance $1048 r0 *1 7.2,420.1 NMOS
XM$1048 \$I3927 \$I3926 VSS VSS NMOS L=1u W=3.4u AS=6.12p AD=6.46p PS=7u PD=7.2u
* device instance $1049 r0 *1 12,420.1 NMOS
XM$1049 VSS \$I3927 \$I3926 VSS NMOS L=1u W=3.4u AS=6.46p AD=6.12p PS=7.2u PD=7u
* device instance $1050 r0 *1 16.6,420.1 NMOS
XM$1050 \$I3926 WL14 BLB0 VSS NMOS L=1u W=3.4u AS=6.12p AD=9.52p PS=7u PD=12.4u
* device instance $1051 r0 *1 7.2,381.3 PMOS
XM$1051 \$I3929 \$I3928 VDD VDD PMOS L=1u W=3.4u AS=10.88p AD=6.46p PS=13.2u
+ PD=7.2u
* device instance $1052 r0 *1 12,381.3 PMOS
XM$1052 VDD \$I3929 \$I3928 VDD PMOS L=1u W=3.4u AS=6.46p AD=10.88p PS=7.2u
+ PD=13.2u
* device instance $1053 r0 *1 2.6,360.9 NMOS
XM$1053 BL0 WL12 \$I3929 VSS NMOS L=1u W=3.4u AS=9.52p AD=6.12p PS=12.4u PD=7u
* device instance $1054 r0 *1 7.2,360.9 NMOS
XM$1054 \$I3929 \$I3928 VSS VSS NMOS L=1u W=3.4u AS=6.12p AD=6.46p PS=7u PD=7.2u
* device instance $1055 r0 *1 12,360.9 NMOS
XM$1055 VSS \$I3929 \$I3928 VSS NMOS L=1u W=3.4u AS=6.46p AD=6.12p PS=7.2u PD=7u
* device instance $1056 r0 *1 16.6,360.9 NMOS
XM$1056 \$I3928 WL12 BLB0 VSS NMOS L=1u W=3.4u AS=6.12p AD=9.52p PS=7u PD=12.4u
* device instance $1057 r0 *1 7.2,322.1 PMOS
XM$1057 \$I3931 \$I3930 VDD VDD PMOS L=1u W=3.4u AS=10.88p AD=6.46p PS=13.2u
+ PD=7.2u
* device instance $1058 r0 *1 12,322.1 PMOS
XM$1058 VDD \$I3931 \$I3930 VDD PMOS L=1u W=3.4u AS=6.46p AD=10.88p PS=7.2u
+ PD=13.2u
* device instance $1059 r0 *1 2.6,301.7 NMOS
XM$1059 BL0 WL10 \$I3931 VSS NMOS L=1u W=3.4u AS=9.52p AD=6.12p PS=12.4u PD=7u
* device instance $1060 r0 *1 7.2,301.7 NMOS
XM$1060 \$I3931 \$I3930 VSS VSS NMOS L=1u W=3.4u AS=6.12p AD=6.46p PS=7u PD=7.2u
* device instance $1061 r0 *1 12,301.7 NMOS
XM$1061 VSS \$I3931 \$I3930 VSS NMOS L=1u W=3.4u AS=6.46p AD=6.12p PS=7.2u PD=7u
* device instance $1062 r0 *1 16.6,301.7 NMOS
XM$1062 \$I3930 WL10 BLB0 VSS NMOS L=1u W=3.4u AS=6.12p AD=9.52p PS=7u PD=12.4u
* device instance $1063 r0 *1 7.2,262.9 PMOS
XM$1063 \$I3933 \$I3932 VDD VDD PMOS L=1u W=3.4u AS=10.88p AD=6.46p PS=13.2u
+ PD=7.2u
* device instance $1064 r0 *1 12,262.9 PMOS
XM$1064 VDD \$I3933 \$I3932 VDD PMOS L=1u W=3.4u AS=6.46p AD=10.88p PS=7.2u
+ PD=13.2u
* device instance $1065 r0 *1 2.6,242.5 NMOS
XM$1065 BL0 WL8 \$I3933 VSS NMOS L=1u W=3.4u AS=9.52p AD=6.12p PS=12.4u PD=7u
* device instance $1066 r0 *1 7.2,242.5 NMOS
XM$1066 \$I3933 \$I3932 VSS VSS NMOS L=1u W=3.4u AS=6.12p AD=6.46p PS=7u PD=7.2u
* device instance $1067 r0 *1 12,242.5 NMOS
XM$1067 VSS \$I3933 \$I3932 VSS NMOS L=1u W=3.4u AS=6.46p AD=6.12p PS=7.2u PD=7u
* device instance $1068 r0 *1 16.6,242.5 NMOS
XM$1068 \$I3932 WL8 BLB0 VSS NMOS L=1u W=3.4u AS=6.12p AD=9.52p PS=7u PD=12.4u
* device instance $1069 r0 *1 7.2,144.5 PMOS
XM$1069 \$I3935 \$I3934 VDD VDD PMOS L=1u W=3.4u AS=10.88p AD=6.46p PS=13.2u
+ PD=7.2u
* device instance $1070 r0 *1 12,144.5 PMOS
XM$1070 VDD \$I3935 \$I3934 VDD PMOS L=1u W=3.4u AS=6.46p AD=10.88p PS=7.2u
+ PD=13.2u
* device instance $1071 r0 *1 2.6,124.1 NMOS
XM$1071 BL0 WL4 \$I3935 VSS NMOS L=1u W=3.4u AS=9.52p AD=6.12p PS=12.4u PD=7u
* device instance $1072 r0 *1 7.2,124.1 NMOS
XM$1072 \$I3935 \$I3934 VSS VSS NMOS L=1u W=3.4u AS=6.12p AD=6.46p PS=7u PD=7.2u
* device instance $1073 r0 *1 12,124.1 NMOS
XM$1073 VSS \$I3935 \$I3934 VSS NMOS L=1u W=3.4u AS=6.46p AD=6.12p PS=7.2u PD=7u
* device instance $1074 r0 *1 16.6,124.1 NMOS
XM$1074 \$I3934 WL4 BLB0 VSS NMOS L=1u W=3.4u AS=6.12p AD=9.52p PS=7u PD=12.4u
* device instance $1075 m0 *1 7.2,33.1 PMOS
XM$1075 \$I3937 \$I3936 VDD VDD PMOS L=1u W=3.4u AS=10.88p AD=6.46p PS=13.2u
+ PD=7.2u
* device instance $1076 m0 *1 12,33.1 PMOS
XM$1076 VDD \$I3937 \$I3936 VDD PMOS L=1u W=3.4u AS=6.46p AD=10.88p PS=7.2u
+ PD=13.2u
* device instance $1077 m0 *1 2.6,53.5 NMOS
XM$1077 BL0 WL1 \$I3937 VSS NMOS L=1u W=3.4u AS=9.52p AD=6.12p PS=12.4u PD=7u
* device instance $1078 m0 *1 7.2,53.5 NMOS
XM$1078 \$I3937 \$I3936 VSS VSS NMOS L=1u W=3.4u AS=6.12p AD=6.46p PS=7u PD=7.2u
* device instance $1079 m0 *1 12,53.5 NMOS
XM$1079 VSS \$I3937 \$I3936 VSS NMOS L=1u W=3.4u AS=6.46p AD=6.12p PS=7.2u PD=7u
* device instance $1080 m0 *1 16.6,53.5 NMOS
XM$1080 \$I3936 WL1 BLB0 VSS NMOS L=1u W=3.4u AS=6.12p AD=9.52p PS=7u PD=12.4u
* device instance $1081 r0 *1 7.2,85.3 PMOS
XM$1081 \$I3939 \$I3938 VDD VDD PMOS L=1u W=3.4u AS=10.88p AD=6.46p PS=13.2u
+ PD=7.2u
* device instance $1082 r0 *1 12,85.3 PMOS
XM$1082 VDD \$I3939 \$I3938 VDD PMOS L=1u W=3.4u AS=6.46p AD=10.88p PS=7.2u
+ PD=13.2u
* device instance $1083 r0 *1 2.6,64.9 NMOS
XM$1083 BL0 WL2 \$I3939 VSS NMOS L=1u W=3.4u AS=9.52p AD=6.12p PS=12.4u PD=7u
* device instance $1084 r0 *1 7.2,64.9 NMOS
XM$1084 \$I3939 \$I3938 VSS VSS NMOS L=1u W=3.4u AS=6.12p AD=6.46p PS=7u PD=7.2u
* device instance $1085 r0 *1 12,64.9 NMOS
XM$1085 VSS \$I3939 \$I3938 VSS NMOS L=1u W=3.4u AS=6.46p AD=6.12p PS=7.2u PD=7u
* device instance $1086 r0 *1 16.6,64.9 NMOS
XM$1086 \$I3938 WL2 BLB0 VSS NMOS L=1u W=3.4u AS=6.12p AD=9.52p PS=7u PD=12.4u
* device instance $1087 r0 *1 7.2,203.7 PMOS
XM$1087 \$I3941 \$I3940 VDD VDD PMOS L=1u W=3.4u AS=10.88p AD=6.46p PS=13.2u
+ PD=7.2u
* device instance $1088 r0 *1 12,203.7 PMOS
XM$1088 VDD \$I3941 \$I3940 VDD PMOS L=1u W=3.4u AS=6.46p AD=10.88p PS=7.2u
+ PD=13.2u
* device instance $1089 r0 *1 2.6,183.3 NMOS
XM$1089 BL0 WL6 \$I3941 VSS NMOS L=1u W=3.4u AS=9.52p AD=6.12p PS=12.4u PD=7u
* device instance $1090 r0 *1 7.2,183.3 NMOS
XM$1090 \$I3941 \$I3940 VSS VSS NMOS L=1u W=3.4u AS=6.12p AD=6.46p PS=7u PD=7.2u
* device instance $1091 r0 *1 12,183.3 NMOS
XM$1091 VSS \$I3941 \$I3940 VSS NMOS L=1u W=3.4u AS=6.46p AD=6.12p PS=7.2u PD=7u
* device instance $1092 r0 *1 16.6,183.3 NMOS
XM$1092 \$I3940 WL6 BLB0 VSS NMOS L=1u W=3.4u AS=6.12p AD=9.52p PS=7u PD=12.4u
* device instance $1093 m0 *1 117.2,269.9 PMOS
XM$1093 \$I3943 \$I3942 VDD VDD PMOS L=1u W=3.4u AS=10.88p AD=6.46p PS=13.2u
+ PD=7.2u
* device instance $1094 m0 *1 122,269.9 PMOS
XM$1094 VDD \$I3943 \$I3942 VDD PMOS L=1u W=3.4u AS=6.46p AD=10.88p PS=7.2u
+ PD=13.2u
* device instance $1095 m0 *1 112.6,290.3 NMOS
XM$1095 BL5 WL9 \$I3943 VSS NMOS L=1u W=3.4u AS=9.52p AD=6.12p PS=12.4u PD=7u
* device instance $1096 m0 *1 117.2,290.3 NMOS
XM$1096 \$I3943 \$I3942 VSS VSS NMOS L=1u W=3.4u AS=6.12p AD=6.46p PS=7u PD=7.2u
* device instance $1097 m0 *1 122,290.3 NMOS
XM$1097 VSS \$I3943 \$I3942 VSS NMOS L=1u W=3.4u AS=6.46p AD=6.12p PS=7.2u PD=7u
* device instance $1098 m0 *1 126.6,290.3 NMOS
XM$1098 \$I3942 WL9 BLB5 VSS NMOS L=1u W=3.4u AS=6.12p AD=9.52p PS=7u PD=12.4u
* device instance $1099 m0 *1 117.2,33.1 PMOS
XM$1099 \$I3945 \$I3944 VDD VDD PMOS L=1u W=3.4u AS=10.88p AD=6.46p PS=13.2u
+ PD=7.2u
* device instance $1100 m0 *1 122,33.1 PMOS
XM$1100 VDD \$I3945 \$I3944 VDD PMOS L=1u W=3.4u AS=6.46p AD=10.88p PS=7.2u
+ PD=13.2u
* device instance $1101 m0 *1 112.6,53.5 NMOS
XM$1101 BL5 WL1 \$I3945 VSS NMOS L=1u W=3.4u AS=9.52p AD=6.12p PS=12.4u PD=7u
* device instance $1102 m0 *1 117.2,53.5 NMOS
XM$1102 \$I3945 \$I3944 VSS VSS NMOS L=1u W=3.4u AS=6.12p AD=6.46p PS=7u PD=7.2u
* device instance $1103 m0 *1 122,53.5 NMOS
XM$1103 VSS \$I3945 \$I3944 VSS NMOS L=1u W=3.4u AS=6.46p AD=6.12p PS=7.2u PD=7u
* device instance $1104 m0 *1 126.6,53.5 NMOS
XM$1104 \$I3944 WL1 BLB5 VSS NMOS L=1u W=3.4u AS=6.12p AD=9.52p PS=7u PD=12.4u
* device instance $1105 m0 *1 117.2,210.7 PMOS
XM$1105 \$I3947 \$I3946 VDD VDD PMOS L=1u W=3.4u AS=10.88p AD=6.46p PS=13.2u
+ PD=7.2u
* device instance $1106 m0 *1 122,210.7 PMOS
XM$1106 VDD \$I3947 \$I3946 VDD PMOS L=1u W=3.4u AS=6.46p AD=10.88p PS=7.2u
+ PD=13.2u
* device instance $1107 m0 *1 112.6,231.1 NMOS
XM$1107 BL5 WL7 \$I3947 VSS NMOS L=1u W=3.4u AS=9.52p AD=6.12p PS=12.4u PD=7u
* device instance $1108 m0 *1 117.2,231.1 NMOS
XM$1108 \$I3947 \$I3946 VSS VSS NMOS L=1u W=3.4u AS=6.12p AD=6.46p PS=7u PD=7.2u
* device instance $1109 m0 *1 122,231.1 NMOS
XM$1109 VSS \$I3947 \$I3946 VSS NMOS L=1u W=3.4u AS=6.46p AD=6.12p PS=7.2u PD=7u
* device instance $1110 m0 *1 126.6,231.1 NMOS
XM$1110 \$I3946 WL7 BLB5 VSS NMOS L=1u W=3.4u AS=6.12p AD=9.52p PS=7u PD=12.4u
* device instance $1111 m0 *1 117.2,92.3 PMOS
XM$1111 \$I3949 \$I3948 VDD VDD PMOS L=1u W=3.4u AS=10.88p AD=6.46p PS=13.2u
+ PD=7.2u
* device instance $1112 m0 *1 122,92.3 PMOS
XM$1112 VDD \$I3949 \$I3948 VDD PMOS L=1u W=3.4u AS=6.46p AD=10.88p PS=7.2u
+ PD=13.2u
* device instance $1113 m0 *1 112.6,112.7 NMOS
XM$1113 BL5 WL3 \$I3949 VSS NMOS L=1u W=3.4u AS=9.52p AD=6.12p PS=12.4u PD=7u
* device instance $1114 m0 *1 117.2,112.7 NMOS
XM$1114 \$I3949 \$I3948 VSS VSS NMOS L=1u W=3.4u AS=6.12p AD=6.46p PS=7u PD=7.2u
* device instance $1115 m0 *1 122,112.7 NMOS
XM$1115 VSS \$I3949 \$I3948 VSS NMOS L=1u W=3.4u AS=6.46p AD=6.12p PS=7.2u PD=7u
* device instance $1116 m0 *1 126.6,112.7 NMOS
XM$1116 \$I3948 WL3 BLB5 VSS NMOS L=1u W=3.4u AS=6.12p AD=9.52p PS=7u PD=12.4u
* device instance $1117 m0 *1 117.2,151.5 PMOS
XM$1117 \$I3951 \$I3950 VDD VDD PMOS L=1u W=3.4u AS=10.88p AD=6.46p PS=13.2u
+ PD=7.2u
* device instance $1118 m0 *1 122,151.5 PMOS
XM$1118 VDD \$I3951 \$I3950 VDD PMOS L=1u W=3.4u AS=6.46p AD=10.88p PS=7.2u
+ PD=13.2u
* device instance $1119 m0 *1 112.6,171.9 NMOS
XM$1119 BL5 WL5 \$I3951 VSS NMOS L=1u W=3.4u AS=9.52p AD=6.12p PS=12.4u PD=7u
* device instance $1120 m0 *1 117.2,171.9 NMOS
XM$1120 \$I3951 \$I3950 VSS VSS NMOS L=1u W=3.4u AS=6.12p AD=6.46p PS=7u PD=7.2u
* device instance $1121 m0 *1 122,171.9 NMOS
XM$1121 VSS \$I3951 \$I3950 VSS NMOS L=1u W=3.4u AS=6.46p AD=6.12p PS=7.2u PD=7u
* device instance $1122 m0 *1 126.6,171.9 NMOS
XM$1122 \$I3950 WL5 BLB5 VSS NMOS L=1u W=3.4u AS=6.12p AD=9.52p PS=7u PD=12.4u
* device instance $1123 m0 *1 117.2,447.5 PMOS
XM$1123 \$I3953 \$I3952 VDD VDD PMOS L=1u W=3.4u AS=10.88p AD=6.46p PS=13.2u
+ PD=7.2u
* device instance $1124 m0 *1 122,447.5 PMOS
XM$1124 VDD \$I3953 \$I3952 VDD PMOS L=1u W=3.4u AS=6.46p AD=10.88p PS=7.2u
+ PD=13.2u
* device instance $1125 m0 *1 112.6,467.9 NMOS
XM$1125 BL5 WL15 \$I3953 VSS NMOS L=1u W=3.4u AS=9.52p AD=6.12p PS=12.4u PD=7u
* device instance $1126 m0 *1 117.2,467.9 NMOS
XM$1126 \$I3953 \$I3952 VSS VSS NMOS L=1u W=3.4u AS=6.12p AD=6.46p PS=7u PD=7.2u
* device instance $1127 m0 *1 122,467.9 NMOS
XM$1127 VSS \$I3953 \$I3952 VSS NMOS L=1u W=3.4u AS=6.46p AD=6.12p PS=7.2u PD=7u
* device instance $1128 m0 *1 126.6,467.9 NMOS
XM$1128 \$I3952 WL15 BLB5 VSS NMOS L=1u W=3.4u AS=6.12p AD=9.52p PS=7u PD=12.4u
* device instance $1129 m0 *1 117.2,388.3 PMOS
XM$1129 \$I3955 \$I3954 VDD VDD PMOS L=1u W=3.4u AS=10.88p AD=6.46p PS=13.2u
+ PD=7.2u
* device instance $1130 m0 *1 122,388.3 PMOS
XM$1130 VDD \$I3955 \$I3954 VDD PMOS L=1u W=3.4u AS=6.46p AD=10.88p PS=7.2u
+ PD=13.2u
* device instance $1131 m0 *1 112.6,408.7 NMOS
XM$1131 BL5 WL13 \$I3955 VSS NMOS L=1u W=3.4u AS=9.52p AD=6.12p PS=12.4u PD=7u
* device instance $1132 m0 *1 117.2,408.7 NMOS
XM$1132 \$I3955 \$I3954 VSS VSS NMOS L=1u W=3.4u AS=6.12p AD=6.46p PS=7u PD=7.2u
* device instance $1133 m0 *1 122,408.7 NMOS
XM$1133 VSS \$I3955 \$I3954 VSS NMOS L=1u W=3.4u AS=6.46p AD=6.12p PS=7.2u PD=7u
* device instance $1134 m0 *1 126.6,408.7 NMOS
XM$1134 \$I3954 WL13 BLB5 VSS NMOS L=1u W=3.4u AS=6.12p AD=9.52p PS=7u PD=12.4u
* device instance $1135 m0 *1 117.2,329.1 PMOS
XM$1135 \$I3957 \$I3956 VDD VDD PMOS L=1u W=3.4u AS=10.88p AD=6.46p PS=13.2u
+ PD=7.2u
* device instance $1136 m0 *1 122,329.1 PMOS
XM$1136 VDD \$I3957 \$I3956 VDD PMOS L=1u W=3.4u AS=6.46p AD=10.88p PS=7.2u
+ PD=13.2u
* device instance $1137 m0 *1 112.6,349.5 NMOS
XM$1137 BL5 WL11 \$I3957 VSS NMOS L=1u W=3.4u AS=9.52p AD=6.12p PS=12.4u PD=7u
* device instance $1138 m0 *1 117.2,349.5 NMOS
XM$1138 \$I3957 \$I3956 VSS VSS NMOS L=1u W=3.4u AS=6.12p AD=6.46p PS=7u PD=7.2u
* device instance $1139 m0 *1 122,349.5 NMOS
XM$1139 VSS \$I3957 \$I3956 VSS NMOS L=1u W=3.4u AS=6.46p AD=6.12p PS=7.2u PD=7u
* device instance $1140 m0 *1 126.6,349.5 NMOS
XM$1140 \$I3956 WL11 BLB5 VSS NMOS L=1u W=3.4u AS=6.12p AD=9.52p PS=7u PD=12.4u
* device instance $1141 r0 *1 117.2,440.5 PMOS
XM$1141 \$I3959 \$I3958 VDD VDD PMOS L=1u W=3.4u AS=10.88p AD=6.46p PS=13.2u
+ PD=7.2u
* device instance $1142 r0 *1 122,440.5 PMOS
XM$1142 VDD \$I3959 \$I3958 VDD PMOS L=1u W=3.4u AS=6.46p AD=10.88p PS=7.2u
+ PD=13.2u
* device instance $1143 r0 *1 112.6,420.1 NMOS
XM$1143 BL5 WL14 \$I3959 VSS NMOS L=1u W=3.4u AS=9.52p AD=6.12p PS=12.4u PD=7u
* device instance $1144 r0 *1 117.2,420.1 NMOS
XM$1144 \$I3959 \$I3958 VSS VSS NMOS L=1u W=3.4u AS=6.12p AD=6.46p PS=7u PD=7.2u
* device instance $1145 r0 *1 122,420.1 NMOS
XM$1145 VSS \$I3959 \$I3958 VSS NMOS L=1u W=3.4u AS=6.46p AD=6.12p PS=7.2u PD=7u
* device instance $1146 r0 *1 126.6,420.1 NMOS
XM$1146 \$I3958 WL14 BLB5 VSS NMOS L=1u W=3.4u AS=6.12p AD=9.52p PS=7u PD=12.4u
* device instance $1147 r0 *1 117.2,85.3 PMOS
XM$1147 \$I3961 \$I3960 VDD VDD PMOS L=1u W=3.4u AS=10.88p AD=6.46p PS=13.2u
+ PD=7.2u
* device instance $1148 r0 *1 122,85.3 PMOS
XM$1148 VDD \$I3961 \$I3960 VDD PMOS L=1u W=3.4u AS=6.46p AD=10.88p PS=7.2u
+ PD=13.2u
* device instance $1149 r0 *1 112.6,64.9 NMOS
XM$1149 BL5 WL2 \$I3961 VSS NMOS L=1u W=3.4u AS=9.52p AD=6.12p PS=12.4u PD=7u
* device instance $1150 r0 *1 117.2,64.9 NMOS
XM$1150 \$I3961 \$I3960 VSS VSS NMOS L=1u W=3.4u AS=6.12p AD=6.46p PS=7u PD=7.2u
* device instance $1151 r0 *1 122,64.9 NMOS
XM$1151 VSS \$I3961 \$I3960 VSS NMOS L=1u W=3.4u AS=6.46p AD=6.12p PS=7.2u PD=7u
* device instance $1152 r0 *1 126.6,64.9 NMOS
XM$1152 \$I3960 WL2 BLB5 VSS NMOS L=1u W=3.4u AS=6.12p AD=9.52p PS=7u PD=12.4u
* device instance $1153 r0 *1 117.2,262.9 PMOS
XM$1153 \$I3963 \$I3962 VDD VDD PMOS L=1u W=3.4u AS=10.88p AD=6.46p PS=13.2u
+ PD=7.2u
* device instance $1154 r0 *1 122,262.9 PMOS
XM$1154 VDD \$I3963 \$I3962 VDD PMOS L=1u W=3.4u AS=6.46p AD=10.88p PS=7.2u
+ PD=13.2u
* device instance $1155 r0 *1 112.6,242.5 NMOS
XM$1155 BL5 WL8 \$I3963 VSS NMOS L=1u W=3.4u AS=9.52p AD=6.12p PS=12.4u PD=7u
* device instance $1156 r0 *1 117.2,242.5 NMOS
XM$1156 \$I3963 \$I3962 VSS VSS NMOS L=1u W=3.4u AS=6.12p AD=6.46p PS=7u PD=7.2u
* device instance $1157 r0 *1 122,242.5 NMOS
XM$1157 VSS \$I3963 \$I3962 VSS NMOS L=1u W=3.4u AS=6.46p AD=6.12p PS=7.2u PD=7u
* device instance $1158 r0 *1 126.6,242.5 NMOS
XM$1158 \$I3962 WL8 BLB5 VSS NMOS L=1u W=3.4u AS=6.12p AD=9.52p PS=7u PD=12.4u
* device instance $1159 r0 *1 117.2,381.3 PMOS
XM$1159 \$I3965 \$I3964 VDD VDD PMOS L=1u W=3.4u AS=10.88p AD=6.46p PS=13.2u
+ PD=7.2u
* device instance $1160 r0 *1 122,381.3 PMOS
XM$1160 VDD \$I3965 \$I3964 VDD PMOS L=1u W=3.4u AS=6.46p AD=10.88p PS=7.2u
+ PD=13.2u
* device instance $1161 r0 *1 112.6,360.9 NMOS
XM$1161 BL5 WL12 \$I3965 VSS NMOS L=1u W=3.4u AS=9.52p AD=6.12p PS=12.4u PD=7u
* device instance $1162 r0 *1 117.2,360.9 NMOS
XM$1162 \$I3965 \$I3964 VSS VSS NMOS L=1u W=3.4u AS=6.12p AD=6.46p PS=7u PD=7.2u
* device instance $1163 r0 *1 122,360.9 NMOS
XM$1163 VSS \$I3965 \$I3964 VSS NMOS L=1u W=3.4u AS=6.46p AD=6.12p PS=7.2u PD=7u
* device instance $1164 r0 *1 126.6,360.9 NMOS
XM$1164 \$I3964 WL12 BLB5 VSS NMOS L=1u W=3.4u AS=6.12p AD=9.52p PS=7u PD=12.4u
* device instance $1165 r0 *1 117.2,322.1 PMOS
XM$1165 \$I3967 \$I3966 VDD VDD PMOS L=1u W=3.4u AS=10.88p AD=6.46p PS=13.2u
+ PD=7.2u
* device instance $1166 r0 *1 122,322.1 PMOS
XM$1166 VDD \$I3967 \$I3966 VDD PMOS L=1u W=3.4u AS=6.46p AD=10.88p PS=7.2u
+ PD=13.2u
* device instance $1167 r0 *1 112.6,301.7 NMOS
XM$1167 BL5 WL10 \$I3967 VSS NMOS L=1u W=3.4u AS=9.52p AD=6.12p PS=12.4u PD=7u
* device instance $1168 r0 *1 117.2,301.7 NMOS
XM$1168 \$I3967 \$I3966 VSS VSS NMOS L=1u W=3.4u AS=6.12p AD=6.46p PS=7u PD=7.2u
* device instance $1169 r0 *1 122,301.7 NMOS
XM$1169 VSS \$I3967 \$I3966 VSS NMOS L=1u W=3.4u AS=6.46p AD=6.12p PS=7.2u PD=7u
* device instance $1170 r0 *1 126.6,301.7 NMOS
XM$1170 \$I3966 WL10 BLB5 VSS NMOS L=1u W=3.4u AS=6.12p AD=9.52p PS=7u PD=12.4u
* device instance $1171 r0 *1 117.2,144.5 PMOS
XM$1171 \$I3969 \$I3968 VDD VDD PMOS L=1u W=3.4u AS=10.88p AD=6.46p PS=13.2u
+ PD=7.2u
* device instance $1172 r0 *1 122,144.5 PMOS
XM$1172 VDD \$I3969 \$I3968 VDD PMOS L=1u W=3.4u AS=6.46p AD=10.88p PS=7.2u
+ PD=13.2u
* device instance $1173 r0 *1 112.6,124.1 NMOS
XM$1173 BL5 WL4 \$I3969 VSS NMOS L=1u W=3.4u AS=9.52p AD=6.12p PS=12.4u PD=7u
* device instance $1174 r0 *1 117.2,124.1 NMOS
XM$1174 \$I3969 \$I3968 VSS VSS NMOS L=1u W=3.4u AS=6.12p AD=6.46p PS=7u PD=7.2u
* device instance $1175 r0 *1 122,124.1 NMOS
XM$1175 VSS \$I3969 \$I3968 VSS NMOS L=1u W=3.4u AS=6.46p AD=6.12p PS=7.2u PD=7u
* device instance $1176 r0 *1 126.6,124.1 NMOS
XM$1176 \$I3968 WL4 BLB5 VSS NMOS L=1u W=3.4u AS=6.12p AD=9.52p PS=7u PD=12.4u
* device instance $1177 r0 *1 117.2,203.7 PMOS
XM$1177 \$I3971 \$I3970 VDD VDD PMOS L=1u W=3.4u AS=10.88p AD=6.46p PS=13.2u
+ PD=7.2u
* device instance $1178 r0 *1 122,203.7 PMOS
XM$1178 VDD \$I3971 \$I3970 VDD PMOS L=1u W=3.4u AS=6.46p AD=10.88p PS=7.2u
+ PD=13.2u
* device instance $1179 r0 *1 112.6,183.3 NMOS
XM$1179 BL5 WL6 \$I3971 VSS NMOS L=1u W=3.4u AS=9.52p AD=6.12p PS=12.4u PD=7u
* device instance $1180 r0 *1 117.2,183.3 NMOS
XM$1180 \$I3971 \$I3970 VSS VSS NMOS L=1u W=3.4u AS=6.12p AD=6.46p PS=7u PD=7.2u
* device instance $1181 r0 *1 122,183.3 NMOS
XM$1181 VSS \$I3971 \$I3970 VSS NMOS L=1u W=3.4u AS=6.46p AD=6.12p PS=7.2u PD=7u
* device instance $1182 r0 *1 126.6,183.3 NMOS
XM$1182 \$I3970 WL6 BLB5 VSS NMOS L=1u W=3.4u AS=6.12p AD=9.52p PS=7u PD=12.4u
* device instance $1183 m0 *1 95.2,269.9 PMOS
XM$1183 \$I3973 \$I3972 VDD VDD PMOS L=1u W=3.4u AS=10.88p AD=6.46p PS=13.2u
+ PD=7.2u
* device instance $1184 m0 *1 100,269.9 PMOS
XM$1184 VDD \$I3973 \$I3972 VDD PMOS L=1u W=3.4u AS=6.46p AD=10.88p PS=7.2u
+ PD=13.2u
* device instance $1185 m0 *1 90.6,290.3 NMOS
XM$1185 BL4 WL9 \$I3973 VSS NMOS L=1u W=3.4u AS=9.52p AD=6.12p PS=12.4u PD=7u
* device instance $1186 m0 *1 95.2,290.3 NMOS
XM$1186 \$I3973 \$I3972 VSS VSS NMOS L=1u W=3.4u AS=6.12p AD=6.46p PS=7u PD=7.2u
* device instance $1187 m0 *1 100,290.3 NMOS
XM$1187 VSS \$I3973 \$I3972 VSS NMOS L=1u W=3.4u AS=6.46p AD=6.12p PS=7.2u PD=7u
* device instance $1188 m0 *1 104.6,290.3 NMOS
XM$1188 \$I3972 WL9 BLB4 VSS NMOS L=1u W=3.4u AS=6.12p AD=9.52p PS=7u PD=12.4u
* device instance $1189 m0 *1 95.2,33.1 PMOS
XM$1189 \$I3975 \$I3974 VDD VDD PMOS L=1u W=3.4u AS=10.88p AD=6.46p PS=13.2u
+ PD=7.2u
* device instance $1190 m0 *1 100,33.1 PMOS
XM$1190 VDD \$I3975 \$I3974 VDD PMOS L=1u W=3.4u AS=6.46p AD=10.88p PS=7.2u
+ PD=13.2u
* device instance $1191 m0 *1 90.6,53.5 NMOS
XM$1191 BL4 WL1 \$I3975 VSS NMOS L=1u W=3.4u AS=9.52p AD=6.12p PS=12.4u PD=7u
* device instance $1192 m0 *1 95.2,53.5 NMOS
XM$1192 \$I3975 \$I3974 VSS VSS NMOS L=1u W=3.4u AS=6.12p AD=6.46p PS=7u PD=7.2u
* device instance $1193 m0 *1 100,53.5 NMOS
XM$1193 VSS \$I3975 \$I3974 VSS NMOS L=1u W=3.4u AS=6.46p AD=6.12p PS=7.2u PD=7u
* device instance $1194 m0 *1 104.6,53.5 NMOS
XM$1194 \$I3974 WL1 BLB4 VSS NMOS L=1u W=3.4u AS=6.12p AD=9.52p PS=7u PD=12.4u
* device instance $1195 m0 *1 95.2,210.7 PMOS
XM$1195 \$I3977 \$I3976 VDD VDD PMOS L=1u W=3.4u AS=10.88p AD=6.46p PS=13.2u
+ PD=7.2u
* device instance $1196 m0 *1 100,210.7 PMOS
XM$1196 VDD \$I3977 \$I3976 VDD PMOS L=1u W=3.4u AS=6.46p AD=10.88p PS=7.2u
+ PD=13.2u
* device instance $1197 m0 *1 90.6,231.1 NMOS
XM$1197 BL4 WL7 \$I3977 VSS NMOS L=1u W=3.4u AS=9.52p AD=6.12p PS=12.4u PD=7u
* device instance $1198 m0 *1 95.2,231.1 NMOS
XM$1198 \$I3977 \$I3976 VSS VSS NMOS L=1u W=3.4u AS=6.12p AD=6.46p PS=7u PD=7.2u
* device instance $1199 m0 *1 100,231.1 NMOS
XM$1199 VSS \$I3977 \$I3976 VSS NMOS L=1u W=3.4u AS=6.46p AD=6.12p PS=7.2u PD=7u
* device instance $1200 m0 *1 104.6,231.1 NMOS
XM$1200 \$I3976 WL7 BLB4 VSS NMOS L=1u W=3.4u AS=6.12p AD=9.52p PS=7u PD=12.4u
* device instance $1201 m0 *1 95.2,92.3 PMOS
XM$1201 \$I3979 \$I3978 VDD VDD PMOS L=1u W=3.4u AS=10.88p AD=6.46p PS=13.2u
+ PD=7.2u
* device instance $1202 m0 *1 100,92.3 PMOS
XM$1202 VDD \$I3979 \$I3978 VDD PMOS L=1u W=3.4u AS=6.46p AD=10.88p PS=7.2u
+ PD=13.2u
* device instance $1203 m0 *1 90.6,112.7 NMOS
XM$1203 BL4 WL3 \$I3979 VSS NMOS L=1u W=3.4u AS=9.52p AD=6.12p PS=12.4u PD=7u
* device instance $1204 m0 *1 95.2,112.7 NMOS
XM$1204 \$I3979 \$I3978 VSS VSS NMOS L=1u W=3.4u AS=6.12p AD=6.46p PS=7u PD=7.2u
* device instance $1205 m0 *1 100,112.7 NMOS
XM$1205 VSS \$I3979 \$I3978 VSS NMOS L=1u W=3.4u AS=6.46p AD=6.12p PS=7.2u PD=7u
* device instance $1206 m0 *1 104.6,112.7 NMOS
XM$1206 \$I3978 WL3 BLB4 VSS NMOS L=1u W=3.4u AS=6.12p AD=9.52p PS=7u PD=12.4u
* device instance $1207 m0 *1 95.2,151.5 PMOS
XM$1207 \$I3981 \$I3980 VDD VDD PMOS L=1u W=3.4u AS=10.88p AD=6.46p PS=13.2u
+ PD=7.2u
* device instance $1208 m0 *1 100,151.5 PMOS
XM$1208 VDD \$I3981 \$I3980 VDD PMOS L=1u W=3.4u AS=6.46p AD=10.88p PS=7.2u
+ PD=13.2u
* device instance $1209 m0 *1 90.6,171.9 NMOS
XM$1209 BL4 WL5 \$I3981 VSS NMOS L=1u W=3.4u AS=9.52p AD=6.12p PS=12.4u PD=7u
* device instance $1210 m0 *1 95.2,171.9 NMOS
XM$1210 \$I3981 \$I3980 VSS VSS NMOS L=1u W=3.4u AS=6.12p AD=6.46p PS=7u PD=7.2u
* device instance $1211 m0 *1 100,171.9 NMOS
XM$1211 VSS \$I3981 \$I3980 VSS NMOS L=1u W=3.4u AS=6.46p AD=6.12p PS=7.2u PD=7u
* device instance $1212 m0 *1 104.6,171.9 NMOS
XM$1212 \$I3980 WL5 BLB4 VSS NMOS L=1u W=3.4u AS=6.12p AD=9.52p PS=7u PD=12.4u
* device instance $1213 m0 *1 95.2,447.5 PMOS
XM$1213 \$I3983 \$I3982 VDD VDD PMOS L=1u W=3.4u AS=10.88p AD=6.46p PS=13.2u
+ PD=7.2u
* device instance $1214 m0 *1 100,447.5 PMOS
XM$1214 VDD \$I3983 \$I3982 VDD PMOS L=1u W=3.4u AS=6.46p AD=10.88p PS=7.2u
+ PD=13.2u
* device instance $1215 m0 *1 90.6,467.9 NMOS
XM$1215 BL4 WL15 \$I3983 VSS NMOS L=1u W=3.4u AS=9.52p AD=6.12p PS=12.4u PD=7u
* device instance $1216 m0 *1 95.2,467.9 NMOS
XM$1216 \$I3983 \$I3982 VSS VSS NMOS L=1u W=3.4u AS=6.12p AD=6.46p PS=7u PD=7.2u
* device instance $1217 m0 *1 100,467.9 NMOS
XM$1217 VSS \$I3983 \$I3982 VSS NMOS L=1u W=3.4u AS=6.46p AD=6.12p PS=7.2u PD=7u
* device instance $1218 m0 *1 104.6,467.9 NMOS
XM$1218 \$I3982 WL15 BLB4 VSS NMOS L=1u W=3.4u AS=6.12p AD=9.52p PS=7u PD=12.4u
* device instance $1219 m0 *1 95.2,388.3 PMOS
XM$1219 \$I3985 \$I3984 VDD VDD PMOS L=1u W=3.4u AS=10.88p AD=6.46p PS=13.2u
+ PD=7.2u
* device instance $1220 m0 *1 100,388.3 PMOS
XM$1220 VDD \$I3985 \$I3984 VDD PMOS L=1u W=3.4u AS=6.46p AD=10.88p PS=7.2u
+ PD=13.2u
* device instance $1221 m0 *1 90.6,408.7 NMOS
XM$1221 BL4 WL13 \$I3985 VSS NMOS L=1u W=3.4u AS=9.52p AD=6.12p PS=12.4u PD=7u
* device instance $1222 m0 *1 95.2,408.7 NMOS
XM$1222 \$I3985 \$I3984 VSS VSS NMOS L=1u W=3.4u AS=6.12p AD=6.46p PS=7u PD=7.2u
* device instance $1223 m0 *1 100,408.7 NMOS
XM$1223 VSS \$I3985 \$I3984 VSS NMOS L=1u W=3.4u AS=6.46p AD=6.12p PS=7.2u PD=7u
* device instance $1224 m0 *1 104.6,408.7 NMOS
XM$1224 \$I3984 WL13 BLB4 VSS NMOS L=1u W=3.4u AS=6.12p AD=9.52p PS=7u PD=12.4u
* device instance $1225 m0 *1 95.2,329.1 PMOS
XM$1225 \$I3987 \$I3986 VDD VDD PMOS L=1u W=3.4u AS=10.88p AD=6.46p PS=13.2u
+ PD=7.2u
* device instance $1226 m0 *1 100,329.1 PMOS
XM$1226 VDD \$I3987 \$I3986 VDD PMOS L=1u W=3.4u AS=6.46p AD=10.88p PS=7.2u
+ PD=13.2u
* device instance $1227 m0 *1 90.6,349.5 NMOS
XM$1227 BL4 WL11 \$I3987 VSS NMOS L=1u W=3.4u AS=9.52p AD=6.12p PS=12.4u PD=7u
* device instance $1228 m0 *1 95.2,349.5 NMOS
XM$1228 \$I3987 \$I3986 VSS VSS NMOS L=1u W=3.4u AS=6.12p AD=6.46p PS=7u PD=7.2u
* device instance $1229 m0 *1 100,349.5 NMOS
XM$1229 VSS \$I3987 \$I3986 VSS NMOS L=1u W=3.4u AS=6.46p AD=6.12p PS=7.2u PD=7u
* device instance $1230 m0 *1 104.6,349.5 NMOS
XM$1230 \$I3986 WL11 BLB4 VSS NMOS L=1u W=3.4u AS=6.12p AD=9.52p PS=7u PD=12.4u
* device instance $1231 r0 *1 95.2,440.5 PMOS
XM$1231 \$I3989 \$I3988 VDD VDD PMOS L=1u W=3.4u AS=10.88p AD=6.46p PS=13.2u
+ PD=7.2u
* device instance $1232 r0 *1 100,440.5 PMOS
XM$1232 VDD \$I3989 \$I3988 VDD PMOS L=1u W=3.4u AS=6.46p AD=10.88p PS=7.2u
+ PD=13.2u
* device instance $1233 r0 *1 90.6,420.1 NMOS
XM$1233 BL4 WL14 \$I3989 VSS NMOS L=1u W=3.4u AS=9.52p AD=6.12p PS=12.4u PD=7u
* device instance $1234 r0 *1 95.2,420.1 NMOS
XM$1234 \$I3989 \$I3988 VSS VSS NMOS L=1u W=3.4u AS=6.12p AD=6.46p PS=7u PD=7.2u
* device instance $1235 r0 *1 100,420.1 NMOS
XM$1235 VSS \$I3989 \$I3988 VSS NMOS L=1u W=3.4u AS=6.46p AD=6.12p PS=7.2u PD=7u
* device instance $1236 r0 *1 104.6,420.1 NMOS
XM$1236 \$I3988 WL14 BLB4 VSS NMOS L=1u W=3.4u AS=6.12p AD=9.52p PS=7u PD=12.4u
* device instance $1237 r0 *1 95.2,85.3 PMOS
XM$1237 \$I3991 \$I3990 VDD VDD PMOS L=1u W=3.4u AS=10.88p AD=6.46p PS=13.2u
+ PD=7.2u
* device instance $1238 r0 *1 100,85.3 PMOS
XM$1238 VDD \$I3991 \$I3990 VDD PMOS L=1u W=3.4u AS=6.46p AD=10.88p PS=7.2u
+ PD=13.2u
* device instance $1239 r0 *1 90.6,64.9 NMOS
XM$1239 BL4 WL2 \$I3991 VSS NMOS L=1u W=3.4u AS=9.52p AD=6.12p PS=12.4u PD=7u
* device instance $1240 r0 *1 95.2,64.9 NMOS
XM$1240 \$I3991 \$I3990 VSS VSS NMOS L=1u W=3.4u AS=6.12p AD=6.46p PS=7u PD=7.2u
* device instance $1241 r0 *1 100,64.9 NMOS
XM$1241 VSS \$I3991 \$I3990 VSS NMOS L=1u W=3.4u AS=6.46p AD=6.12p PS=7.2u PD=7u
* device instance $1242 r0 *1 104.6,64.9 NMOS
XM$1242 \$I3990 WL2 BLB4 VSS NMOS L=1u W=3.4u AS=6.12p AD=9.52p PS=7u PD=12.4u
* device instance $1243 r0 *1 95.2,381.3 PMOS
XM$1243 \$I3993 \$I3992 VDD VDD PMOS L=1u W=3.4u AS=10.88p AD=6.46p PS=13.2u
+ PD=7.2u
* device instance $1244 r0 *1 100,381.3 PMOS
XM$1244 VDD \$I3993 \$I3992 VDD PMOS L=1u W=3.4u AS=6.46p AD=10.88p PS=7.2u
+ PD=13.2u
* device instance $1245 r0 *1 90.6,360.9 NMOS
XM$1245 BL4 WL12 \$I3993 VSS NMOS L=1u W=3.4u AS=9.52p AD=6.12p PS=12.4u PD=7u
* device instance $1246 r0 *1 95.2,360.9 NMOS
XM$1246 \$I3993 \$I3992 VSS VSS NMOS L=1u W=3.4u AS=6.12p AD=6.46p PS=7u PD=7.2u
* device instance $1247 r0 *1 100,360.9 NMOS
XM$1247 VSS \$I3993 \$I3992 VSS NMOS L=1u W=3.4u AS=6.46p AD=6.12p PS=7.2u PD=7u
* device instance $1248 r0 *1 104.6,360.9 NMOS
XM$1248 \$I3992 WL12 BLB4 VSS NMOS L=1u W=3.4u AS=6.12p AD=9.52p PS=7u PD=12.4u
* device instance $1249 r0 *1 95.2,262.9 PMOS
XM$1249 \$I3995 \$I3994 VDD VDD PMOS L=1u W=3.4u AS=10.88p AD=6.46p PS=13.2u
+ PD=7.2u
* device instance $1250 r0 *1 100,262.9 PMOS
XM$1250 VDD \$I3995 \$I3994 VDD PMOS L=1u W=3.4u AS=6.46p AD=10.88p PS=7.2u
+ PD=13.2u
* device instance $1251 r0 *1 90.6,242.5 NMOS
XM$1251 BL4 WL8 \$I3995 VSS NMOS L=1u W=3.4u AS=9.52p AD=6.12p PS=12.4u PD=7u
* device instance $1252 r0 *1 95.2,242.5 NMOS
XM$1252 \$I3995 \$I3994 VSS VSS NMOS L=1u W=3.4u AS=6.12p AD=6.46p PS=7u PD=7.2u
* device instance $1253 r0 *1 100,242.5 NMOS
XM$1253 VSS \$I3995 \$I3994 VSS NMOS L=1u W=3.4u AS=6.46p AD=6.12p PS=7.2u PD=7u
* device instance $1254 r0 *1 104.6,242.5 NMOS
XM$1254 \$I3994 WL8 BLB4 VSS NMOS L=1u W=3.4u AS=6.12p AD=9.52p PS=7u PD=12.4u
* device instance $1255 r0 *1 95.2,322.1 PMOS
XM$1255 \$I3997 \$I3996 VDD VDD PMOS L=1u W=3.4u AS=10.88p AD=6.46p PS=13.2u
+ PD=7.2u
* device instance $1256 r0 *1 100,322.1 PMOS
XM$1256 VDD \$I3997 \$I3996 VDD PMOS L=1u W=3.4u AS=6.46p AD=10.88p PS=7.2u
+ PD=13.2u
* device instance $1257 r0 *1 90.6,301.7 NMOS
XM$1257 BL4 WL10 \$I3997 VSS NMOS L=1u W=3.4u AS=9.52p AD=6.12p PS=12.4u PD=7u
* device instance $1258 r0 *1 95.2,301.7 NMOS
XM$1258 \$I3997 \$I3996 VSS VSS NMOS L=1u W=3.4u AS=6.12p AD=6.46p PS=7u PD=7.2u
* device instance $1259 r0 *1 100,301.7 NMOS
XM$1259 VSS \$I3997 \$I3996 VSS NMOS L=1u W=3.4u AS=6.46p AD=6.12p PS=7.2u PD=7u
* device instance $1260 r0 *1 104.6,301.7 NMOS
XM$1260 \$I3996 WL10 BLB4 VSS NMOS L=1u W=3.4u AS=6.12p AD=9.52p PS=7u PD=12.4u
* device instance $1261 r0 *1 95.2,144.5 PMOS
XM$1261 \$I3999 \$I3998 VDD VDD PMOS L=1u W=3.4u AS=10.88p AD=6.46p PS=13.2u
+ PD=7.2u
* device instance $1262 r0 *1 100,144.5 PMOS
XM$1262 VDD \$I3999 \$I3998 VDD PMOS L=1u W=3.4u AS=6.46p AD=10.88p PS=7.2u
+ PD=13.2u
* device instance $1263 r0 *1 90.6,124.1 NMOS
XM$1263 BL4 WL4 \$I3999 VSS NMOS L=1u W=3.4u AS=9.52p AD=6.12p PS=12.4u PD=7u
* device instance $1264 r0 *1 95.2,124.1 NMOS
XM$1264 \$I3999 \$I3998 VSS VSS NMOS L=1u W=3.4u AS=6.12p AD=6.46p PS=7u PD=7.2u
* device instance $1265 r0 *1 100,124.1 NMOS
XM$1265 VSS \$I3999 \$I3998 VSS NMOS L=1u W=3.4u AS=6.46p AD=6.12p PS=7.2u PD=7u
* device instance $1266 r0 *1 104.6,124.1 NMOS
XM$1266 \$I3998 WL4 BLB4 VSS NMOS L=1u W=3.4u AS=6.12p AD=9.52p PS=7u PD=12.4u
* device instance $1267 r0 *1 95.2,203.7 PMOS
XM$1267 \$I4001 \$I4000 VDD VDD PMOS L=1u W=3.4u AS=10.88p AD=6.46p PS=13.2u
+ PD=7.2u
* device instance $1268 r0 *1 100,203.7 PMOS
XM$1268 VDD \$I4001 \$I4000 VDD PMOS L=1u W=3.4u AS=6.46p AD=10.88p PS=7.2u
+ PD=13.2u
* device instance $1269 r0 *1 90.6,183.3 NMOS
XM$1269 BL4 WL6 \$I4001 VSS NMOS L=1u W=3.4u AS=9.52p AD=6.12p PS=12.4u PD=7u
* device instance $1270 r0 *1 95.2,183.3 NMOS
XM$1270 \$I4001 \$I4000 VSS VSS NMOS L=1u W=3.4u AS=6.12p AD=6.46p PS=7u PD=7.2u
* device instance $1271 r0 *1 100,183.3 NMOS
XM$1271 VSS \$I4001 \$I4000 VSS NMOS L=1u W=3.4u AS=6.46p AD=6.12p PS=7.2u PD=7u
* device instance $1272 r0 *1 104.6,183.3 NMOS
XM$1272 \$I4000 WL6 BLB4 VSS NMOS L=1u W=3.4u AS=6.12p AD=9.52p PS=7u PD=12.4u
* device instance $1273 m0 *1 73.2,269.9 PMOS
XM$1273 \$I4003 \$I4002 VDD VDD PMOS L=1u W=3.4u AS=10.88p AD=6.46p PS=13.2u
+ PD=7.2u
* device instance $1274 m0 *1 78,269.9 PMOS
XM$1274 VDD \$I4003 \$I4002 VDD PMOS L=1u W=3.4u AS=6.46p AD=10.88p PS=7.2u
+ PD=13.2u
* device instance $1275 m0 *1 68.6,290.3 NMOS
XM$1275 BL3 WL9 \$I4003 VSS NMOS L=1u W=3.4u AS=9.52p AD=6.12p PS=12.4u PD=7u
* device instance $1276 m0 *1 73.2,290.3 NMOS
XM$1276 \$I4003 \$I4002 VSS VSS NMOS L=1u W=3.4u AS=6.12p AD=6.46p PS=7u PD=7.2u
* device instance $1277 m0 *1 78,290.3 NMOS
XM$1277 VSS \$I4003 \$I4002 VSS NMOS L=1u W=3.4u AS=6.46p AD=6.12p PS=7.2u PD=7u
* device instance $1278 m0 *1 82.6,290.3 NMOS
XM$1278 \$I4002 WL9 BLB3 VSS NMOS L=1u W=3.4u AS=6.12p AD=9.52p PS=7u PD=12.4u
* device instance $1279 m0 *1 73.2,33.1 PMOS
XM$1279 \$I4005 \$I4004 VDD VDD PMOS L=1u W=3.4u AS=10.88p AD=6.46p PS=13.2u
+ PD=7.2u
* device instance $1280 m0 *1 78,33.1 PMOS
XM$1280 VDD \$I4005 \$I4004 VDD PMOS L=1u W=3.4u AS=6.46p AD=10.88p PS=7.2u
+ PD=13.2u
* device instance $1281 m0 *1 68.6,53.5 NMOS
XM$1281 BL3 WL1 \$I4005 VSS NMOS L=1u W=3.4u AS=9.52p AD=6.12p PS=12.4u PD=7u
* device instance $1282 m0 *1 73.2,53.5 NMOS
XM$1282 \$I4005 \$I4004 VSS VSS NMOS L=1u W=3.4u AS=6.12p AD=6.46p PS=7u PD=7.2u
* device instance $1283 m0 *1 78,53.5 NMOS
XM$1283 VSS \$I4005 \$I4004 VSS NMOS L=1u W=3.4u AS=6.46p AD=6.12p PS=7.2u PD=7u
* device instance $1284 m0 *1 82.6,53.5 NMOS
XM$1284 \$I4004 WL1 BLB3 VSS NMOS L=1u W=3.4u AS=6.12p AD=9.52p PS=7u PD=12.4u
* device instance $1285 m0 *1 73.2,92.3 PMOS
XM$1285 \$I4007 \$I4006 VDD VDD PMOS L=1u W=3.4u AS=10.88p AD=6.46p PS=13.2u
+ PD=7.2u
* device instance $1286 m0 *1 78,92.3 PMOS
XM$1286 VDD \$I4007 \$I4006 VDD PMOS L=1u W=3.4u AS=6.46p AD=10.88p PS=7.2u
+ PD=13.2u
* device instance $1287 m0 *1 68.6,112.7 NMOS
XM$1287 BL3 WL3 \$I4007 VSS NMOS L=1u W=3.4u AS=9.52p AD=6.12p PS=12.4u PD=7u
* device instance $1288 m0 *1 73.2,112.7 NMOS
XM$1288 \$I4007 \$I4006 VSS VSS NMOS L=1u W=3.4u AS=6.12p AD=6.46p PS=7u PD=7.2u
* device instance $1289 m0 *1 78,112.7 NMOS
XM$1289 VSS \$I4007 \$I4006 VSS NMOS L=1u W=3.4u AS=6.46p AD=6.12p PS=7.2u PD=7u
* device instance $1290 m0 *1 82.6,112.7 NMOS
XM$1290 \$I4006 WL3 BLB3 VSS NMOS L=1u W=3.4u AS=6.12p AD=9.52p PS=7u PD=12.4u
* device instance $1291 m0 *1 73.2,210.7 PMOS
XM$1291 \$I4009 \$I4008 VDD VDD PMOS L=1u W=3.4u AS=10.88p AD=6.46p PS=13.2u
+ PD=7.2u
* device instance $1292 m0 *1 78,210.7 PMOS
XM$1292 VDD \$I4009 \$I4008 VDD PMOS L=1u W=3.4u AS=6.46p AD=10.88p PS=7.2u
+ PD=13.2u
* device instance $1293 m0 *1 68.6,231.1 NMOS
XM$1293 BL3 WL7 \$I4009 VSS NMOS L=1u W=3.4u AS=9.52p AD=6.12p PS=12.4u PD=7u
* device instance $1294 m0 *1 73.2,231.1 NMOS
XM$1294 \$I4009 \$I4008 VSS VSS NMOS L=1u W=3.4u AS=6.12p AD=6.46p PS=7u PD=7.2u
* device instance $1295 m0 *1 78,231.1 NMOS
XM$1295 VSS \$I4009 \$I4008 VSS NMOS L=1u W=3.4u AS=6.46p AD=6.12p PS=7.2u PD=7u
* device instance $1296 m0 *1 82.6,231.1 NMOS
XM$1296 \$I4008 WL7 BLB3 VSS NMOS L=1u W=3.4u AS=6.12p AD=9.52p PS=7u PD=12.4u
* device instance $1297 m0 *1 73.2,151.5 PMOS
XM$1297 \$I4011 \$I4010 VDD VDD PMOS L=1u W=3.4u AS=10.88p AD=6.46p PS=13.2u
+ PD=7.2u
* device instance $1298 m0 *1 78,151.5 PMOS
XM$1298 VDD \$I4011 \$I4010 VDD PMOS L=1u W=3.4u AS=6.46p AD=10.88p PS=7.2u
+ PD=13.2u
* device instance $1299 m0 *1 68.6,171.9 NMOS
XM$1299 BL3 WL5 \$I4011 VSS NMOS L=1u W=3.4u AS=9.52p AD=6.12p PS=12.4u PD=7u
* device instance $1300 m0 *1 73.2,171.9 NMOS
XM$1300 \$I4011 \$I4010 VSS VSS NMOS L=1u W=3.4u AS=6.12p AD=6.46p PS=7u PD=7.2u
* device instance $1301 m0 *1 78,171.9 NMOS
XM$1301 VSS \$I4011 \$I4010 VSS NMOS L=1u W=3.4u AS=6.46p AD=6.12p PS=7.2u PD=7u
* device instance $1302 m0 *1 82.6,171.9 NMOS
XM$1302 \$I4010 WL5 BLB3 VSS NMOS L=1u W=3.4u AS=6.12p AD=9.52p PS=7u PD=12.4u
* device instance $1303 m0 *1 73.2,447.5 PMOS
XM$1303 \$I4013 \$I4012 VDD VDD PMOS L=1u W=3.4u AS=10.88p AD=6.46p PS=13.2u
+ PD=7.2u
* device instance $1304 m0 *1 78,447.5 PMOS
XM$1304 VDD \$I4013 \$I4012 VDD PMOS L=1u W=3.4u AS=6.46p AD=10.88p PS=7.2u
+ PD=13.2u
* device instance $1305 m0 *1 68.6,467.9 NMOS
XM$1305 BL3 WL15 \$I4013 VSS NMOS L=1u W=3.4u AS=9.52p AD=6.12p PS=12.4u PD=7u
* device instance $1306 m0 *1 73.2,467.9 NMOS
XM$1306 \$I4013 \$I4012 VSS VSS NMOS L=1u W=3.4u AS=6.12p AD=6.46p PS=7u PD=7.2u
* device instance $1307 m0 *1 78,467.9 NMOS
XM$1307 VSS \$I4013 \$I4012 VSS NMOS L=1u W=3.4u AS=6.46p AD=6.12p PS=7.2u PD=7u
* device instance $1308 m0 *1 82.6,467.9 NMOS
XM$1308 \$I4012 WL15 BLB3 VSS NMOS L=1u W=3.4u AS=6.12p AD=9.52p PS=7u PD=12.4u
* device instance $1309 m0 *1 73.2,388.3 PMOS
XM$1309 \$I4015 \$I4014 VDD VDD PMOS L=1u W=3.4u AS=10.88p AD=6.46p PS=13.2u
+ PD=7.2u
* device instance $1310 m0 *1 78,388.3 PMOS
XM$1310 VDD \$I4015 \$I4014 VDD PMOS L=1u W=3.4u AS=6.46p AD=10.88p PS=7.2u
+ PD=13.2u
* device instance $1311 m0 *1 68.6,408.7 NMOS
XM$1311 BL3 WL13 \$I4015 VSS NMOS L=1u W=3.4u AS=9.52p AD=6.12p PS=12.4u PD=7u
* device instance $1312 m0 *1 73.2,408.7 NMOS
XM$1312 \$I4015 \$I4014 VSS VSS NMOS L=1u W=3.4u AS=6.12p AD=6.46p PS=7u PD=7.2u
* device instance $1313 m0 *1 78,408.7 NMOS
XM$1313 VSS \$I4015 \$I4014 VSS NMOS L=1u W=3.4u AS=6.46p AD=6.12p PS=7.2u PD=7u
* device instance $1314 m0 *1 82.6,408.7 NMOS
XM$1314 \$I4014 WL13 BLB3 VSS NMOS L=1u W=3.4u AS=6.12p AD=9.52p PS=7u PD=12.4u
* device instance $1315 m0 *1 73.2,329.1 PMOS
XM$1315 \$I4017 \$I4016 VDD VDD PMOS L=1u W=3.4u AS=10.88p AD=6.46p PS=13.2u
+ PD=7.2u
* device instance $1316 m0 *1 78,329.1 PMOS
XM$1316 VDD \$I4017 \$I4016 VDD PMOS L=1u W=3.4u AS=6.46p AD=10.88p PS=7.2u
+ PD=13.2u
* device instance $1317 m0 *1 68.6,349.5 NMOS
XM$1317 BL3 WL11 \$I4017 VSS NMOS L=1u W=3.4u AS=9.52p AD=6.12p PS=12.4u PD=7u
* device instance $1318 m0 *1 73.2,349.5 NMOS
XM$1318 \$I4017 \$I4016 VSS VSS NMOS L=1u W=3.4u AS=6.12p AD=6.46p PS=7u PD=7.2u
* device instance $1319 m0 *1 78,349.5 NMOS
XM$1319 VSS \$I4017 \$I4016 VSS NMOS L=1u W=3.4u AS=6.46p AD=6.12p PS=7.2u PD=7u
* device instance $1320 m0 *1 82.6,349.5 NMOS
XM$1320 \$I4016 WL11 BLB3 VSS NMOS L=1u W=3.4u AS=6.12p AD=9.52p PS=7u PD=12.4u
* device instance $1321 r0 *1 73.2,440.5 PMOS
XM$1321 \$I4019 \$I4018 VDD VDD PMOS L=1u W=3.4u AS=10.88p AD=6.46p PS=13.2u
+ PD=7.2u
* device instance $1322 r0 *1 78,440.5 PMOS
XM$1322 VDD \$I4019 \$I4018 VDD PMOS L=1u W=3.4u AS=6.46p AD=10.88p PS=7.2u
+ PD=13.2u
* device instance $1323 r0 *1 68.6,420.1 NMOS
XM$1323 BL3 WL14 \$I4019 VSS NMOS L=1u W=3.4u AS=9.52p AD=6.12p PS=12.4u PD=7u
* device instance $1324 r0 *1 73.2,420.1 NMOS
XM$1324 \$I4019 \$I4018 VSS VSS NMOS L=1u W=3.4u AS=6.12p AD=6.46p PS=7u PD=7.2u
* device instance $1325 r0 *1 78,420.1 NMOS
XM$1325 VSS \$I4019 \$I4018 VSS NMOS L=1u W=3.4u AS=6.46p AD=6.12p PS=7.2u PD=7u
* device instance $1326 r0 *1 82.6,420.1 NMOS
XM$1326 \$I4018 WL14 BLB3 VSS NMOS L=1u W=3.4u AS=6.12p AD=9.52p PS=7u PD=12.4u
* device instance $1327 r0 *1 73.2,381.3 PMOS
XM$1327 \$I4021 \$I4020 VDD VDD PMOS L=1u W=3.4u AS=10.88p AD=6.46p PS=13.2u
+ PD=7.2u
* device instance $1328 r0 *1 78,381.3 PMOS
XM$1328 VDD \$I4021 \$I4020 VDD PMOS L=1u W=3.4u AS=6.46p AD=10.88p PS=7.2u
+ PD=13.2u
* device instance $1329 r0 *1 68.6,360.9 NMOS
XM$1329 BL3 WL12 \$I4021 VSS NMOS L=1u W=3.4u AS=9.52p AD=6.12p PS=12.4u PD=7u
* device instance $1330 r0 *1 73.2,360.9 NMOS
XM$1330 \$I4021 \$I4020 VSS VSS NMOS L=1u W=3.4u AS=6.12p AD=6.46p PS=7u PD=7.2u
* device instance $1331 r0 *1 78,360.9 NMOS
XM$1331 VSS \$I4021 \$I4020 VSS NMOS L=1u W=3.4u AS=6.46p AD=6.12p PS=7.2u PD=7u
* device instance $1332 r0 *1 82.6,360.9 NMOS
XM$1332 \$I4020 WL12 BLB3 VSS NMOS L=1u W=3.4u AS=6.12p AD=9.52p PS=7u PD=12.4u
* device instance $1333 r0 *1 73.2,322.1 PMOS
XM$1333 \$I4023 \$I4022 VDD VDD PMOS L=1u W=3.4u AS=10.88p AD=6.46p PS=13.2u
+ PD=7.2u
* device instance $1334 r0 *1 78,322.1 PMOS
XM$1334 VDD \$I4023 \$I4022 VDD PMOS L=1u W=3.4u AS=6.46p AD=10.88p PS=7.2u
+ PD=13.2u
* device instance $1335 r0 *1 68.6,301.7 NMOS
XM$1335 BL3 WL10 \$I4023 VSS NMOS L=1u W=3.4u AS=9.52p AD=6.12p PS=12.4u PD=7u
* device instance $1336 r0 *1 73.2,301.7 NMOS
XM$1336 \$I4023 \$I4022 VSS VSS NMOS L=1u W=3.4u AS=6.12p AD=6.46p PS=7u PD=7.2u
* device instance $1337 r0 *1 78,301.7 NMOS
XM$1337 VSS \$I4023 \$I4022 VSS NMOS L=1u W=3.4u AS=6.46p AD=6.12p PS=7.2u PD=7u
* device instance $1338 r0 *1 82.6,301.7 NMOS
XM$1338 \$I4022 WL10 BLB3 VSS NMOS L=1u W=3.4u AS=6.12p AD=9.52p PS=7u PD=12.4u
* device instance $1339 r0 *1 73.2,262.9 PMOS
XM$1339 \$I4025 \$I4024 VDD VDD PMOS L=1u W=3.4u AS=10.88p AD=6.46p PS=13.2u
+ PD=7.2u
* device instance $1340 r0 *1 78,262.9 PMOS
XM$1340 VDD \$I4025 \$I4024 VDD PMOS L=1u W=3.4u AS=6.46p AD=10.88p PS=7.2u
+ PD=13.2u
* device instance $1341 r0 *1 68.6,242.5 NMOS
XM$1341 BL3 WL8 \$I4025 VSS NMOS L=1u W=3.4u AS=9.52p AD=6.12p PS=12.4u PD=7u
* device instance $1342 r0 *1 73.2,242.5 NMOS
XM$1342 \$I4025 \$I4024 VSS VSS NMOS L=1u W=3.4u AS=6.12p AD=6.46p PS=7u PD=7.2u
* device instance $1343 r0 *1 78,242.5 NMOS
XM$1343 VSS \$I4025 \$I4024 VSS NMOS L=1u W=3.4u AS=6.46p AD=6.12p PS=7.2u PD=7u
* device instance $1344 r0 *1 82.6,242.5 NMOS
XM$1344 \$I4024 WL8 BLB3 VSS NMOS L=1u W=3.4u AS=6.12p AD=9.52p PS=7u PD=12.4u
* device instance $1345 r0 *1 73.2,144.5 PMOS
XM$1345 \$I4027 \$I4026 VDD VDD PMOS L=1u W=3.4u AS=10.88p AD=6.46p PS=13.2u
+ PD=7.2u
* device instance $1346 r0 *1 78,144.5 PMOS
XM$1346 VDD \$I4027 \$I4026 VDD PMOS L=1u W=3.4u AS=6.46p AD=10.88p PS=7.2u
+ PD=13.2u
* device instance $1347 r0 *1 68.6,124.1 NMOS
XM$1347 BL3 WL4 \$I4027 VSS NMOS L=1u W=3.4u AS=9.52p AD=6.12p PS=12.4u PD=7u
* device instance $1348 r0 *1 73.2,124.1 NMOS
XM$1348 \$I4027 \$I4026 VSS VSS NMOS L=1u W=3.4u AS=6.12p AD=6.46p PS=7u PD=7.2u
* device instance $1349 r0 *1 78,124.1 NMOS
XM$1349 VSS \$I4027 \$I4026 VSS NMOS L=1u W=3.4u AS=6.46p AD=6.12p PS=7.2u PD=7u
* device instance $1350 r0 *1 82.6,124.1 NMOS
XM$1350 \$I4026 WL4 BLB3 VSS NMOS L=1u W=3.4u AS=6.12p AD=9.52p PS=7u PD=12.4u
* device instance $1351 r0 *1 73.2,85.3 PMOS
XM$1351 \$I4029 \$I4028 VDD VDD PMOS L=1u W=3.4u AS=10.88p AD=6.46p PS=13.2u
+ PD=7.2u
* device instance $1352 r0 *1 78,85.3 PMOS
XM$1352 VDD \$I4029 \$I4028 VDD PMOS L=1u W=3.4u AS=6.46p AD=10.88p PS=7.2u
+ PD=13.2u
* device instance $1353 r0 *1 68.6,64.9 NMOS
XM$1353 BL3 WL2 \$I4029 VSS NMOS L=1u W=3.4u AS=9.52p AD=6.12p PS=12.4u PD=7u
* device instance $1354 r0 *1 73.2,64.9 NMOS
XM$1354 \$I4029 \$I4028 VSS VSS NMOS L=1u W=3.4u AS=6.12p AD=6.46p PS=7u PD=7.2u
* device instance $1355 r0 *1 78,64.9 NMOS
XM$1355 VSS \$I4029 \$I4028 VSS NMOS L=1u W=3.4u AS=6.46p AD=6.12p PS=7.2u PD=7u
* device instance $1356 r0 *1 82.6,64.9 NMOS
XM$1356 \$I4028 WL2 BLB3 VSS NMOS L=1u W=3.4u AS=6.12p AD=9.52p PS=7u PD=12.4u
* device instance $1357 r0 *1 73.2,203.7 PMOS
XM$1357 \$I4031 \$I4030 VDD VDD PMOS L=1u W=3.4u AS=10.88p AD=6.46p PS=13.2u
+ PD=7.2u
* device instance $1358 r0 *1 78,203.7 PMOS
XM$1358 VDD \$I4031 \$I4030 VDD PMOS L=1u W=3.4u AS=6.46p AD=10.88p PS=7.2u
+ PD=13.2u
* device instance $1359 r0 *1 68.6,183.3 NMOS
XM$1359 BL3 WL6 \$I4031 VSS NMOS L=1u W=3.4u AS=9.52p AD=6.12p PS=12.4u PD=7u
* device instance $1360 r0 *1 73.2,183.3 NMOS
XM$1360 \$I4031 \$I4030 VSS VSS NMOS L=1u W=3.4u AS=6.12p AD=6.46p PS=7u PD=7.2u
* device instance $1361 r0 *1 78,183.3 NMOS
XM$1361 VSS \$I4031 \$I4030 VSS NMOS L=1u W=3.4u AS=6.46p AD=6.12p PS=7.2u PD=7u
* device instance $1362 r0 *1 82.6,183.3 NMOS
XM$1362 \$I4030 WL6 BLB3 VSS NMOS L=1u W=3.4u AS=6.12p AD=9.52p PS=7u PD=12.4u
* device instance $1363 m0 *1 161.2,269.9 PMOS
XM$1363 \$I4033 \$I4032 VDD VDD PMOS L=1u W=3.4u AS=10.88p AD=6.46p PS=13.2u
+ PD=7.2u
* device instance $1364 m0 *1 166,269.9 PMOS
XM$1364 VDD \$I4033 \$I4032 VDD PMOS L=1u W=3.4u AS=6.46p AD=10.88p PS=7.2u
+ PD=13.2u
* device instance $1365 m0 *1 156.6,290.3 NMOS
XM$1365 BL7 WL9 \$I4033 VSS NMOS L=1u W=3.4u AS=9.52p AD=6.12p PS=12.4u PD=7u
* device instance $1366 m0 *1 161.2,290.3 NMOS
XM$1366 \$I4033 \$I4032 VSS VSS NMOS L=1u W=3.4u AS=6.12p AD=6.46p PS=7u PD=7.2u
* device instance $1367 m0 *1 166,290.3 NMOS
XM$1367 VSS \$I4033 \$I4032 VSS NMOS L=1u W=3.4u AS=6.46p AD=6.12p PS=7.2u PD=7u
* device instance $1368 m0 *1 170.6,290.3 NMOS
XM$1368 \$I4032 WL9 BLB7 VSS NMOS L=1u W=3.4u AS=6.12p AD=9.52p PS=7u PD=12.4u
* device instance $1369 m0 *1 161.2,33.1 PMOS
XM$1369 \$I4035 \$I4034 VDD VDD PMOS L=1u W=3.4u AS=10.88p AD=6.46p PS=13.2u
+ PD=7.2u
* device instance $1370 m0 *1 166,33.1 PMOS
XM$1370 VDD \$I4035 \$I4034 VDD PMOS L=1u W=3.4u AS=6.46p AD=10.88p PS=7.2u
+ PD=13.2u
* device instance $1371 m0 *1 156.6,53.5 NMOS
XM$1371 BL7 WL1 \$I4035 VSS NMOS L=1u W=3.4u AS=9.52p AD=6.12p PS=12.4u PD=7u
* device instance $1372 m0 *1 161.2,53.5 NMOS
XM$1372 \$I4035 \$I4034 VSS VSS NMOS L=1u W=3.4u AS=6.12p AD=6.46p PS=7u PD=7.2u
* device instance $1373 m0 *1 166,53.5 NMOS
XM$1373 VSS \$I4035 \$I4034 VSS NMOS L=1u W=3.4u AS=6.46p AD=6.12p PS=7.2u PD=7u
* device instance $1374 m0 *1 170.6,53.5 NMOS
XM$1374 \$I4034 WL1 BLB7 VSS NMOS L=1u W=3.4u AS=6.12p AD=9.52p PS=7u PD=12.4u
* device instance $1375 m0 *1 161.2,210.7 PMOS
XM$1375 \$I4037 \$I4036 VDD VDD PMOS L=1u W=3.4u AS=10.88p AD=6.46p PS=13.2u
+ PD=7.2u
* device instance $1376 m0 *1 166,210.7 PMOS
XM$1376 VDD \$I4037 \$I4036 VDD PMOS L=1u W=3.4u AS=6.46p AD=10.88p PS=7.2u
+ PD=13.2u
* device instance $1377 m0 *1 156.6,231.1 NMOS
XM$1377 BL7 WL7 \$I4037 VSS NMOS L=1u W=3.4u AS=9.52p AD=6.12p PS=12.4u PD=7u
* device instance $1378 m0 *1 161.2,231.1 NMOS
XM$1378 \$I4037 \$I4036 VSS VSS NMOS L=1u W=3.4u AS=6.12p AD=6.46p PS=7u PD=7.2u
* device instance $1379 m0 *1 166,231.1 NMOS
XM$1379 VSS \$I4037 \$I4036 VSS NMOS L=1u W=3.4u AS=6.46p AD=6.12p PS=7.2u PD=7u
* device instance $1380 m0 *1 170.6,231.1 NMOS
XM$1380 \$I4036 WL7 BLB7 VSS NMOS L=1u W=3.4u AS=6.12p AD=9.52p PS=7u PD=12.4u
* device instance $1381 m0 *1 161.2,92.3 PMOS
XM$1381 \$I4039 \$I4038 VDD VDD PMOS L=1u W=3.4u AS=10.88p AD=6.46p PS=13.2u
+ PD=7.2u
* device instance $1382 m0 *1 166,92.3 PMOS
XM$1382 VDD \$I4039 \$I4038 VDD PMOS L=1u W=3.4u AS=6.46p AD=10.88p PS=7.2u
+ PD=13.2u
* device instance $1383 m0 *1 156.6,112.7 NMOS
XM$1383 BL7 WL3 \$I4039 VSS NMOS L=1u W=3.4u AS=9.52p AD=6.12p PS=12.4u PD=7u
* device instance $1384 m0 *1 161.2,112.7 NMOS
XM$1384 \$I4039 \$I4038 VSS VSS NMOS L=1u W=3.4u AS=6.12p AD=6.46p PS=7u PD=7.2u
* device instance $1385 m0 *1 166,112.7 NMOS
XM$1385 VSS \$I4039 \$I4038 VSS NMOS L=1u W=3.4u AS=6.46p AD=6.12p PS=7.2u PD=7u
* device instance $1386 m0 *1 170.6,112.7 NMOS
XM$1386 \$I4038 WL3 BLB7 VSS NMOS L=1u W=3.4u AS=6.12p AD=9.52p PS=7u PD=12.4u
* device instance $1387 m0 *1 161.2,151.5 PMOS
XM$1387 \$I4041 \$I4040 VDD VDD PMOS L=1u W=3.4u AS=10.88p AD=6.46p PS=13.2u
+ PD=7.2u
* device instance $1388 m0 *1 166,151.5 PMOS
XM$1388 VDD \$I4041 \$I4040 VDD PMOS L=1u W=3.4u AS=6.46p AD=10.88p PS=7.2u
+ PD=13.2u
* device instance $1389 m0 *1 156.6,171.9 NMOS
XM$1389 BL7 WL5 \$I4041 VSS NMOS L=1u W=3.4u AS=9.52p AD=6.12p PS=12.4u PD=7u
* device instance $1390 m0 *1 161.2,171.9 NMOS
XM$1390 \$I4041 \$I4040 VSS VSS NMOS L=1u W=3.4u AS=6.12p AD=6.46p PS=7u PD=7.2u
* device instance $1391 m0 *1 166,171.9 NMOS
XM$1391 VSS \$I4041 \$I4040 VSS NMOS L=1u W=3.4u AS=6.46p AD=6.12p PS=7.2u PD=7u
* device instance $1392 m0 *1 170.6,171.9 NMOS
XM$1392 \$I4040 WL5 BLB7 VSS NMOS L=1u W=3.4u AS=6.12p AD=9.52p PS=7u PD=12.4u
* device instance $1393 m0 *1 161.2,447.5 PMOS
XM$1393 \$I4043 \$I4042 VDD VDD PMOS L=1u W=3.4u AS=10.88p AD=6.46p PS=13.2u
+ PD=7.2u
* device instance $1394 m0 *1 166,447.5 PMOS
XM$1394 VDD \$I4043 \$I4042 VDD PMOS L=1u W=3.4u AS=6.46p AD=10.88p PS=7.2u
+ PD=13.2u
* device instance $1395 m0 *1 156.6,467.9 NMOS
XM$1395 BL7 WL15 \$I4043 VSS NMOS L=1u W=3.4u AS=9.52p AD=6.12p PS=12.4u PD=7u
* device instance $1396 m0 *1 161.2,467.9 NMOS
XM$1396 \$I4043 \$I4042 VSS VSS NMOS L=1u W=3.4u AS=6.12p AD=6.46p PS=7u PD=7.2u
* device instance $1397 m0 *1 166,467.9 NMOS
XM$1397 VSS \$I4043 \$I4042 VSS NMOS L=1u W=3.4u AS=6.46p AD=6.12p PS=7.2u PD=7u
* device instance $1398 m0 *1 170.6,467.9 NMOS
XM$1398 \$I4042 WL15 BLB7 VSS NMOS L=1u W=3.4u AS=6.12p AD=9.52p PS=7u PD=12.4u
* device instance $1399 m0 *1 161.2,388.3 PMOS
XM$1399 \$I4045 \$I4044 VDD VDD PMOS L=1u W=3.4u AS=10.88p AD=6.46p PS=13.2u
+ PD=7.2u
* device instance $1400 m0 *1 166,388.3 PMOS
XM$1400 VDD \$I4045 \$I4044 VDD PMOS L=1u W=3.4u AS=6.46p AD=10.88p PS=7.2u
+ PD=13.2u
* device instance $1401 m0 *1 156.6,408.7 NMOS
XM$1401 BL7 WL13 \$I4045 VSS NMOS L=1u W=3.4u AS=9.52p AD=6.12p PS=12.4u PD=7u
* device instance $1402 m0 *1 161.2,408.7 NMOS
XM$1402 \$I4045 \$I4044 VSS VSS NMOS L=1u W=3.4u AS=6.12p AD=6.46p PS=7u PD=7.2u
* device instance $1403 m0 *1 166,408.7 NMOS
XM$1403 VSS \$I4045 \$I4044 VSS NMOS L=1u W=3.4u AS=6.46p AD=6.12p PS=7.2u PD=7u
* device instance $1404 m0 *1 170.6,408.7 NMOS
XM$1404 \$I4044 WL13 BLB7 VSS NMOS L=1u W=3.4u AS=6.12p AD=9.52p PS=7u PD=12.4u
* device instance $1405 m0 *1 161.2,329.1 PMOS
XM$1405 \$I4047 \$I4046 VDD VDD PMOS L=1u W=3.4u AS=10.88p AD=6.46p PS=13.2u
+ PD=7.2u
* device instance $1406 m0 *1 166,329.1 PMOS
XM$1406 VDD \$I4047 \$I4046 VDD PMOS L=1u W=3.4u AS=6.46p AD=10.88p PS=7.2u
+ PD=13.2u
* device instance $1407 m0 *1 156.6,349.5 NMOS
XM$1407 BL7 WL11 \$I4047 VSS NMOS L=1u W=3.4u AS=9.52p AD=6.12p PS=12.4u PD=7u
* device instance $1408 m0 *1 161.2,349.5 NMOS
XM$1408 \$I4047 \$I4046 VSS VSS NMOS L=1u W=3.4u AS=6.12p AD=6.46p PS=7u PD=7.2u
* device instance $1409 m0 *1 166,349.5 NMOS
XM$1409 VSS \$I4047 \$I4046 VSS NMOS L=1u W=3.4u AS=6.46p AD=6.12p PS=7.2u PD=7u
* device instance $1410 m0 *1 170.6,349.5 NMOS
XM$1410 \$I4046 WL11 BLB7 VSS NMOS L=1u W=3.4u AS=6.12p AD=9.52p PS=7u PD=12.4u
* device instance $1411 r0 *1 161.2,440.5 PMOS
XM$1411 \$I4049 \$I4048 VDD VDD PMOS L=1u W=3.4u AS=10.88p AD=6.46p PS=13.2u
+ PD=7.2u
* device instance $1412 r0 *1 166,440.5 PMOS
XM$1412 VDD \$I4049 \$I4048 VDD PMOS L=1u W=3.4u AS=6.46p AD=10.88p PS=7.2u
+ PD=13.2u
* device instance $1413 r0 *1 156.6,420.1 NMOS
XM$1413 BL7 WL14 \$I4049 VSS NMOS L=1u W=3.4u AS=9.52p AD=6.12p PS=12.4u PD=7u
* device instance $1414 r0 *1 161.2,420.1 NMOS
XM$1414 \$I4049 \$I4048 VSS VSS NMOS L=1u W=3.4u AS=6.12p AD=6.46p PS=7u PD=7.2u
* device instance $1415 r0 *1 166,420.1 NMOS
XM$1415 VSS \$I4049 \$I4048 VSS NMOS L=1u W=3.4u AS=6.46p AD=6.12p PS=7.2u PD=7u
* device instance $1416 r0 *1 170.6,420.1 NMOS
XM$1416 \$I4048 WL14 BLB7 VSS NMOS L=1u W=3.4u AS=6.12p AD=9.52p PS=7u PD=12.4u
* device instance $1417 r0 *1 161.2,85.3 PMOS
XM$1417 \$I4051 \$I4050 VDD VDD PMOS L=1u W=3.4u AS=10.88p AD=6.46p PS=13.2u
+ PD=7.2u
* device instance $1418 r0 *1 166,85.3 PMOS
XM$1418 VDD \$I4051 \$I4050 VDD PMOS L=1u W=3.4u AS=6.46p AD=10.88p PS=7.2u
+ PD=13.2u
* device instance $1419 r0 *1 156.6,64.9 NMOS
XM$1419 BL7 WL2 \$I4051 VSS NMOS L=1u W=3.4u AS=9.52p AD=6.12p PS=12.4u PD=7u
* device instance $1420 r0 *1 161.2,64.9 NMOS
XM$1420 \$I4051 \$I4050 VSS VSS NMOS L=1u W=3.4u AS=6.12p AD=6.46p PS=7u PD=7.2u
* device instance $1421 r0 *1 166,64.9 NMOS
XM$1421 VSS \$I4051 \$I4050 VSS NMOS L=1u W=3.4u AS=6.46p AD=6.12p PS=7.2u PD=7u
* device instance $1422 r0 *1 170.6,64.9 NMOS
XM$1422 \$I4050 WL2 BLB7 VSS NMOS L=1u W=3.4u AS=6.12p AD=9.52p PS=7u PD=12.4u
* device instance $1423 r0 *1 161.2,262.9 PMOS
XM$1423 \$I4053 \$I4052 VDD VDD PMOS L=1u W=3.4u AS=10.88p AD=6.46p PS=13.2u
+ PD=7.2u
* device instance $1424 r0 *1 166,262.9 PMOS
XM$1424 VDD \$I4053 \$I4052 VDD PMOS L=1u W=3.4u AS=6.46p AD=10.88p PS=7.2u
+ PD=13.2u
* device instance $1425 r0 *1 156.6,242.5 NMOS
XM$1425 BL7 WL8 \$I4053 VSS NMOS L=1u W=3.4u AS=9.52p AD=6.12p PS=12.4u PD=7u
* device instance $1426 r0 *1 161.2,242.5 NMOS
XM$1426 \$I4053 \$I4052 VSS VSS NMOS L=1u W=3.4u AS=6.12p AD=6.46p PS=7u PD=7.2u
* device instance $1427 r0 *1 166,242.5 NMOS
XM$1427 VSS \$I4053 \$I4052 VSS NMOS L=1u W=3.4u AS=6.46p AD=6.12p PS=7.2u PD=7u
* device instance $1428 r0 *1 170.6,242.5 NMOS
XM$1428 \$I4052 WL8 BLB7 VSS NMOS L=1u W=3.4u AS=6.12p AD=9.52p PS=7u PD=12.4u
* device instance $1429 r0 *1 161.2,381.3 PMOS
XM$1429 \$I4055 \$I4054 VDD VDD PMOS L=1u W=3.4u AS=10.88p AD=6.46p PS=13.2u
+ PD=7.2u
* device instance $1430 r0 *1 166,381.3 PMOS
XM$1430 VDD \$I4055 \$I4054 VDD PMOS L=1u W=3.4u AS=6.46p AD=10.88p PS=7.2u
+ PD=13.2u
* device instance $1431 r0 *1 156.6,360.9 NMOS
XM$1431 BL7 WL12 \$I4055 VSS NMOS L=1u W=3.4u AS=9.52p AD=6.12p PS=12.4u PD=7u
* device instance $1432 r0 *1 161.2,360.9 NMOS
XM$1432 \$I4055 \$I4054 VSS VSS NMOS L=1u W=3.4u AS=6.12p AD=6.46p PS=7u PD=7.2u
* device instance $1433 r0 *1 166,360.9 NMOS
XM$1433 VSS \$I4055 \$I4054 VSS NMOS L=1u W=3.4u AS=6.46p AD=6.12p PS=7.2u PD=7u
* device instance $1434 r0 *1 170.6,360.9 NMOS
XM$1434 \$I4054 WL12 BLB7 VSS NMOS L=1u W=3.4u AS=6.12p AD=9.52p PS=7u PD=12.4u
* device instance $1435 r0 *1 161.2,322.1 PMOS
XM$1435 \$I4057 \$I4056 VDD VDD PMOS L=1u W=3.4u AS=10.88p AD=6.46p PS=13.2u
+ PD=7.2u
* device instance $1436 r0 *1 166,322.1 PMOS
XM$1436 VDD \$I4057 \$I4056 VDD PMOS L=1u W=3.4u AS=6.46p AD=10.88p PS=7.2u
+ PD=13.2u
* device instance $1437 r0 *1 156.6,301.7 NMOS
XM$1437 BL7 WL10 \$I4057 VSS NMOS L=1u W=3.4u AS=9.52p AD=6.12p PS=12.4u PD=7u
* device instance $1438 r0 *1 161.2,301.7 NMOS
XM$1438 \$I4057 \$I4056 VSS VSS NMOS L=1u W=3.4u AS=6.12p AD=6.46p PS=7u PD=7.2u
* device instance $1439 r0 *1 166,301.7 NMOS
XM$1439 VSS \$I4057 \$I4056 VSS NMOS L=1u W=3.4u AS=6.46p AD=6.12p PS=7.2u PD=7u
* device instance $1440 r0 *1 170.6,301.7 NMOS
XM$1440 \$I4056 WL10 BLB7 VSS NMOS L=1u W=3.4u AS=6.12p AD=9.52p PS=7u PD=12.4u
* device instance $1441 r0 *1 161.2,144.5 PMOS
XM$1441 \$I4059 \$I4058 VDD VDD PMOS L=1u W=3.4u AS=10.88p AD=6.46p PS=13.2u
+ PD=7.2u
* device instance $1442 r0 *1 166,144.5 PMOS
XM$1442 VDD \$I4059 \$I4058 VDD PMOS L=1u W=3.4u AS=6.46p AD=10.88p PS=7.2u
+ PD=13.2u
* device instance $1443 r0 *1 156.6,124.1 NMOS
XM$1443 BL7 WL4 \$I4059 VSS NMOS L=1u W=3.4u AS=9.52p AD=6.12p PS=12.4u PD=7u
* device instance $1444 r0 *1 161.2,124.1 NMOS
XM$1444 \$I4059 \$I4058 VSS VSS NMOS L=1u W=3.4u AS=6.12p AD=6.46p PS=7u PD=7.2u
* device instance $1445 r0 *1 166,124.1 NMOS
XM$1445 VSS \$I4059 \$I4058 VSS NMOS L=1u W=3.4u AS=6.46p AD=6.12p PS=7.2u PD=7u
* device instance $1446 r0 *1 170.6,124.1 NMOS
XM$1446 \$I4058 WL4 BLB7 VSS NMOS L=1u W=3.4u AS=6.12p AD=9.52p PS=7u PD=12.4u
* device instance $1447 r0 *1 161.2,203.7 PMOS
XM$1447 \$I4061 \$I4060 VDD VDD PMOS L=1u W=3.4u AS=10.88p AD=6.46p PS=13.2u
+ PD=7.2u
* device instance $1448 r0 *1 166,203.7 PMOS
XM$1448 VDD \$I4061 \$I4060 VDD PMOS L=1u W=3.4u AS=6.46p AD=10.88p PS=7.2u
+ PD=13.2u
* device instance $1449 r0 *1 156.6,183.3 NMOS
XM$1449 BL7 WL6 \$I4061 VSS NMOS L=1u W=3.4u AS=9.52p AD=6.12p PS=12.4u PD=7u
* device instance $1450 r0 *1 161.2,183.3 NMOS
XM$1450 \$I4061 \$I4060 VSS VSS NMOS L=1u W=3.4u AS=6.12p AD=6.46p PS=7u PD=7.2u
* device instance $1451 r0 *1 166,183.3 NMOS
XM$1451 VSS \$I4061 \$I4060 VSS NMOS L=1u W=3.4u AS=6.46p AD=6.12p PS=7.2u PD=7u
* device instance $1452 r0 *1 170.6,183.3 NMOS
XM$1452 \$I4060 WL6 BLB7 VSS NMOS L=1u W=3.4u AS=6.12p AD=9.52p PS=7u PD=12.4u
* device instance $1453 m0 *1 139.2,269.9 PMOS
XM$1453 \$I4063 \$I4062 VDD VDD PMOS L=1u W=3.4u AS=10.88p AD=6.46p PS=13.2u
+ PD=7.2u
* device instance $1454 m0 *1 144,269.9 PMOS
XM$1454 VDD \$I4063 \$I4062 VDD PMOS L=1u W=3.4u AS=6.46p AD=10.88p PS=7.2u
+ PD=13.2u
* device instance $1455 m0 *1 134.6,290.3 NMOS
XM$1455 BL6 WL9 \$I4063 VSS NMOS L=1u W=3.4u AS=9.52p AD=6.12p PS=12.4u PD=7u
* device instance $1456 m0 *1 139.2,290.3 NMOS
XM$1456 \$I4063 \$I4062 VSS VSS NMOS L=1u W=3.4u AS=6.12p AD=6.46p PS=7u PD=7.2u
* device instance $1457 m0 *1 144,290.3 NMOS
XM$1457 VSS \$I4063 \$I4062 VSS NMOS L=1u W=3.4u AS=6.46p AD=6.12p PS=7.2u PD=7u
* device instance $1458 m0 *1 148.6,290.3 NMOS
XM$1458 \$I4062 WL9 BLB6 VSS NMOS L=1u W=3.4u AS=6.12p AD=9.52p PS=7u PD=12.4u
* device instance $1459 m0 *1 139.2,33.1 PMOS
XM$1459 \$I4065 \$I4064 VDD VDD PMOS L=1u W=3.4u AS=10.88p AD=6.46p PS=13.2u
+ PD=7.2u
* device instance $1460 m0 *1 144,33.1 PMOS
XM$1460 VDD \$I4065 \$I4064 VDD PMOS L=1u W=3.4u AS=6.46p AD=10.88p PS=7.2u
+ PD=13.2u
* device instance $1461 m0 *1 134.6,53.5 NMOS
XM$1461 BL6 WL1 \$I4065 VSS NMOS L=1u W=3.4u AS=9.52p AD=6.12p PS=12.4u PD=7u
* device instance $1462 m0 *1 139.2,53.5 NMOS
XM$1462 \$I4065 \$I4064 VSS VSS NMOS L=1u W=3.4u AS=6.12p AD=6.46p PS=7u PD=7.2u
* device instance $1463 m0 *1 144,53.5 NMOS
XM$1463 VSS \$I4065 \$I4064 VSS NMOS L=1u W=3.4u AS=6.46p AD=6.12p PS=7.2u PD=7u
* device instance $1464 m0 *1 148.6,53.5 NMOS
XM$1464 \$I4064 WL1 BLB6 VSS NMOS L=1u W=3.4u AS=6.12p AD=9.52p PS=7u PD=12.4u
* device instance $1465 m0 *1 139.2,210.7 PMOS
XM$1465 \$I4067 \$I4066 VDD VDD PMOS L=1u W=3.4u AS=10.88p AD=6.46p PS=13.2u
+ PD=7.2u
* device instance $1466 m0 *1 144,210.7 PMOS
XM$1466 VDD \$I4067 \$I4066 VDD PMOS L=1u W=3.4u AS=6.46p AD=10.88p PS=7.2u
+ PD=13.2u
* device instance $1467 m0 *1 134.6,231.1 NMOS
XM$1467 BL6 WL7 \$I4067 VSS NMOS L=1u W=3.4u AS=9.52p AD=6.12p PS=12.4u PD=7u
* device instance $1468 m0 *1 139.2,231.1 NMOS
XM$1468 \$I4067 \$I4066 VSS VSS NMOS L=1u W=3.4u AS=6.12p AD=6.46p PS=7u PD=7.2u
* device instance $1469 m0 *1 144,231.1 NMOS
XM$1469 VSS \$I4067 \$I4066 VSS NMOS L=1u W=3.4u AS=6.46p AD=6.12p PS=7.2u PD=7u
* device instance $1470 m0 *1 148.6,231.1 NMOS
XM$1470 \$I4066 WL7 BLB6 VSS NMOS L=1u W=3.4u AS=6.12p AD=9.52p PS=7u PD=12.4u
* device instance $1471 m0 *1 139.2,92.3 PMOS
XM$1471 \$I4069 \$I4068 VDD VDD PMOS L=1u W=3.4u AS=10.88p AD=6.46p PS=13.2u
+ PD=7.2u
* device instance $1472 m0 *1 144,92.3 PMOS
XM$1472 VDD \$I4069 \$I4068 VDD PMOS L=1u W=3.4u AS=6.46p AD=10.88p PS=7.2u
+ PD=13.2u
* device instance $1473 m0 *1 134.6,112.7 NMOS
XM$1473 BL6 WL3 \$I4069 VSS NMOS L=1u W=3.4u AS=9.52p AD=6.12p PS=12.4u PD=7u
* device instance $1474 m0 *1 139.2,112.7 NMOS
XM$1474 \$I4069 \$I4068 VSS VSS NMOS L=1u W=3.4u AS=6.12p AD=6.46p PS=7u PD=7.2u
* device instance $1475 m0 *1 144,112.7 NMOS
XM$1475 VSS \$I4069 \$I4068 VSS NMOS L=1u W=3.4u AS=6.46p AD=6.12p PS=7.2u PD=7u
* device instance $1476 m0 *1 148.6,112.7 NMOS
XM$1476 \$I4068 WL3 BLB6 VSS NMOS L=1u W=3.4u AS=6.12p AD=9.52p PS=7u PD=12.4u
* device instance $1477 m0 *1 139.2,151.5 PMOS
XM$1477 \$I4071 \$I4070 VDD VDD PMOS L=1u W=3.4u AS=10.88p AD=6.46p PS=13.2u
+ PD=7.2u
* device instance $1478 m0 *1 144,151.5 PMOS
XM$1478 VDD \$I4071 \$I4070 VDD PMOS L=1u W=3.4u AS=6.46p AD=10.88p PS=7.2u
+ PD=13.2u
* device instance $1479 m0 *1 134.6,171.9 NMOS
XM$1479 BL6 WL5 \$I4071 VSS NMOS L=1u W=3.4u AS=9.52p AD=6.12p PS=12.4u PD=7u
* device instance $1480 m0 *1 139.2,171.9 NMOS
XM$1480 \$I4071 \$I4070 VSS VSS NMOS L=1u W=3.4u AS=6.12p AD=6.46p PS=7u PD=7.2u
* device instance $1481 m0 *1 144,171.9 NMOS
XM$1481 VSS \$I4071 \$I4070 VSS NMOS L=1u W=3.4u AS=6.46p AD=6.12p PS=7.2u PD=7u
* device instance $1482 m0 *1 148.6,171.9 NMOS
XM$1482 \$I4070 WL5 BLB6 VSS NMOS L=1u W=3.4u AS=6.12p AD=9.52p PS=7u PD=12.4u
* device instance $1483 m0 *1 139.2,447.5 PMOS
XM$1483 \$I4073 \$I4072 VDD VDD PMOS L=1u W=3.4u AS=10.88p AD=6.46p PS=13.2u
+ PD=7.2u
* device instance $1484 m0 *1 144,447.5 PMOS
XM$1484 VDD \$I4073 \$I4072 VDD PMOS L=1u W=3.4u AS=6.46p AD=10.88p PS=7.2u
+ PD=13.2u
* device instance $1485 m0 *1 134.6,467.9 NMOS
XM$1485 BL6 WL15 \$I4073 VSS NMOS L=1u W=3.4u AS=9.52p AD=6.12p PS=12.4u PD=7u
* device instance $1486 m0 *1 139.2,467.9 NMOS
XM$1486 \$I4073 \$I4072 VSS VSS NMOS L=1u W=3.4u AS=6.12p AD=6.46p PS=7u PD=7.2u
* device instance $1487 m0 *1 144,467.9 NMOS
XM$1487 VSS \$I4073 \$I4072 VSS NMOS L=1u W=3.4u AS=6.46p AD=6.12p PS=7.2u PD=7u
* device instance $1488 m0 *1 148.6,467.9 NMOS
XM$1488 \$I4072 WL15 BLB6 VSS NMOS L=1u W=3.4u AS=6.12p AD=9.52p PS=7u PD=12.4u
* device instance $1489 m0 *1 139.2,388.3 PMOS
XM$1489 \$I4075 \$I4074 VDD VDD PMOS L=1u W=3.4u AS=10.88p AD=6.46p PS=13.2u
+ PD=7.2u
* device instance $1490 m0 *1 144,388.3 PMOS
XM$1490 VDD \$I4075 \$I4074 VDD PMOS L=1u W=3.4u AS=6.46p AD=10.88p PS=7.2u
+ PD=13.2u
* device instance $1491 m0 *1 134.6,408.7 NMOS
XM$1491 BL6 WL13 \$I4075 VSS NMOS L=1u W=3.4u AS=9.52p AD=6.12p PS=12.4u PD=7u
* device instance $1492 m0 *1 139.2,408.7 NMOS
XM$1492 \$I4075 \$I4074 VSS VSS NMOS L=1u W=3.4u AS=6.12p AD=6.46p PS=7u PD=7.2u
* device instance $1493 m0 *1 144,408.7 NMOS
XM$1493 VSS \$I4075 \$I4074 VSS NMOS L=1u W=3.4u AS=6.46p AD=6.12p PS=7.2u PD=7u
* device instance $1494 m0 *1 148.6,408.7 NMOS
XM$1494 \$I4074 WL13 BLB6 VSS NMOS L=1u W=3.4u AS=6.12p AD=9.52p PS=7u PD=12.4u
* device instance $1495 m0 *1 139.2,329.1 PMOS
XM$1495 \$I4077 \$I4076 VDD VDD PMOS L=1u W=3.4u AS=10.88p AD=6.46p PS=13.2u
+ PD=7.2u
* device instance $1496 m0 *1 144,329.1 PMOS
XM$1496 VDD \$I4077 \$I4076 VDD PMOS L=1u W=3.4u AS=6.46p AD=10.88p PS=7.2u
+ PD=13.2u
* device instance $1497 m0 *1 134.6,349.5 NMOS
XM$1497 BL6 WL11 \$I4077 VSS NMOS L=1u W=3.4u AS=9.52p AD=6.12p PS=12.4u PD=7u
* device instance $1498 m0 *1 139.2,349.5 NMOS
XM$1498 \$I4077 \$I4076 VSS VSS NMOS L=1u W=3.4u AS=6.12p AD=6.46p PS=7u PD=7.2u
* device instance $1499 m0 *1 144,349.5 NMOS
XM$1499 VSS \$I4077 \$I4076 VSS NMOS L=1u W=3.4u AS=6.46p AD=6.12p PS=7.2u PD=7u
* device instance $1500 m0 *1 148.6,349.5 NMOS
XM$1500 \$I4076 WL11 BLB6 VSS NMOS L=1u W=3.4u AS=6.12p AD=9.52p PS=7u PD=12.4u
* device instance $1501 r0 *1 139.2,440.5 PMOS
XM$1501 \$I4079 \$I4078 VDD VDD PMOS L=1u W=3.4u AS=10.88p AD=6.46p PS=13.2u
+ PD=7.2u
* device instance $1502 r0 *1 144,440.5 PMOS
XM$1502 VDD \$I4079 \$I4078 VDD PMOS L=1u W=3.4u AS=6.46p AD=10.88p PS=7.2u
+ PD=13.2u
* device instance $1503 r0 *1 134.6,420.1 NMOS
XM$1503 BL6 WL14 \$I4079 VSS NMOS L=1u W=3.4u AS=9.52p AD=6.12p PS=12.4u PD=7u
* device instance $1504 r0 *1 139.2,420.1 NMOS
XM$1504 \$I4079 \$I4078 VSS VSS NMOS L=1u W=3.4u AS=6.12p AD=6.46p PS=7u PD=7.2u
* device instance $1505 r0 *1 144,420.1 NMOS
XM$1505 VSS \$I4079 \$I4078 VSS NMOS L=1u W=3.4u AS=6.46p AD=6.12p PS=7.2u PD=7u
* device instance $1506 r0 *1 148.6,420.1 NMOS
XM$1506 \$I4078 WL14 BLB6 VSS NMOS L=1u W=3.4u AS=6.12p AD=9.52p PS=7u PD=12.4u
* device instance $1507 r0 *1 139.2,85.3 PMOS
XM$1507 \$I4081 \$I4080 VDD VDD PMOS L=1u W=3.4u AS=10.88p AD=6.46p PS=13.2u
+ PD=7.2u
* device instance $1508 r0 *1 144,85.3 PMOS
XM$1508 VDD \$I4081 \$I4080 VDD PMOS L=1u W=3.4u AS=6.46p AD=10.88p PS=7.2u
+ PD=13.2u
* device instance $1509 r0 *1 134.6,64.9 NMOS
XM$1509 BL6 WL2 \$I4081 VSS NMOS L=1u W=3.4u AS=9.52p AD=6.12p PS=12.4u PD=7u
* device instance $1510 r0 *1 139.2,64.9 NMOS
XM$1510 \$I4081 \$I4080 VSS VSS NMOS L=1u W=3.4u AS=6.12p AD=6.46p PS=7u PD=7.2u
* device instance $1511 r0 *1 144,64.9 NMOS
XM$1511 VSS \$I4081 \$I4080 VSS NMOS L=1u W=3.4u AS=6.46p AD=6.12p PS=7.2u PD=7u
* device instance $1512 r0 *1 148.6,64.9 NMOS
XM$1512 \$I4080 WL2 BLB6 VSS NMOS L=1u W=3.4u AS=6.12p AD=9.52p PS=7u PD=12.4u
* device instance $1513 r0 *1 139.2,262.9 PMOS
XM$1513 \$I4083 \$I4082 VDD VDD PMOS L=1u W=3.4u AS=10.88p AD=6.46p PS=13.2u
+ PD=7.2u
* device instance $1514 r0 *1 144,262.9 PMOS
XM$1514 VDD \$I4083 \$I4082 VDD PMOS L=1u W=3.4u AS=6.46p AD=10.88p PS=7.2u
+ PD=13.2u
* device instance $1515 r0 *1 134.6,242.5 NMOS
XM$1515 BL6 WL8 \$I4083 VSS NMOS L=1u W=3.4u AS=9.52p AD=6.12p PS=12.4u PD=7u
* device instance $1516 r0 *1 139.2,242.5 NMOS
XM$1516 \$I4083 \$I4082 VSS VSS NMOS L=1u W=3.4u AS=6.12p AD=6.46p PS=7u PD=7.2u
* device instance $1517 r0 *1 144,242.5 NMOS
XM$1517 VSS \$I4083 \$I4082 VSS NMOS L=1u W=3.4u AS=6.46p AD=6.12p PS=7.2u PD=7u
* device instance $1518 r0 *1 148.6,242.5 NMOS
XM$1518 \$I4082 WL8 BLB6 VSS NMOS L=1u W=3.4u AS=6.12p AD=9.52p PS=7u PD=12.4u
* device instance $1519 r0 *1 139.2,381.3 PMOS
XM$1519 \$I4085 \$I4084 VDD VDD PMOS L=1u W=3.4u AS=10.88p AD=6.46p PS=13.2u
+ PD=7.2u
* device instance $1520 r0 *1 144,381.3 PMOS
XM$1520 VDD \$I4085 \$I4084 VDD PMOS L=1u W=3.4u AS=6.46p AD=10.88p PS=7.2u
+ PD=13.2u
* device instance $1521 r0 *1 134.6,360.9 NMOS
XM$1521 BL6 WL12 \$I4085 VSS NMOS L=1u W=3.4u AS=9.52p AD=6.12p PS=12.4u PD=7u
* device instance $1522 r0 *1 139.2,360.9 NMOS
XM$1522 \$I4085 \$I4084 VSS VSS NMOS L=1u W=3.4u AS=6.12p AD=6.46p PS=7u PD=7.2u
* device instance $1523 r0 *1 144,360.9 NMOS
XM$1523 VSS \$I4085 \$I4084 VSS NMOS L=1u W=3.4u AS=6.46p AD=6.12p PS=7.2u PD=7u
* device instance $1524 r0 *1 148.6,360.9 NMOS
XM$1524 \$I4084 WL12 BLB6 VSS NMOS L=1u W=3.4u AS=6.12p AD=9.52p PS=7u PD=12.4u
* device instance $1525 r0 *1 139.2,322.1 PMOS
XM$1525 \$I4087 \$I4086 VDD VDD PMOS L=1u W=3.4u AS=10.88p AD=6.46p PS=13.2u
+ PD=7.2u
* device instance $1526 r0 *1 144,322.1 PMOS
XM$1526 VDD \$I4087 \$I4086 VDD PMOS L=1u W=3.4u AS=6.46p AD=10.88p PS=7.2u
+ PD=13.2u
* device instance $1527 r0 *1 134.6,301.7 NMOS
XM$1527 BL6 WL10 \$I4087 VSS NMOS L=1u W=3.4u AS=9.52p AD=6.12p PS=12.4u PD=7u
* device instance $1528 r0 *1 139.2,301.7 NMOS
XM$1528 \$I4087 \$I4086 VSS VSS NMOS L=1u W=3.4u AS=6.12p AD=6.46p PS=7u PD=7.2u
* device instance $1529 r0 *1 144,301.7 NMOS
XM$1529 VSS \$I4087 \$I4086 VSS NMOS L=1u W=3.4u AS=6.46p AD=6.12p PS=7.2u PD=7u
* device instance $1530 r0 *1 148.6,301.7 NMOS
XM$1530 \$I4086 WL10 BLB6 VSS NMOS L=1u W=3.4u AS=6.12p AD=9.52p PS=7u PD=12.4u
* device instance $1531 r0 *1 139.2,144.5 PMOS
XM$1531 \$I4089 \$I4088 VDD VDD PMOS L=1u W=3.4u AS=10.88p AD=6.46p PS=13.2u
+ PD=7.2u
* device instance $1532 r0 *1 144,144.5 PMOS
XM$1532 VDD \$I4089 \$I4088 VDD PMOS L=1u W=3.4u AS=6.46p AD=10.88p PS=7.2u
+ PD=13.2u
* device instance $1533 r0 *1 134.6,124.1 NMOS
XM$1533 BL6 WL4 \$I4089 VSS NMOS L=1u W=3.4u AS=9.52p AD=6.12p PS=12.4u PD=7u
* device instance $1534 r0 *1 139.2,124.1 NMOS
XM$1534 \$I4089 \$I4088 VSS VSS NMOS L=1u W=3.4u AS=6.12p AD=6.46p PS=7u PD=7.2u
* device instance $1535 r0 *1 144,124.1 NMOS
XM$1535 VSS \$I4089 \$I4088 VSS NMOS L=1u W=3.4u AS=6.46p AD=6.12p PS=7.2u PD=7u
* device instance $1536 r0 *1 148.6,124.1 NMOS
XM$1536 \$I4088 WL4 BLB6 VSS NMOS L=1u W=3.4u AS=6.12p AD=9.52p PS=7u PD=12.4u
* device instance $1537 r0 *1 139.2,203.7 PMOS
XM$1537 \$I4091 \$I4090 VDD VDD PMOS L=1u W=3.4u AS=10.88p AD=6.46p PS=13.2u
+ PD=7.2u
* device instance $1538 r0 *1 144,203.7 PMOS
XM$1538 VDD \$I4091 \$I4090 VDD PMOS L=1u W=3.4u AS=6.46p AD=10.88p PS=7.2u
+ PD=13.2u
* device instance $1539 r0 *1 134.6,183.3 NMOS
XM$1539 BL6 WL6 \$I4091 VSS NMOS L=1u W=3.4u AS=9.52p AD=6.12p PS=12.4u PD=7u
* device instance $1540 r0 *1 139.2,183.3 NMOS
XM$1540 \$I4091 \$I4090 VSS VSS NMOS L=1u W=3.4u AS=6.12p AD=6.46p PS=7u PD=7.2u
* device instance $1541 r0 *1 144,183.3 NMOS
XM$1541 VSS \$I4091 \$I4090 VSS NMOS L=1u W=3.4u AS=6.46p AD=6.12p PS=7.2u PD=7u
* device instance $1542 r0 *1 148.6,183.3 NMOS
XM$1542 \$I4090 WL6 BLB6 VSS NMOS L=1u W=3.4u AS=6.12p AD=9.52p PS=7u PD=12.4u
* device instance $1543 m0 *1 204.4,269.9 PMOS
XM$1543 \$I4093 \$I4092 VDD VDD PMOS L=1u W=3.4u AS=10.88p AD=6.46p PS=13.2u
+ PD=7.2u
* device instance $1544 m0 *1 209.2,269.9 PMOS
XM$1544 VDD \$I4093 \$I4092 VDD PMOS L=1u W=3.4u AS=6.46p AD=10.88p PS=7.2u
+ PD=13.2u
* device instance $1545 m0 *1 199.8,290.3 NMOS
XM$1545 BL8 WL9 \$I4093 VSS NMOS L=1u W=3.4u AS=9.52p AD=6.12p PS=12.4u PD=7u
* device instance $1546 m0 *1 204.4,290.3 NMOS
XM$1546 \$I4093 \$I4092 VSS VSS NMOS L=1u W=3.4u AS=6.12p AD=6.46p PS=7u PD=7.2u
* device instance $1547 m0 *1 209.2,290.3 NMOS
XM$1547 VSS \$I4093 \$I4092 VSS NMOS L=1u W=3.4u AS=6.46p AD=6.12p PS=7.2u PD=7u
* device instance $1548 m0 *1 213.8,290.3 NMOS
XM$1548 \$I4092 WL9 BLB8 VSS NMOS L=1u W=3.4u AS=6.12p AD=9.52p PS=7u PD=12.4u
* device instance $1549 m0 *1 204.4,447.5 PMOS
XM$1549 \$I4095 \$I4094 VDD VDD PMOS L=1u W=3.4u AS=10.88p AD=6.46p PS=13.2u
+ PD=7.2u
* device instance $1550 m0 *1 209.2,447.5 PMOS
XM$1550 VDD \$I4095 \$I4094 VDD PMOS L=1u W=3.4u AS=6.46p AD=10.88p PS=7.2u
+ PD=13.2u
* device instance $1551 m0 *1 199.8,467.9 NMOS
XM$1551 BL8 WL15 \$I4095 VSS NMOS L=1u W=3.4u AS=9.52p AD=6.12p PS=12.4u PD=7u
* device instance $1552 m0 *1 204.4,467.9 NMOS
XM$1552 \$I4095 \$I4094 VSS VSS NMOS L=1u W=3.4u AS=6.12p AD=6.46p PS=7u PD=7.2u
* device instance $1553 m0 *1 209.2,467.9 NMOS
XM$1553 VSS \$I4095 \$I4094 VSS NMOS L=1u W=3.4u AS=6.46p AD=6.12p PS=7.2u PD=7u
* device instance $1554 m0 *1 213.8,467.9 NMOS
XM$1554 \$I4094 WL15 BLB8 VSS NMOS L=1u W=3.4u AS=6.12p AD=9.52p PS=7u PD=12.4u
* device instance $1555 m0 *1 204.4,329.1 PMOS
XM$1555 \$I4097 \$I4096 VDD VDD PMOS L=1u W=3.4u AS=10.88p AD=6.46p PS=13.2u
+ PD=7.2u
* device instance $1556 m0 *1 209.2,329.1 PMOS
XM$1556 VDD \$I4097 \$I4096 VDD PMOS L=1u W=3.4u AS=6.46p AD=10.88p PS=7.2u
+ PD=13.2u
* device instance $1557 m0 *1 199.8,349.5 NMOS
XM$1557 BL8 WL11 \$I4097 VSS NMOS L=1u W=3.4u AS=9.52p AD=6.12p PS=12.4u PD=7u
* device instance $1558 m0 *1 204.4,349.5 NMOS
XM$1558 \$I4097 \$I4096 VSS VSS NMOS L=1u W=3.4u AS=6.12p AD=6.46p PS=7u PD=7.2u
* device instance $1559 m0 *1 209.2,349.5 NMOS
XM$1559 VSS \$I4097 \$I4096 VSS NMOS L=1u W=3.4u AS=6.46p AD=6.12p PS=7.2u PD=7u
* device instance $1560 m0 *1 213.8,349.5 NMOS
XM$1560 \$I4096 WL11 BLB8 VSS NMOS L=1u W=3.4u AS=6.12p AD=9.52p PS=7u PD=12.4u
* device instance $1561 m0 *1 204.4,33.1 PMOS
XM$1561 \$I4099 \$I4098 VDD VDD PMOS L=1u W=3.4u AS=10.88p AD=6.46p PS=13.2u
+ PD=7.2u
* device instance $1562 m0 *1 209.2,33.1 PMOS
XM$1562 VDD \$I4099 \$I4098 VDD PMOS L=1u W=3.4u AS=6.46p AD=10.88p PS=7.2u
+ PD=13.2u
* device instance $1563 m0 *1 199.8,53.5 NMOS
XM$1563 BL8 WL1 \$I4099 VSS NMOS L=1u W=3.4u AS=9.52p AD=6.12p PS=12.4u PD=7u
* device instance $1564 m0 *1 204.4,53.5 NMOS
XM$1564 \$I4099 \$I4098 VSS VSS NMOS L=1u W=3.4u AS=6.12p AD=6.46p PS=7u PD=7.2u
* device instance $1565 m0 *1 209.2,53.5 NMOS
XM$1565 VSS \$I4099 \$I4098 VSS NMOS L=1u W=3.4u AS=6.46p AD=6.12p PS=7.2u PD=7u
* device instance $1566 m0 *1 213.8,53.5 NMOS
XM$1566 \$I4098 WL1 BLB8 VSS NMOS L=1u W=3.4u AS=6.12p AD=9.52p PS=7u PD=12.4u
* device instance $1567 m0 *1 204.4,151.5 PMOS
XM$1567 \$I4101 \$I4100 VDD VDD PMOS L=1u W=3.4u AS=10.88p AD=6.46p PS=13.2u
+ PD=7.2u
* device instance $1568 m0 *1 209.2,151.5 PMOS
XM$1568 VDD \$I4101 \$I4100 VDD PMOS L=1u W=3.4u AS=6.46p AD=10.88p PS=7.2u
+ PD=13.2u
* device instance $1569 m0 *1 199.8,171.9 NMOS
XM$1569 BL8 WL5 \$I4101 VSS NMOS L=1u W=3.4u AS=9.52p AD=6.12p PS=12.4u PD=7u
* device instance $1570 m0 *1 204.4,171.9 NMOS
XM$1570 \$I4101 \$I4100 VSS VSS NMOS L=1u W=3.4u AS=6.12p AD=6.46p PS=7u PD=7.2u
* device instance $1571 m0 *1 209.2,171.9 NMOS
XM$1571 VSS \$I4101 \$I4100 VSS NMOS L=1u W=3.4u AS=6.46p AD=6.12p PS=7.2u PD=7u
* device instance $1572 m0 *1 213.8,171.9 NMOS
XM$1572 \$I4100 WL5 BLB8 VSS NMOS L=1u W=3.4u AS=6.12p AD=9.52p PS=7u PD=12.4u
* device instance $1573 m0 *1 204.4,388.3 PMOS
XM$1573 \$I4103 \$I4102 VDD VDD PMOS L=1u W=3.4u AS=10.88p AD=6.46p PS=13.2u
+ PD=7.2u
* device instance $1574 m0 *1 209.2,388.3 PMOS
XM$1574 VDD \$I4103 \$I4102 VDD PMOS L=1u W=3.4u AS=6.46p AD=10.88p PS=7.2u
+ PD=13.2u
* device instance $1575 m0 *1 199.8,408.7 NMOS
XM$1575 BL8 WL13 \$I4103 VSS NMOS L=1u W=3.4u AS=9.52p AD=6.12p PS=12.4u PD=7u
* device instance $1576 m0 *1 204.4,408.7 NMOS
XM$1576 \$I4103 \$I4102 VSS VSS NMOS L=1u W=3.4u AS=6.12p AD=6.46p PS=7u PD=7.2u
* device instance $1577 m0 *1 209.2,408.7 NMOS
XM$1577 VSS \$I4103 \$I4102 VSS NMOS L=1u W=3.4u AS=6.46p AD=6.12p PS=7.2u PD=7u
* device instance $1578 m0 *1 213.8,408.7 NMOS
XM$1578 \$I4102 WL13 BLB8 VSS NMOS L=1u W=3.4u AS=6.12p AD=9.52p PS=7u PD=12.4u
* device instance $1579 m0 *1 204.4,210.7 PMOS
XM$1579 \$I4105 \$I4104 VDD VDD PMOS L=1u W=3.4u AS=10.88p AD=6.46p PS=13.2u
+ PD=7.2u
* device instance $1580 m0 *1 209.2,210.7 PMOS
XM$1580 VDD \$I4105 \$I4104 VDD PMOS L=1u W=3.4u AS=6.46p AD=10.88p PS=7.2u
+ PD=13.2u
* device instance $1581 m0 *1 199.8,231.1 NMOS
XM$1581 BL8 WL7 \$I4105 VSS NMOS L=1u W=3.4u AS=9.52p AD=6.12p PS=12.4u PD=7u
* device instance $1582 m0 *1 204.4,231.1 NMOS
XM$1582 \$I4105 \$I4104 VSS VSS NMOS L=1u W=3.4u AS=6.12p AD=6.46p PS=7u PD=7.2u
* device instance $1583 m0 *1 209.2,231.1 NMOS
XM$1583 VSS \$I4105 \$I4104 VSS NMOS L=1u W=3.4u AS=6.46p AD=6.12p PS=7.2u PD=7u
* device instance $1584 m0 *1 213.8,231.1 NMOS
XM$1584 \$I4104 WL7 BLB8 VSS NMOS L=1u W=3.4u AS=6.12p AD=9.52p PS=7u PD=12.4u
* device instance $1585 m0 *1 204.4,92.3 PMOS
XM$1585 \$I4107 \$I4106 VDD VDD PMOS L=1u W=3.4u AS=10.88p AD=6.46p PS=13.2u
+ PD=7.2u
* device instance $1586 m0 *1 209.2,92.3 PMOS
XM$1586 VDD \$I4107 \$I4106 VDD PMOS L=1u W=3.4u AS=6.46p AD=10.88p PS=7.2u
+ PD=13.2u
* device instance $1587 m0 *1 199.8,112.7 NMOS
XM$1587 BL8 WL3 \$I4107 VSS NMOS L=1u W=3.4u AS=9.52p AD=6.12p PS=12.4u PD=7u
* device instance $1588 m0 *1 204.4,112.7 NMOS
XM$1588 \$I4107 \$I4106 VSS VSS NMOS L=1u W=3.4u AS=6.12p AD=6.46p PS=7u PD=7.2u
* device instance $1589 m0 *1 209.2,112.7 NMOS
XM$1589 VSS \$I4107 \$I4106 VSS NMOS L=1u W=3.4u AS=6.46p AD=6.12p PS=7.2u PD=7u
* device instance $1590 m0 *1 213.8,112.7 NMOS
XM$1590 \$I4106 WL3 BLB8 VSS NMOS L=1u W=3.4u AS=6.12p AD=9.52p PS=7u PD=12.4u
* device instance $1591 r0 *1 204.4,440.5 PMOS
XM$1591 \$I4109 \$I4108 VDD VDD PMOS L=1u W=3.4u AS=10.88p AD=6.46p PS=13.2u
+ PD=7.2u
* device instance $1592 r0 *1 209.2,440.5 PMOS
XM$1592 VDD \$I4109 \$I4108 VDD PMOS L=1u W=3.4u AS=6.46p AD=10.88p PS=7.2u
+ PD=13.2u
* device instance $1593 r0 *1 199.8,420.1 NMOS
XM$1593 BL8 WL14 \$I4109 VSS NMOS L=1u W=3.4u AS=9.52p AD=6.12p PS=12.4u PD=7u
* device instance $1594 r0 *1 204.4,420.1 NMOS
XM$1594 \$I4109 \$I4108 VSS VSS NMOS L=1u W=3.4u AS=6.12p AD=6.46p PS=7u PD=7.2u
* device instance $1595 r0 *1 209.2,420.1 NMOS
XM$1595 VSS \$I4109 \$I4108 VSS NMOS L=1u W=3.4u AS=6.46p AD=6.12p PS=7.2u PD=7u
* device instance $1596 r0 *1 213.8,420.1 NMOS
XM$1596 \$I4108 WL14 BLB8 VSS NMOS L=1u W=3.4u AS=6.12p AD=9.52p PS=7u PD=12.4u
* device instance $1597 r0 *1 204.4,381.3 PMOS
XM$1597 \$I4111 \$I4110 VDD VDD PMOS L=1u W=3.4u AS=10.88p AD=6.46p PS=13.2u
+ PD=7.2u
* device instance $1598 r0 *1 209.2,381.3 PMOS
XM$1598 VDD \$I4111 \$I4110 VDD PMOS L=1u W=3.4u AS=6.46p AD=10.88p PS=7.2u
+ PD=13.2u
* device instance $1599 r0 *1 199.8,360.9 NMOS
XM$1599 BL8 WL12 \$I4111 VSS NMOS L=1u W=3.4u AS=9.52p AD=6.12p PS=12.4u PD=7u
* device instance $1600 r0 *1 204.4,360.9 NMOS
XM$1600 \$I4111 \$I4110 VSS VSS NMOS L=1u W=3.4u AS=6.12p AD=6.46p PS=7u PD=7.2u
* device instance $1601 r0 *1 209.2,360.9 NMOS
XM$1601 VSS \$I4111 \$I4110 VSS NMOS L=1u W=3.4u AS=6.46p AD=6.12p PS=7.2u PD=7u
* device instance $1602 r0 *1 213.8,360.9 NMOS
XM$1602 \$I4110 WL12 BLB8 VSS NMOS L=1u W=3.4u AS=6.12p AD=9.52p PS=7u PD=12.4u
* device instance $1603 r0 *1 204.4,144.5 PMOS
XM$1603 \$I4113 \$I4112 VDD VDD PMOS L=1u W=3.4u AS=10.88p AD=6.46p PS=13.2u
+ PD=7.2u
* device instance $1604 r0 *1 209.2,144.5 PMOS
XM$1604 VDD \$I4113 \$I4112 VDD PMOS L=1u W=3.4u AS=6.46p AD=10.88p PS=7.2u
+ PD=13.2u
* device instance $1605 r0 *1 199.8,124.1 NMOS
XM$1605 BL8 WL4 \$I4113 VSS NMOS L=1u W=3.4u AS=9.52p AD=6.12p PS=12.4u PD=7u
* device instance $1606 r0 *1 204.4,124.1 NMOS
XM$1606 \$I4113 \$I4112 VSS VSS NMOS L=1u W=3.4u AS=6.12p AD=6.46p PS=7u PD=7.2u
* device instance $1607 r0 *1 209.2,124.1 NMOS
XM$1607 VSS \$I4113 \$I4112 VSS NMOS L=1u W=3.4u AS=6.46p AD=6.12p PS=7.2u PD=7u
* device instance $1608 r0 *1 213.8,124.1 NMOS
XM$1608 \$I4112 WL4 BLB8 VSS NMOS L=1u W=3.4u AS=6.12p AD=9.52p PS=7u PD=12.4u
* device instance $1609 r0 *1 204.4,85.3 PMOS
XM$1609 \$I4115 \$I4114 VDD VDD PMOS L=1u W=3.4u AS=10.88p AD=6.46p PS=13.2u
+ PD=7.2u
* device instance $1610 r0 *1 209.2,85.3 PMOS
XM$1610 VDD \$I4115 \$I4114 VDD PMOS L=1u W=3.4u AS=6.46p AD=10.88p PS=7.2u
+ PD=13.2u
* device instance $1611 r0 *1 199.8,64.9 NMOS
XM$1611 BL8 WL2 \$I4115 VSS NMOS L=1u W=3.4u AS=9.52p AD=6.12p PS=12.4u PD=7u
* device instance $1612 r0 *1 204.4,64.9 NMOS
XM$1612 \$I4115 \$I4114 VSS VSS NMOS L=1u W=3.4u AS=6.12p AD=6.46p PS=7u PD=7.2u
* device instance $1613 r0 *1 209.2,64.9 NMOS
XM$1613 VSS \$I4115 \$I4114 VSS NMOS L=1u W=3.4u AS=6.46p AD=6.12p PS=7.2u PD=7u
* device instance $1614 r0 *1 213.8,64.9 NMOS
XM$1614 \$I4114 WL2 BLB8 VSS NMOS L=1u W=3.4u AS=6.12p AD=9.52p PS=7u PD=12.4u
* device instance $1615 r0 *1 204.4,322.1 PMOS
XM$1615 \$I4117 \$I4116 VDD VDD PMOS L=1u W=3.4u AS=10.88p AD=6.46p PS=13.2u
+ PD=7.2u
* device instance $1616 r0 *1 209.2,322.1 PMOS
XM$1616 VDD \$I4117 \$I4116 VDD PMOS L=1u W=3.4u AS=6.46p AD=10.88p PS=7.2u
+ PD=13.2u
* device instance $1617 r0 *1 199.8,301.7 NMOS
XM$1617 BL8 WL10 \$I4117 VSS NMOS L=1u W=3.4u AS=9.52p AD=6.12p PS=12.4u PD=7u
* device instance $1618 r0 *1 204.4,301.7 NMOS
XM$1618 \$I4117 \$I4116 VSS VSS NMOS L=1u W=3.4u AS=6.12p AD=6.46p PS=7u PD=7.2u
* device instance $1619 r0 *1 209.2,301.7 NMOS
XM$1619 VSS \$I4117 \$I4116 VSS NMOS L=1u W=3.4u AS=6.46p AD=6.12p PS=7.2u PD=7u
* device instance $1620 r0 *1 213.8,301.7 NMOS
XM$1620 \$I4116 WL10 BLB8 VSS NMOS L=1u W=3.4u AS=6.12p AD=9.52p PS=7u PD=12.4u
* device instance $1621 r0 *1 204.4,262.9 PMOS
XM$1621 \$I4119 \$I4118 VDD VDD PMOS L=1u W=3.4u AS=10.88p AD=6.46p PS=13.2u
+ PD=7.2u
* device instance $1622 r0 *1 209.2,262.9 PMOS
XM$1622 VDD \$I4119 \$I4118 VDD PMOS L=1u W=3.4u AS=6.46p AD=10.88p PS=7.2u
+ PD=13.2u
* device instance $1623 r0 *1 199.8,242.5 NMOS
XM$1623 BL8 WL8 \$I4119 VSS NMOS L=1u W=3.4u AS=9.52p AD=6.12p PS=12.4u PD=7u
* device instance $1624 r0 *1 204.4,242.5 NMOS
XM$1624 \$I4119 \$I4118 VSS VSS NMOS L=1u W=3.4u AS=6.12p AD=6.46p PS=7u PD=7.2u
* device instance $1625 r0 *1 209.2,242.5 NMOS
XM$1625 VSS \$I4119 \$I4118 VSS NMOS L=1u W=3.4u AS=6.46p AD=6.12p PS=7.2u PD=7u
* device instance $1626 r0 *1 213.8,242.5 NMOS
XM$1626 \$I4118 WL8 BLB8 VSS NMOS L=1u W=3.4u AS=6.12p AD=9.52p PS=7u PD=12.4u
* device instance $1627 r0 *1 204.4,203.7 PMOS
XM$1627 \$I4121 \$I4120 VDD VDD PMOS L=1u W=3.4u AS=10.88p AD=6.46p PS=13.2u
+ PD=7.2u
* device instance $1628 r0 *1 209.2,203.7 PMOS
XM$1628 VDD \$I4121 \$I4120 VDD PMOS L=1u W=3.4u AS=6.46p AD=10.88p PS=7.2u
+ PD=13.2u
* device instance $1629 r0 *1 199.8,183.3 NMOS
XM$1629 BL8 WL6 \$I4121 VSS NMOS L=1u W=3.4u AS=9.52p AD=6.12p PS=12.4u PD=7u
* device instance $1630 r0 *1 204.4,183.3 NMOS
XM$1630 \$I4121 \$I4120 VSS VSS NMOS L=1u W=3.4u AS=6.12p AD=6.46p PS=7u PD=7.2u
* device instance $1631 r0 *1 209.2,183.3 NMOS
XM$1631 VSS \$I4121 \$I4120 VSS NMOS L=1u W=3.4u AS=6.46p AD=6.12p PS=7.2u PD=7u
* device instance $1632 r0 *1 213.8,183.3 NMOS
XM$1632 \$I4120 WL6 BLB8 VSS NMOS L=1u W=3.4u AS=6.12p AD=9.52p PS=7u PD=12.4u
* device instance $1633 m0 *1 664.8,329.1 PMOS
XM$1633 \$I4123 \$I4122 VDD VDD PMOS L=1u W=3.4u AS=10.88p AD=6.46p PS=13.2u
+ PD=7.2u
* device instance $1634 m0 *1 669.6,329.1 PMOS
XM$1634 VDD \$I4123 \$I4122 VDD PMOS L=1u W=3.4u AS=6.46p AD=10.88p PS=7.2u
+ PD=13.2u
* device instance $1635 m0 *1 660.2,349.5 NMOS
XM$1635 BL27 WL11 \$I4123 VSS NMOS L=1u W=3.4u AS=9.52p AD=6.12p PS=12.4u PD=7u
* device instance $1636 m0 *1 664.8,349.5 NMOS
XM$1636 \$I4123 \$I4122 VSS VSS NMOS L=1u W=3.4u AS=6.12p AD=6.46p PS=7u PD=7.2u
* device instance $1637 m0 *1 669.6,349.5 NMOS
XM$1637 VSS \$I4123 \$I4122 VSS NMOS L=1u W=3.4u AS=6.46p AD=6.12p PS=7.2u PD=7u
* device instance $1638 m0 *1 674.2,349.5 NMOS
XM$1638 \$I4122 WL11 BLB27 VSS NMOS L=1u W=3.4u AS=6.12p AD=9.52p PS=7u PD=12.4u
* device instance $1639 m0 *1 664.8,269.9 PMOS
XM$1639 \$I4125 \$I4124 VDD VDD PMOS L=1u W=3.4u AS=10.88p AD=6.46p PS=13.2u
+ PD=7.2u
* device instance $1640 m0 *1 669.6,269.9 PMOS
XM$1640 VDD \$I4125 \$I4124 VDD PMOS L=1u W=3.4u AS=6.46p AD=10.88p PS=7.2u
+ PD=13.2u
* device instance $1641 m0 *1 660.2,290.3 NMOS
XM$1641 BL27 WL9 \$I4125 VSS NMOS L=1u W=3.4u AS=9.52p AD=6.12p PS=12.4u PD=7u
* device instance $1642 m0 *1 664.8,290.3 NMOS
XM$1642 \$I4125 \$I4124 VSS VSS NMOS L=1u W=3.4u AS=6.12p AD=6.46p PS=7u PD=7.2u
* device instance $1643 m0 *1 669.6,290.3 NMOS
XM$1643 VSS \$I4125 \$I4124 VSS NMOS L=1u W=3.4u AS=6.46p AD=6.12p PS=7.2u PD=7u
* device instance $1644 m0 *1 674.2,290.3 NMOS
XM$1644 \$I4124 WL9 BLB27 VSS NMOS L=1u W=3.4u AS=6.12p AD=9.52p PS=7u PD=12.4u
* device instance $1645 m0 *1 664.8,447.5 PMOS
XM$1645 \$I4127 \$I4126 VDD VDD PMOS L=1u W=3.4u AS=10.88p AD=6.46p PS=13.2u
+ PD=7.2u
* device instance $1646 m0 *1 669.6,447.5 PMOS
XM$1646 VDD \$I4127 \$I4126 VDD PMOS L=1u W=3.4u AS=6.46p AD=10.88p PS=7.2u
+ PD=13.2u
* device instance $1647 m0 *1 660.2,467.9 NMOS
XM$1647 BL27 WL15 \$I4127 VSS NMOS L=1u W=3.4u AS=9.52p AD=6.12p PS=12.4u PD=7u
* device instance $1648 m0 *1 664.8,467.9 NMOS
XM$1648 \$I4127 \$I4126 VSS VSS NMOS L=1u W=3.4u AS=6.12p AD=6.46p PS=7u PD=7.2u
* device instance $1649 m0 *1 669.6,467.9 NMOS
XM$1649 VSS \$I4127 \$I4126 VSS NMOS L=1u W=3.4u AS=6.46p AD=6.12p PS=7.2u PD=7u
* device instance $1650 m0 *1 674.2,467.9 NMOS
XM$1650 \$I4126 WL15 BLB27 VSS NMOS L=1u W=3.4u AS=6.12p AD=9.52p PS=7u PD=12.4u
* device instance $1651 m0 *1 664.8,388.3 PMOS
XM$1651 \$I4129 \$I4128 VDD VDD PMOS L=1u W=3.4u AS=10.88p AD=6.46p PS=13.2u
+ PD=7.2u
* device instance $1652 m0 *1 669.6,388.3 PMOS
XM$1652 VDD \$I4129 \$I4128 VDD PMOS L=1u W=3.4u AS=6.46p AD=10.88p PS=7.2u
+ PD=13.2u
* device instance $1653 m0 *1 660.2,408.7 NMOS
XM$1653 BL27 WL13 \$I4129 VSS NMOS L=1u W=3.4u AS=9.52p AD=6.12p PS=12.4u PD=7u
* device instance $1654 m0 *1 664.8,408.7 NMOS
XM$1654 \$I4129 \$I4128 VSS VSS NMOS L=1u W=3.4u AS=6.12p AD=6.46p PS=7u PD=7.2u
* device instance $1655 m0 *1 669.6,408.7 NMOS
XM$1655 VSS \$I4129 \$I4128 VSS NMOS L=1u W=3.4u AS=6.46p AD=6.12p PS=7.2u PD=7u
* device instance $1656 m0 *1 674.2,408.7 NMOS
XM$1656 \$I4128 WL13 BLB27 VSS NMOS L=1u W=3.4u AS=6.12p AD=9.52p PS=7u PD=12.4u
* device instance $1657 m0 *1 664.8,92.3 PMOS
XM$1657 \$I4131 \$I4130 VDD VDD PMOS L=1u W=3.4u AS=10.88p AD=6.46p PS=13.2u
+ PD=7.2u
* device instance $1658 m0 *1 669.6,92.3 PMOS
XM$1658 VDD \$I4131 \$I4130 VDD PMOS L=1u W=3.4u AS=6.46p AD=10.88p PS=7.2u
+ PD=13.2u
* device instance $1659 m0 *1 660.2,112.7 NMOS
XM$1659 BL27 WL3 \$I4131 VSS NMOS L=1u W=3.4u AS=9.52p AD=6.12p PS=12.4u PD=7u
* device instance $1660 m0 *1 664.8,112.7 NMOS
XM$1660 \$I4131 \$I4130 VSS VSS NMOS L=1u W=3.4u AS=6.12p AD=6.46p PS=7u PD=7.2u
* device instance $1661 m0 *1 669.6,112.7 NMOS
XM$1661 VSS \$I4131 \$I4130 VSS NMOS L=1u W=3.4u AS=6.46p AD=6.12p PS=7.2u PD=7u
* device instance $1662 m0 *1 674.2,112.7 NMOS
XM$1662 \$I4130 WL3 BLB27 VSS NMOS L=1u W=3.4u AS=6.12p AD=9.52p PS=7u PD=12.4u
* device instance $1663 m0 *1 664.8,33.1 PMOS
XM$1663 \$I4133 \$I4132 VDD VDD PMOS L=1u W=3.4u AS=10.88p AD=6.46p PS=13.2u
+ PD=7.2u
* device instance $1664 m0 *1 669.6,33.1 PMOS
XM$1664 VDD \$I4133 \$I4132 VDD PMOS L=1u W=3.4u AS=6.46p AD=10.88p PS=7.2u
+ PD=13.2u
* device instance $1665 m0 *1 660.2,53.5 NMOS
XM$1665 BL27 WL1 \$I4133 VSS NMOS L=1u W=3.4u AS=9.52p AD=6.12p PS=12.4u PD=7u
* device instance $1666 m0 *1 664.8,53.5 NMOS
XM$1666 \$I4133 \$I4132 VSS VSS NMOS L=1u W=3.4u AS=6.12p AD=6.46p PS=7u PD=7.2u
* device instance $1667 m0 *1 669.6,53.5 NMOS
XM$1667 VSS \$I4133 \$I4132 VSS NMOS L=1u W=3.4u AS=6.46p AD=6.12p PS=7.2u PD=7u
* device instance $1668 m0 *1 674.2,53.5 NMOS
XM$1668 \$I4132 WL1 BLB27 VSS NMOS L=1u W=3.4u AS=6.12p AD=9.52p PS=7u PD=12.4u
* device instance $1669 m0 *1 664.8,210.7 PMOS
XM$1669 \$I4135 \$I4134 VDD VDD PMOS L=1u W=3.4u AS=10.88p AD=6.46p PS=13.2u
+ PD=7.2u
* device instance $1670 m0 *1 669.6,210.7 PMOS
XM$1670 VDD \$I4135 \$I4134 VDD PMOS L=1u W=3.4u AS=6.46p AD=10.88p PS=7.2u
+ PD=13.2u
* device instance $1671 m0 *1 660.2,231.1 NMOS
XM$1671 BL27 WL7 \$I4135 VSS NMOS L=1u W=3.4u AS=9.52p AD=6.12p PS=12.4u PD=7u
* device instance $1672 m0 *1 664.8,231.1 NMOS
XM$1672 \$I4135 \$I4134 VSS VSS NMOS L=1u W=3.4u AS=6.12p AD=6.46p PS=7u PD=7.2u
* device instance $1673 m0 *1 669.6,231.1 NMOS
XM$1673 VSS \$I4135 \$I4134 VSS NMOS L=1u W=3.4u AS=6.46p AD=6.12p PS=7.2u PD=7u
* device instance $1674 m0 *1 674.2,231.1 NMOS
XM$1674 \$I4134 WL7 BLB27 VSS NMOS L=1u W=3.4u AS=6.12p AD=9.52p PS=7u PD=12.4u
* device instance $1675 m0 *1 664.8,151.5 PMOS
XM$1675 \$I4137 \$I4136 VDD VDD PMOS L=1u W=3.4u AS=10.88p AD=6.46p PS=13.2u
+ PD=7.2u
* device instance $1676 m0 *1 669.6,151.5 PMOS
XM$1676 VDD \$I4137 \$I4136 VDD PMOS L=1u W=3.4u AS=6.46p AD=10.88p PS=7.2u
+ PD=13.2u
* device instance $1677 m0 *1 660.2,171.9 NMOS
XM$1677 BL27 WL5 \$I4137 VSS NMOS L=1u W=3.4u AS=9.52p AD=6.12p PS=12.4u PD=7u
* device instance $1678 m0 *1 664.8,171.9 NMOS
XM$1678 \$I4137 \$I4136 VSS VSS NMOS L=1u W=3.4u AS=6.12p AD=6.46p PS=7u PD=7.2u
* device instance $1679 m0 *1 669.6,171.9 NMOS
XM$1679 VSS \$I4137 \$I4136 VSS NMOS L=1u W=3.4u AS=6.46p AD=6.12p PS=7.2u PD=7u
* device instance $1680 m0 *1 674.2,171.9 NMOS
XM$1680 \$I4136 WL5 BLB27 VSS NMOS L=1u W=3.4u AS=6.12p AD=9.52p PS=7u PD=12.4u
* device instance $1681 r0 *1 664.8,381.3 PMOS
XM$1681 \$I4139 \$I4138 VDD VDD PMOS L=1u W=3.4u AS=10.88p AD=6.46p PS=13.2u
+ PD=7.2u
* device instance $1682 r0 *1 669.6,381.3 PMOS
XM$1682 VDD \$I4139 \$I4138 VDD PMOS L=1u W=3.4u AS=6.46p AD=10.88p PS=7.2u
+ PD=13.2u
* device instance $1683 r0 *1 660.2,360.9 NMOS
XM$1683 BL27 WL12 \$I4139 VSS NMOS L=1u W=3.4u AS=9.52p AD=6.12p PS=12.4u PD=7u
* device instance $1684 r0 *1 664.8,360.9 NMOS
XM$1684 \$I4139 \$I4138 VSS VSS NMOS L=1u W=3.4u AS=6.12p AD=6.46p PS=7u PD=7.2u
* device instance $1685 r0 *1 669.6,360.9 NMOS
XM$1685 VSS \$I4139 \$I4138 VSS NMOS L=1u W=3.4u AS=6.46p AD=6.12p PS=7.2u PD=7u
* device instance $1686 r0 *1 674.2,360.9 NMOS
XM$1686 \$I4138 WL12 BLB27 VSS NMOS L=1u W=3.4u AS=6.12p AD=9.52p PS=7u PD=12.4u
* device instance $1687 r0 *1 664.8,440.5 PMOS
XM$1687 \$I4141 \$I4140 VDD VDD PMOS L=1u W=3.4u AS=10.88p AD=6.46p PS=13.2u
+ PD=7.2u
* device instance $1688 r0 *1 669.6,440.5 PMOS
XM$1688 VDD \$I4141 \$I4140 VDD PMOS L=1u W=3.4u AS=6.46p AD=10.88p PS=7.2u
+ PD=13.2u
* device instance $1689 r0 *1 660.2,420.1 NMOS
XM$1689 BL27 WL14 \$I4141 VSS NMOS L=1u W=3.4u AS=9.52p AD=6.12p PS=12.4u PD=7u
* device instance $1690 r0 *1 664.8,420.1 NMOS
XM$1690 \$I4141 \$I4140 VSS VSS NMOS L=1u W=3.4u AS=6.12p AD=6.46p PS=7u PD=7.2u
* device instance $1691 r0 *1 669.6,420.1 NMOS
XM$1691 VSS \$I4141 \$I4140 VSS NMOS L=1u W=3.4u AS=6.46p AD=6.12p PS=7.2u PD=7u
* device instance $1692 r0 *1 674.2,420.1 NMOS
XM$1692 \$I4140 WL14 BLB27 VSS NMOS L=1u W=3.4u AS=6.12p AD=9.52p PS=7u PD=12.4u
* device instance $1693 r0 *1 664.8,322.1 PMOS
XM$1693 \$I4143 \$I4142 VDD VDD PMOS L=1u W=3.4u AS=10.88p AD=6.46p PS=13.2u
+ PD=7.2u
* device instance $1694 r0 *1 669.6,322.1 PMOS
XM$1694 VDD \$I4143 \$I4142 VDD PMOS L=1u W=3.4u AS=6.46p AD=10.88p PS=7.2u
+ PD=13.2u
* device instance $1695 r0 *1 660.2,301.7 NMOS
XM$1695 BL27 WL10 \$I4143 VSS NMOS L=1u W=3.4u AS=9.52p AD=6.12p PS=12.4u PD=7u
* device instance $1696 r0 *1 664.8,301.7 NMOS
XM$1696 \$I4143 \$I4142 VSS VSS NMOS L=1u W=3.4u AS=6.12p AD=6.46p PS=7u PD=7.2u
* device instance $1697 r0 *1 669.6,301.7 NMOS
XM$1697 VSS \$I4143 \$I4142 VSS NMOS L=1u W=3.4u AS=6.46p AD=6.12p PS=7.2u PD=7u
* device instance $1698 r0 *1 674.2,301.7 NMOS
XM$1698 \$I4142 WL10 BLB27 VSS NMOS L=1u W=3.4u AS=6.12p AD=9.52p PS=7u PD=12.4u
* device instance $1699 r0 *1 664.8,262.9 PMOS
XM$1699 \$I4145 \$I4144 VDD VDD PMOS L=1u W=3.4u AS=10.88p AD=6.46p PS=13.2u
+ PD=7.2u
* device instance $1700 r0 *1 669.6,262.9 PMOS
XM$1700 VDD \$I4145 \$I4144 VDD PMOS L=1u W=3.4u AS=6.46p AD=10.88p PS=7.2u
+ PD=13.2u
* device instance $1701 r0 *1 660.2,242.5 NMOS
XM$1701 BL27 WL8 \$I4145 VSS NMOS L=1u W=3.4u AS=9.52p AD=6.12p PS=12.4u PD=7u
* device instance $1702 r0 *1 664.8,242.5 NMOS
XM$1702 \$I4145 \$I4144 VSS VSS NMOS L=1u W=3.4u AS=6.12p AD=6.46p PS=7u PD=7.2u
* device instance $1703 r0 *1 669.6,242.5 NMOS
XM$1703 VSS \$I4145 \$I4144 VSS NMOS L=1u W=3.4u AS=6.46p AD=6.12p PS=7.2u PD=7u
* device instance $1704 r0 *1 674.2,242.5 NMOS
XM$1704 \$I4144 WL8 BLB27 VSS NMOS L=1u W=3.4u AS=6.12p AD=9.52p PS=7u PD=12.4u
* device instance $1705 r0 *1 664.8,144.5 PMOS
XM$1705 \$I4147 \$I4146 VDD VDD PMOS L=1u W=3.4u AS=10.88p AD=6.46p PS=13.2u
+ PD=7.2u
* device instance $1706 r0 *1 669.6,144.5 PMOS
XM$1706 VDD \$I4147 \$I4146 VDD PMOS L=1u W=3.4u AS=6.46p AD=10.88p PS=7.2u
+ PD=13.2u
* device instance $1707 r0 *1 660.2,124.1 NMOS
XM$1707 BL27 WL4 \$I4147 VSS NMOS L=1u W=3.4u AS=9.52p AD=6.12p PS=12.4u PD=7u
* device instance $1708 r0 *1 664.8,124.1 NMOS
XM$1708 \$I4147 \$I4146 VSS VSS NMOS L=1u W=3.4u AS=6.12p AD=6.46p PS=7u PD=7.2u
* device instance $1709 r0 *1 669.6,124.1 NMOS
XM$1709 VSS \$I4147 \$I4146 VSS NMOS L=1u W=3.4u AS=6.46p AD=6.12p PS=7.2u PD=7u
* device instance $1710 r0 *1 674.2,124.1 NMOS
XM$1710 \$I4146 WL4 BLB27 VSS NMOS L=1u W=3.4u AS=6.12p AD=9.52p PS=7u PD=12.4u
* device instance $1711 r0 *1 664.8,203.7 PMOS
XM$1711 \$I4149 \$I4148 VDD VDD PMOS L=1u W=3.4u AS=10.88p AD=6.46p PS=13.2u
+ PD=7.2u
* device instance $1712 r0 *1 669.6,203.7 PMOS
XM$1712 VDD \$I4149 \$I4148 VDD PMOS L=1u W=3.4u AS=6.46p AD=10.88p PS=7.2u
+ PD=13.2u
* device instance $1713 r0 *1 660.2,183.3 NMOS
XM$1713 BL27 WL6 \$I4149 VSS NMOS L=1u W=3.4u AS=9.52p AD=6.12p PS=12.4u PD=7u
* device instance $1714 r0 *1 664.8,183.3 NMOS
XM$1714 \$I4149 \$I4148 VSS VSS NMOS L=1u W=3.4u AS=6.12p AD=6.46p PS=7u PD=7.2u
* device instance $1715 r0 *1 669.6,183.3 NMOS
XM$1715 VSS \$I4149 \$I4148 VSS NMOS L=1u W=3.4u AS=6.46p AD=6.12p PS=7.2u PD=7u
* device instance $1716 r0 *1 674.2,183.3 NMOS
XM$1716 \$I4148 WL6 BLB27 VSS NMOS L=1u W=3.4u AS=6.12p AD=9.52p PS=7u PD=12.4u
* device instance $1717 r0 *1 664.8,85.3 PMOS
XM$1717 \$I4151 \$I4150 VDD VDD PMOS L=1u W=3.4u AS=10.88p AD=6.46p PS=13.2u
+ PD=7.2u
* device instance $1718 r0 *1 669.6,85.3 PMOS
XM$1718 VDD \$I4151 \$I4150 VDD PMOS L=1u W=3.4u AS=6.46p AD=10.88p PS=7.2u
+ PD=13.2u
* device instance $1719 r0 *1 660.2,64.9 NMOS
XM$1719 BL27 WL2 \$I4151 VSS NMOS L=1u W=3.4u AS=9.52p AD=6.12p PS=12.4u PD=7u
* device instance $1720 r0 *1 664.8,64.9 NMOS
XM$1720 \$I4151 \$I4150 VSS VSS NMOS L=1u W=3.4u AS=6.12p AD=6.46p PS=7u PD=7.2u
* device instance $1721 r0 *1 669.6,64.9 NMOS
XM$1721 VSS \$I4151 \$I4150 VSS NMOS L=1u W=3.4u AS=6.46p AD=6.12p PS=7.2u PD=7u
* device instance $1722 r0 *1 674.2,64.9 NMOS
XM$1722 \$I4150 WL2 BLB27 VSS NMOS L=1u W=3.4u AS=6.12p AD=9.52p PS=7u PD=12.4u
* device instance $1723 m0 *1 511.6,329.1 PMOS
XM$1723 \$I4153 \$I4152 VDD VDD PMOS L=1u W=3.4u AS=10.88p AD=6.46p PS=13.2u
+ PD=7.2u
* device instance $1724 m0 *1 516.4,329.1 PMOS
XM$1724 VDD \$I4153 \$I4152 VDD PMOS L=1u W=3.4u AS=6.46p AD=10.88p PS=7.2u
+ PD=13.2u
* device instance $1725 m0 *1 507,349.5 NMOS
XM$1725 BL21 WL11 \$I4153 VSS NMOS L=1u W=3.4u AS=9.52p AD=6.12p PS=12.4u PD=7u
* device instance $1726 m0 *1 511.6,349.5 NMOS
XM$1726 \$I4153 \$I4152 VSS VSS NMOS L=1u W=3.4u AS=6.12p AD=6.46p PS=7u PD=7.2u
* device instance $1727 m0 *1 516.4,349.5 NMOS
XM$1727 VSS \$I4153 \$I4152 VSS NMOS L=1u W=3.4u AS=6.46p AD=6.12p PS=7.2u PD=7u
* device instance $1728 m0 *1 521,349.5 NMOS
XM$1728 \$I4152 WL11 BLB21 VSS NMOS L=1u W=3.4u AS=6.12p AD=9.52p PS=7u PD=12.4u
* device instance $1729 m0 *1 511.6,269.9 PMOS
XM$1729 \$I4155 \$I4154 VDD VDD PMOS L=1u W=3.4u AS=10.88p AD=6.46p PS=13.2u
+ PD=7.2u
* device instance $1730 m0 *1 516.4,269.9 PMOS
XM$1730 VDD \$I4155 \$I4154 VDD PMOS L=1u W=3.4u AS=6.46p AD=10.88p PS=7.2u
+ PD=13.2u
* device instance $1731 m0 *1 507,290.3 NMOS
XM$1731 BL21 WL9 \$I4155 VSS NMOS L=1u W=3.4u AS=9.52p AD=6.12p PS=12.4u PD=7u
* device instance $1732 m0 *1 511.6,290.3 NMOS
XM$1732 \$I4155 \$I4154 VSS VSS NMOS L=1u W=3.4u AS=6.12p AD=6.46p PS=7u PD=7.2u
* device instance $1733 m0 *1 516.4,290.3 NMOS
XM$1733 VSS \$I4155 \$I4154 VSS NMOS L=1u W=3.4u AS=6.46p AD=6.12p PS=7.2u PD=7u
* device instance $1734 m0 *1 521,290.3 NMOS
XM$1734 \$I4154 WL9 BLB21 VSS NMOS L=1u W=3.4u AS=6.12p AD=9.52p PS=7u PD=12.4u
* device instance $1735 m0 *1 511.6,33.1 PMOS
XM$1735 \$I4157 \$I4156 VDD VDD PMOS L=1u W=3.4u AS=10.88p AD=6.46p PS=13.2u
+ PD=7.2u
* device instance $1736 m0 *1 516.4,33.1 PMOS
XM$1736 VDD \$I4157 \$I4156 VDD PMOS L=1u W=3.4u AS=6.46p AD=10.88p PS=7.2u
+ PD=13.2u
* device instance $1737 m0 *1 507,53.5 NMOS
XM$1737 BL21 WL1 \$I4157 VSS NMOS L=1u W=3.4u AS=9.52p AD=6.12p PS=12.4u PD=7u
* device instance $1738 m0 *1 511.6,53.5 NMOS
XM$1738 \$I4157 \$I4156 VSS VSS NMOS L=1u W=3.4u AS=6.12p AD=6.46p PS=7u PD=7.2u
* device instance $1739 m0 *1 516.4,53.5 NMOS
XM$1739 VSS \$I4157 \$I4156 VSS NMOS L=1u W=3.4u AS=6.46p AD=6.12p PS=7.2u PD=7u
* device instance $1740 m0 *1 521,53.5 NMOS
XM$1740 \$I4156 WL1 BLB21 VSS NMOS L=1u W=3.4u AS=6.12p AD=9.52p PS=7u PD=12.4u
* device instance $1741 m0 *1 511.6,92.3 PMOS
XM$1741 \$I4159 \$I4158 VDD VDD PMOS L=1u W=3.4u AS=10.88p AD=6.46p PS=13.2u
+ PD=7.2u
* device instance $1742 m0 *1 516.4,92.3 PMOS
XM$1742 VDD \$I4159 \$I4158 VDD PMOS L=1u W=3.4u AS=6.46p AD=10.88p PS=7.2u
+ PD=13.2u
* device instance $1743 m0 *1 507,112.7 NMOS
XM$1743 BL21 WL3 \$I4159 VSS NMOS L=1u W=3.4u AS=9.52p AD=6.12p PS=12.4u PD=7u
* device instance $1744 m0 *1 511.6,112.7 NMOS
XM$1744 \$I4159 \$I4158 VSS VSS NMOS L=1u W=3.4u AS=6.12p AD=6.46p PS=7u PD=7.2u
* device instance $1745 m0 *1 516.4,112.7 NMOS
XM$1745 VSS \$I4159 \$I4158 VSS NMOS L=1u W=3.4u AS=6.46p AD=6.12p PS=7.2u PD=7u
* device instance $1746 m0 *1 521,112.7 NMOS
XM$1746 \$I4158 WL3 BLB21 VSS NMOS L=1u W=3.4u AS=6.12p AD=9.52p PS=7u PD=12.4u
* device instance $1747 m0 *1 511.6,447.5 PMOS
XM$1747 \$I4161 \$I4160 VDD VDD PMOS L=1u W=3.4u AS=10.88p AD=6.46p PS=13.2u
+ PD=7.2u
* device instance $1748 m0 *1 516.4,447.5 PMOS
XM$1748 VDD \$I4161 \$I4160 VDD PMOS L=1u W=3.4u AS=6.46p AD=10.88p PS=7.2u
+ PD=13.2u
* device instance $1749 m0 *1 507,467.9 NMOS
XM$1749 BL21 WL15 \$I4161 VSS NMOS L=1u W=3.4u AS=9.52p AD=6.12p PS=12.4u PD=7u
* device instance $1750 m0 *1 511.6,467.9 NMOS
XM$1750 \$I4161 \$I4160 VSS VSS NMOS L=1u W=3.4u AS=6.12p AD=6.46p PS=7u PD=7.2u
* device instance $1751 m0 *1 516.4,467.9 NMOS
XM$1751 VSS \$I4161 \$I4160 VSS NMOS L=1u W=3.4u AS=6.46p AD=6.12p PS=7.2u PD=7u
* device instance $1752 m0 *1 521,467.9 NMOS
XM$1752 \$I4160 WL15 BLB21 VSS NMOS L=1u W=3.4u AS=6.12p AD=9.52p PS=7u PD=12.4u
* device instance $1753 m0 *1 511.6,210.7 PMOS
XM$1753 \$I4163 \$I4162 VDD VDD PMOS L=1u W=3.4u AS=10.88p AD=6.46p PS=13.2u
+ PD=7.2u
* device instance $1754 m0 *1 516.4,210.7 PMOS
XM$1754 VDD \$I4163 \$I4162 VDD PMOS L=1u W=3.4u AS=6.46p AD=10.88p PS=7.2u
+ PD=13.2u
* device instance $1755 m0 *1 507,231.1 NMOS
XM$1755 BL21 WL7 \$I4163 VSS NMOS L=1u W=3.4u AS=9.52p AD=6.12p PS=12.4u PD=7u
* device instance $1756 m0 *1 511.6,231.1 NMOS
XM$1756 \$I4163 \$I4162 VSS VSS NMOS L=1u W=3.4u AS=6.12p AD=6.46p PS=7u PD=7.2u
* device instance $1757 m0 *1 516.4,231.1 NMOS
XM$1757 VSS \$I4163 \$I4162 VSS NMOS L=1u W=3.4u AS=6.46p AD=6.12p PS=7.2u PD=7u
* device instance $1758 m0 *1 521,231.1 NMOS
XM$1758 \$I4162 WL7 BLB21 VSS NMOS L=1u W=3.4u AS=6.12p AD=9.52p PS=7u PD=12.4u
* device instance $1759 m0 *1 511.6,388.3 PMOS
XM$1759 \$I4165 \$I4164 VDD VDD PMOS L=1u W=3.4u AS=10.88p AD=6.46p PS=13.2u
+ PD=7.2u
* device instance $1760 m0 *1 516.4,388.3 PMOS
XM$1760 VDD \$I4165 \$I4164 VDD PMOS L=1u W=3.4u AS=6.46p AD=10.88p PS=7.2u
+ PD=13.2u
* device instance $1761 m0 *1 507,408.7 NMOS
XM$1761 BL21 WL13 \$I4165 VSS NMOS L=1u W=3.4u AS=9.52p AD=6.12p PS=12.4u PD=7u
* device instance $1762 m0 *1 511.6,408.7 NMOS
XM$1762 \$I4165 \$I4164 VSS VSS NMOS L=1u W=3.4u AS=6.12p AD=6.46p PS=7u PD=7.2u
* device instance $1763 m0 *1 516.4,408.7 NMOS
XM$1763 VSS \$I4165 \$I4164 VSS NMOS L=1u W=3.4u AS=6.46p AD=6.12p PS=7.2u PD=7u
* device instance $1764 m0 *1 521,408.7 NMOS
XM$1764 \$I4164 WL13 BLB21 VSS NMOS L=1u W=3.4u AS=6.12p AD=9.52p PS=7u PD=12.4u
* device instance $1765 m0 *1 511.6,151.5 PMOS
XM$1765 \$I4167 \$I4166 VDD VDD PMOS L=1u W=3.4u AS=10.88p AD=6.46p PS=13.2u
+ PD=7.2u
* device instance $1766 m0 *1 516.4,151.5 PMOS
XM$1766 VDD \$I4167 \$I4166 VDD PMOS L=1u W=3.4u AS=6.46p AD=10.88p PS=7.2u
+ PD=13.2u
* device instance $1767 m0 *1 507,171.9 NMOS
XM$1767 BL21 WL5 \$I4167 VSS NMOS L=1u W=3.4u AS=9.52p AD=6.12p PS=12.4u PD=7u
* device instance $1768 m0 *1 511.6,171.9 NMOS
XM$1768 \$I4167 \$I4166 VSS VSS NMOS L=1u W=3.4u AS=6.12p AD=6.46p PS=7u PD=7.2u
* device instance $1769 m0 *1 516.4,171.9 NMOS
XM$1769 VSS \$I4167 \$I4166 VSS NMOS L=1u W=3.4u AS=6.46p AD=6.12p PS=7.2u PD=7u
* device instance $1770 m0 *1 521,171.9 NMOS
XM$1770 \$I4166 WL5 BLB21 VSS NMOS L=1u W=3.4u AS=6.12p AD=9.52p PS=7u PD=12.4u
* device instance $1771 r0 *1 511.6,440.5 PMOS
XM$1771 \$I4169 \$I4168 VDD VDD PMOS L=1u W=3.4u AS=10.88p AD=6.46p PS=13.2u
+ PD=7.2u
* device instance $1772 r0 *1 516.4,440.5 PMOS
XM$1772 VDD \$I4169 \$I4168 VDD PMOS L=1u W=3.4u AS=6.46p AD=10.88p PS=7.2u
+ PD=13.2u
* device instance $1773 r0 *1 507,420.1 NMOS
XM$1773 BL21 WL14 \$I4169 VSS NMOS L=1u W=3.4u AS=9.52p AD=6.12p PS=12.4u PD=7u
* device instance $1774 r0 *1 511.6,420.1 NMOS
XM$1774 \$I4169 \$I4168 VSS VSS NMOS L=1u W=3.4u AS=6.12p AD=6.46p PS=7u PD=7.2u
* device instance $1775 r0 *1 516.4,420.1 NMOS
XM$1775 VSS \$I4169 \$I4168 VSS NMOS L=1u W=3.4u AS=6.46p AD=6.12p PS=7.2u PD=7u
* device instance $1776 r0 *1 521,420.1 NMOS
XM$1776 \$I4168 WL14 BLB21 VSS NMOS L=1u W=3.4u AS=6.12p AD=9.52p PS=7u PD=12.4u
* device instance $1777 r0 *1 511.6,381.3 PMOS
XM$1777 \$I4171 \$I4170 VDD VDD PMOS L=1u W=3.4u AS=10.88p AD=6.46p PS=13.2u
+ PD=7.2u
* device instance $1778 r0 *1 516.4,381.3 PMOS
XM$1778 VDD \$I4171 \$I4170 VDD PMOS L=1u W=3.4u AS=6.46p AD=10.88p PS=7.2u
+ PD=13.2u
* device instance $1779 r0 *1 507,360.9 NMOS
XM$1779 BL21 WL12 \$I4171 VSS NMOS L=1u W=3.4u AS=9.52p AD=6.12p PS=12.4u PD=7u
* device instance $1780 r0 *1 511.6,360.9 NMOS
XM$1780 \$I4171 \$I4170 VSS VSS NMOS L=1u W=3.4u AS=6.12p AD=6.46p PS=7u PD=7.2u
* device instance $1781 r0 *1 516.4,360.9 NMOS
XM$1781 VSS \$I4171 \$I4170 VSS NMOS L=1u W=3.4u AS=6.46p AD=6.12p PS=7.2u PD=7u
* device instance $1782 r0 *1 521,360.9 NMOS
XM$1782 \$I4170 WL12 BLB21 VSS NMOS L=1u W=3.4u AS=6.12p AD=9.52p PS=7u PD=12.4u
* device instance $1783 r0 *1 511.6,262.9 PMOS
XM$1783 \$I4173 \$I4172 VDD VDD PMOS L=1u W=3.4u AS=10.88p AD=6.46p PS=13.2u
+ PD=7.2u
* device instance $1784 r0 *1 516.4,262.9 PMOS
XM$1784 VDD \$I4173 \$I4172 VDD PMOS L=1u W=3.4u AS=6.46p AD=10.88p PS=7.2u
+ PD=13.2u
* device instance $1785 r0 *1 507,242.5 NMOS
XM$1785 BL21 WL8 \$I4173 VSS NMOS L=1u W=3.4u AS=9.52p AD=6.12p PS=12.4u PD=7u
* device instance $1786 r0 *1 511.6,242.5 NMOS
XM$1786 \$I4173 \$I4172 VSS VSS NMOS L=1u W=3.4u AS=6.12p AD=6.46p PS=7u PD=7.2u
* device instance $1787 r0 *1 516.4,242.5 NMOS
XM$1787 VSS \$I4173 \$I4172 VSS NMOS L=1u W=3.4u AS=6.46p AD=6.12p PS=7.2u PD=7u
* device instance $1788 r0 *1 521,242.5 NMOS
XM$1788 \$I4172 WL8 BLB21 VSS NMOS L=1u W=3.4u AS=6.12p AD=9.52p PS=7u PD=12.4u
* device instance $1789 r0 *1 511.6,322.1 PMOS
XM$1789 \$I4175 \$I4174 VDD VDD PMOS L=1u W=3.4u AS=10.88p AD=6.46p PS=13.2u
+ PD=7.2u
* device instance $1790 r0 *1 516.4,322.1 PMOS
XM$1790 VDD \$I4175 \$I4174 VDD PMOS L=1u W=3.4u AS=6.46p AD=10.88p PS=7.2u
+ PD=13.2u
* device instance $1791 r0 *1 507,301.7 NMOS
XM$1791 BL21 WL10 \$I4175 VSS NMOS L=1u W=3.4u AS=9.52p AD=6.12p PS=12.4u PD=7u
* device instance $1792 r0 *1 511.6,301.7 NMOS
XM$1792 \$I4175 \$I4174 VSS VSS NMOS L=1u W=3.4u AS=6.12p AD=6.46p PS=7u PD=7.2u
* device instance $1793 r0 *1 516.4,301.7 NMOS
XM$1793 VSS \$I4175 \$I4174 VSS NMOS L=1u W=3.4u AS=6.46p AD=6.12p PS=7.2u PD=7u
* device instance $1794 r0 *1 521,301.7 NMOS
XM$1794 \$I4174 WL10 BLB21 VSS NMOS L=1u W=3.4u AS=6.12p AD=9.52p PS=7u PD=12.4u
* device instance $1795 r0 *1 511.6,203.7 PMOS
XM$1795 \$I4177 \$I4176 VDD VDD PMOS L=1u W=3.4u AS=10.88p AD=6.46p PS=13.2u
+ PD=7.2u
* device instance $1796 r0 *1 516.4,203.7 PMOS
XM$1796 VDD \$I4177 \$I4176 VDD PMOS L=1u W=3.4u AS=6.46p AD=10.88p PS=7.2u
+ PD=13.2u
* device instance $1797 r0 *1 507,183.3 NMOS
XM$1797 BL21 WL6 \$I4177 VSS NMOS L=1u W=3.4u AS=9.52p AD=6.12p PS=12.4u PD=7u
* device instance $1798 r0 *1 511.6,183.3 NMOS
XM$1798 \$I4177 \$I4176 VSS VSS NMOS L=1u W=3.4u AS=6.12p AD=6.46p PS=7u PD=7.2u
* device instance $1799 r0 *1 516.4,183.3 NMOS
XM$1799 VSS \$I4177 \$I4176 VSS NMOS L=1u W=3.4u AS=6.46p AD=6.12p PS=7.2u PD=7u
* device instance $1800 r0 *1 521,183.3 NMOS
XM$1800 \$I4176 WL6 BLB21 VSS NMOS L=1u W=3.4u AS=6.12p AD=9.52p PS=7u PD=12.4u
* device instance $1801 r0 *1 511.6,144.5 PMOS
XM$1801 \$I4179 \$I4178 VDD VDD PMOS L=1u W=3.4u AS=10.88p AD=6.46p PS=13.2u
+ PD=7.2u
* device instance $1802 r0 *1 516.4,144.5 PMOS
XM$1802 VDD \$I4179 \$I4178 VDD PMOS L=1u W=3.4u AS=6.46p AD=10.88p PS=7.2u
+ PD=13.2u
* device instance $1803 r0 *1 507,124.1 NMOS
XM$1803 BL21 WL4 \$I4179 VSS NMOS L=1u W=3.4u AS=9.52p AD=6.12p PS=12.4u PD=7u
* device instance $1804 r0 *1 511.6,124.1 NMOS
XM$1804 \$I4179 \$I4178 VSS VSS NMOS L=1u W=3.4u AS=6.12p AD=6.46p PS=7u PD=7.2u
* device instance $1805 r0 *1 516.4,124.1 NMOS
XM$1805 VSS \$I4179 \$I4178 VSS NMOS L=1u W=3.4u AS=6.46p AD=6.12p PS=7.2u PD=7u
* device instance $1806 r0 *1 521,124.1 NMOS
XM$1806 \$I4178 WL4 BLB21 VSS NMOS L=1u W=3.4u AS=6.12p AD=9.52p PS=7u PD=12.4u
* device instance $1807 r0 *1 511.6,85.3 PMOS
XM$1807 \$I4181 \$I4180 VDD VDD PMOS L=1u W=3.4u AS=10.88p AD=6.46p PS=13.2u
+ PD=7.2u
* device instance $1808 r0 *1 516.4,85.3 PMOS
XM$1808 VDD \$I4181 \$I4180 VDD PMOS L=1u W=3.4u AS=6.46p AD=10.88p PS=7.2u
+ PD=13.2u
* device instance $1809 r0 *1 507,64.9 NMOS
XM$1809 BL21 WL2 \$I4181 VSS NMOS L=1u W=3.4u AS=9.52p AD=6.12p PS=12.4u PD=7u
* device instance $1810 r0 *1 511.6,64.9 NMOS
XM$1810 \$I4181 \$I4180 VSS VSS NMOS L=1u W=3.4u AS=6.12p AD=6.46p PS=7u PD=7.2u
* device instance $1811 r0 *1 516.4,64.9 NMOS
XM$1811 VSS \$I4181 \$I4180 VSS NMOS L=1u W=3.4u AS=6.46p AD=6.12p PS=7.2u PD=7u
* device instance $1812 r0 *1 521,64.9 NMOS
XM$1812 \$I4180 WL2 BLB21 VSS NMOS L=1u W=3.4u AS=6.12p AD=9.52p PS=7u PD=12.4u
* device instance $1813 m0 *1 533.6,329.1 PMOS
XM$1813 \$I4183 \$I4182 VDD VDD PMOS L=1u W=3.4u AS=10.88p AD=6.46p PS=13.2u
+ PD=7.2u
* device instance $1814 m0 *1 538.4,329.1 PMOS
XM$1814 VDD \$I4183 \$I4182 VDD PMOS L=1u W=3.4u AS=6.46p AD=10.88p PS=7.2u
+ PD=13.2u
* device instance $1815 m0 *1 529,349.5 NMOS
XM$1815 BL22 WL11 \$I4183 VSS NMOS L=1u W=3.4u AS=9.52p AD=6.12p PS=12.4u PD=7u
* device instance $1816 m0 *1 533.6,349.5 NMOS
XM$1816 \$I4183 \$I4182 VSS VSS NMOS L=1u W=3.4u AS=6.12p AD=6.46p PS=7u PD=7.2u
* device instance $1817 m0 *1 538.4,349.5 NMOS
XM$1817 VSS \$I4183 \$I4182 VSS NMOS L=1u W=3.4u AS=6.46p AD=6.12p PS=7.2u PD=7u
* device instance $1818 m0 *1 543,349.5 NMOS
XM$1818 \$I4182 WL11 BLB22 VSS NMOS L=1u W=3.4u AS=6.12p AD=9.52p PS=7u PD=12.4u
* device instance $1819 m0 *1 533.6,269.9 PMOS
XM$1819 \$I4185 \$I4184 VDD VDD PMOS L=1u W=3.4u AS=10.88p AD=6.46p PS=13.2u
+ PD=7.2u
* device instance $1820 m0 *1 538.4,269.9 PMOS
XM$1820 VDD \$I4185 \$I4184 VDD PMOS L=1u W=3.4u AS=6.46p AD=10.88p PS=7.2u
+ PD=13.2u
* device instance $1821 m0 *1 529,290.3 NMOS
XM$1821 BL22 WL9 \$I4185 VSS NMOS L=1u W=3.4u AS=9.52p AD=6.12p PS=12.4u PD=7u
* device instance $1822 m0 *1 533.6,290.3 NMOS
XM$1822 \$I4185 \$I4184 VSS VSS NMOS L=1u W=3.4u AS=6.12p AD=6.46p PS=7u PD=7.2u
* device instance $1823 m0 *1 538.4,290.3 NMOS
XM$1823 VSS \$I4185 \$I4184 VSS NMOS L=1u W=3.4u AS=6.46p AD=6.12p PS=7.2u PD=7u
* device instance $1824 m0 *1 543,290.3 NMOS
XM$1824 \$I4184 WL9 BLB22 VSS NMOS L=1u W=3.4u AS=6.12p AD=9.52p PS=7u PD=12.4u
* device instance $1825 m0 *1 533.6,33.1 PMOS
XM$1825 \$I4187 \$I4186 VDD VDD PMOS L=1u W=3.4u AS=10.88p AD=6.46p PS=13.2u
+ PD=7.2u
* device instance $1826 m0 *1 538.4,33.1 PMOS
XM$1826 VDD \$I4187 \$I4186 VDD PMOS L=1u W=3.4u AS=6.46p AD=10.88p PS=7.2u
+ PD=13.2u
* device instance $1827 m0 *1 529,53.5 NMOS
XM$1827 BL22 WL1 \$I4187 VSS NMOS L=1u W=3.4u AS=9.52p AD=6.12p PS=12.4u PD=7u
* device instance $1828 m0 *1 533.6,53.5 NMOS
XM$1828 \$I4187 \$I4186 VSS VSS NMOS L=1u W=3.4u AS=6.12p AD=6.46p PS=7u PD=7.2u
* device instance $1829 m0 *1 538.4,53.5 NMOS
XM$1829 VSS \$I4187 \$I4186 VSS NMOS L=1u W=3.4u AS=6.46p AD=6.12p PS=7.2u PD=7u
* device instance $1830 m0 *1 543,53.5 NMOS
XM$1830 \$I4186 WL1 BLB22 VSS NMOS L=1u W=3.4u AS=6.12p AD=9.52p PS=7u PD=12.4u
* device instance $1831 m0 *1 533.6,92.3 PMOS
XM$1831 \$I4189 \$I4188 VDD VDD PMOS L=1u W=3.4u AS=10.88p AD=6.46p PS=13.2u
+ PD=7.2u
* device instance $1832 m0 *1 538.4,92.3 PMOS
XM$1832 VDD \$I4189 \$I4188 VDD PMOS L=1u W=3.4u AS=6.46p AD=10.88p PS=7.2u
+ PD=13.2u
* device instance $1833 m0 *1 529,112.7 NMOS
XM$1833 BL22 WL3 \$I4189 VSS NMOS L=1u W=3.4u AS=9.52p AD=6.12p PS=12.4u PD=7u
* device instance $1834 m0 *1 533.6,112.7 NMOS
XM$1834 \$I4189 \$I4188 VSS VSS NMOS L=1u W=3.4u AS=6.12p AD=6.46p PS=7u PD=7.2u
* device instance $1835 m0 *1 538.4,112.7 NMOS
XM$1835 VSS \$I4189 \$I4188 VSS NMOS L=1u W=3.4u AS=6.46p AD=6.12p PS=7.2u PD=7u
* device instance $1836 m0 *1 543,112.7 NMOS
XM$1836 \$I4188 WL3 BLB22 VSS NMOS L=1u W=3.4u AS=6.12p AD=9.52p PS=7u PD=12.4u
* device instance $1837 m0 *1 533.6,447.5 PMOS
XM$1837 \$I4191 \$I4190 VDD VDD PMOS L=1u W=3.4u AS=10.88p AD=6.46p PS=13.2u
+ PD=7.2u
* device instance $1838 m0 *1 538.4,447.5 PMOS
XM$1838 VDD \$I4191 \$I4190 VDD PMOS L=1u W=3.4u AS=6.46p AD=10.88p PS=7.2u
+ PD=13.2u
* device instance $1839 m0 *1 529,467.9 NMOS
XM$1839 BL22 WL15 \$I4191 VSS NMOS L=1u W=3.4u AS=9.52p AD=6.12p PS=12.4u PD=7u
* device instance $1840 m0 *1 533.6,467.9 NMOS
XM$1840 \$I4191 \$I4190 VSS VSS NMOS L=1u W=3.4u AS=6.12p AD=6.46p PS=7u PD=7.2u
* device instance $1841 m0 *1 538.4,467.9 NMOS
XM$1841 VSS \$I4191 \$I4190 VSS NMOS L=1u W=3.4u AS=6.46p AD=6.12p PS=7.2u PD=7u
* device instance $1842 m0 *1 543,467.9 NMOS
XM$1842 \$I4190 WL15 BLB22 VSS NMOS L=1u W=3.4u AS=6.12p AD=9.52p PS=7u PD=12.4u
* device instance $1843 m0 *1 533.6,388.3 PMOS
XM$1843 \$I4193 \$I4192 VDD VDD PMOS L=1u W=3.4u AS=10.88p AD=6.46p PS=13.2u
+ PD=7.2u
* device instance $1844 m0 *1 538.4,388.3 PMOS
XM$1844 VDD \$I4193 \$I4192 VDD PMOS L=1u W=3.4u AS=6.46p AD=10.88p PS=7.2u
+ PD=13.2u
* device instance $1845 m0 *1 529,408.7 NMOS
XM$1845 BL22 WL13 \$I4193 VSS NMOS L=1u W=3.4u AS=9.52p AD=6.12p PS=12.4u PD=7u
* device instance $1846 m0 *1 533.6,408.7 NMOS
XM$1846 \$I4193 \$I4192 VSS VSS NMOS L=1u W=3.4u AS=6.12p AD=6.46p PS=7u PD=7.2u
* device instance $1847 m0 *1 538.4,408.7 NMOS
XM$1847 VSS \$I4193 \$I4192 VSS NMOS L=1u W=3.4u AS=6.46p AD=6.12p PS=7.2u PD=7u
* device instance $1848 m0 *1 543,408.7 NMOS
XM$1848 \$I4192 WL13 BLB22 VSS NMOS L=1u W=3.4u AS=6.12p AD=9.52p PS=7u PD=12.4u
* device instance $1849 m0 *1 533.6,210.7 PMOS
XM$1849 \$I4195 \$I4194 VDD VDD PMOS L=1u W=3.4u AS=10.88p AD=6.46p PS=13.2u
+ PD=7.2u
* device instance $1850 m0 *1 538.4,210.7 PMOS
XM$1850 VDD \$I4195 \$I4194 VDD PMOS L=1u W=3.4u AS=6.46p AD=10.88p PS=7.2u
+ PD=13.2u
* device instance $1851 m0 *1 529,231.1 NMOS
XM$1851 BL22 WL7 \$I4195 VSS NMOS L=1u W=3.4u AS=9.52p AD=6.12p PS=12.4u PD=7u
* device instance $1852 m0 *1 533.6,231.1 NMOS
XM$1852 \$I4195 \$I4194 VSS VSS NMOS L=1u W=3.4u AS=6.12p AD=6.46p PS=7u PD=7.2u
* device instance $1853 m0 *1 538.4,231.1 NMOS
XM$1853 VSS \$I4195 \$I4194 VSS NMOS L=1u W=3.4u AS=6.46p AD=6.12p PS=7.2u PD=7u
* device instance $1854 m0 *1 543,231.1 NMOS
XM$1854 \$I4194 WL7 BLB22 VSS NMOS L=1u W=3.4u AS=6.12p AD=9.52p PS=7u PD=12.4u
* device instance $1855 m0 *1 533.6,151.5 PMOS
XM$1855 \$I4197 \$I4196 VDD VDD PMOS L=1u W=3.4u AS=10.88p AD=6.46p PS=13.2u
+ PD=7.2u
* device instance $1856 m0 *1 538.4,151.5 PMOS
XM$1856 VDD \$I4197 \$I4196 VDD PMOS L=1u W=3.4u AS=6.46p AD=10.88p PS=7.2u
+ PD=13.2u
* device instance $1857 m0 *1 529,171.9 NMOS
XM$1857 BL22 WL5 \$I4197 VSS NMOS L=1u W=3.4u AS=9.52p AD=6.12p PS=12.4u PD=7u
* device instance $1858 m0 *1 533.6,171.9 NMOS
XM$1858 \$I4197 \$I4196 VSS VSS NMOS L=1u W=3.4u AS=6.12p AD=6.46p PS=7u PD=7.2u
* device instance $1859 m0 *1 538.4,171.9 NMOS
XM$1859 VSS \$I4197 \$I4196 VSS NMOS L=1u W=3.4u AS=6.46p AD=6.12p PS=7.2u PD=7u
* device instance $1860 m0 *1 543,171.9 NMOS
XM$1860 \$I4196 WL5 BLB22 VSS NMOS L=1u W=3.4u AS=6.12p AD=9.52p PS=7u PD=12.4u
* device instance $1861 r0 *1 533.6,440.5 PMOS
XM$1861 \$I4199 \$I4198 VDD VDD PMOS L=1u W=3.4u AS=10.88p AD=6.46p PS=13.2u
+ PD=7.2u
* device instance $1862 r0 *1 538.4,440.5 PMOS
XM$1862 VDD \$I4199 \$I4198 VDD PMOS L=1u W=3.4u AS=6.46p AD=10.88p PS=7.2u
+ PD=13.2u
* device instance $1863 r0 *1 529,420.1 NMOS
XM$1863 BL22 WL14 \$I4199 VSS NMOS L=1u W=3.4u AS=9.52p AD=6.12p PS=12.4u PD=7u
* device instance $1864 r0 *1 533.6,420.1 NMOS
XM$1864 \$I4199 \$I4198 VSS VSS NMOS L=1u W=3.4u AS=6.12p AD=6.46p PS=7u PD=7.2u
* device instance $1865 r0 *1 538.4,420.1 NMOS
XM$1865 VSS \$I4199 \$I4198 VSS NMOS L=1u W=3.4u AS=6.46p AD=6.12p PS=7.2u PD=7u
* device instance $1866 r0 *1 543,420.1 NMOS
XM$1866 \$I4198 WL14 BLB22 VSS NMOS L=1u W=3.4u AS=6.12p AD=9.52p PS=7u PD=12.4u
* device instance $1867 r0 *1 533.6,381.3 PMOS
XM$1867 \$I4201 \$I4200 VDD VDD PMOS L=1u W=3.4u AS=10.88p AD=6.46p PS=13.2u
+ PD=7.2u
* device instance $1868 r0 *1 538.4,381.3 PMOS
XM$1868 VDD \$I4201 \$I4200 VDD PMOS L=1u W=3.4u AS=6.46p AD=10.88p PS=7.2u
+ PD=13.2u
* device instance $1869 r0 *1 529,360.9 NMOS
XM$1869 BL22 WL12 \$I4201 VSS NMOS L=1u W=3.4u AS=9.52p AD=6.12p PS=12.4u PD=7u
* device instance $1870 r0 *1 533.6,360.9 NMOS
XM$1870 \$I4201 \$I4200 VSS VSS NMOS L=1u W=3.4u AS=6.12p AD=6.46p PS=7u PD=7.2u
* device instance $1871 r0 *1 538.4,360.9 NMOS
XM$1871 VSS \$I4201 \$I4200 VSS NMOS L=1u W=3.4u AS=6.46p AD=6.12p PS=7.2u PD=7u
* device instance $1872 r0 *1 543,360.9 NMOS
XM$1872 \$I4200 WL12 BLB22 VSS NMOS L=1u W=3.4u AS=6.12p AD=9.52p PS=7u PD=12.4u
* device instance $1873 r0 *1 533.6,262.9 PMOS
XM$1873 \$I4203 \$I4202 VDD VDD PMOS L=1u W=3.4u AS=10.88p AD=6.46p PS=13.2u
+ PD=7.2u
* device instance $1874 r0 *1 538.4,262.9 PMOS
XM$1874 VDD \$I4203 \$I4202 VDD PMOS L=1u W=3.4u AS=6.46p AD=10.88p PS=7.2u
+ PD=13.2u
* device instance $1875 r0 *1 529,242.5 NMOS
XM$1875 BL22 WL8 \$I4203 VSS NMOS L=1u W=3.4u AS=9.52p AD=6.12p PS=12.4u PD=7u
* device instance $1876 r0 *1 533.6,242.5 NMOS
XM$1876 \$I4203 \$I4202 VSS VSS NMOS L=1u W=3.4u AS=6.12p AD=6.46p PS=7u PD=7.2u
* device instance $1877 r0 *1 538.4,242.5 NMOS
XM$1877 VSS \$I4203 \$I4202 VSS NMOS L=1u W=3.4u AS=6.46p AD=6.12p PS=7.2u PD=7u
* device instance $1878 r0 *1 543,242.5 NMOS
XM$1878 \$I4202 WL8 BLB22 VSS NMOS L=1u W=3.4u AS=6.12p AD=9.52p PS=7u PD=12.4u
* device instance $1879 r0 *1 533.6,322.1 PMOS
XM$1879 \$I4205 \$I4204 VDD VDD PMOS L=1u W=3.4u AS=10.88p AD=6.46p PS=13.2u
+ PD=7.2u
* device instance $1880 r0 *1 538.4,322.1 PMOS
XM$1880 VDD \$I4205 \$I4204 VDD PMOS L=1u W=3.4u AS=6.46p AD=10.88p PS=7.2u
+ PD=13.2u
* device instance $1881 r0 *1 529,301.7 NMOS
XM$1881 BL22 WL10 \$I4205 VSS NMOS L=1u W=3.4u AS=9.52p AD=6.12p PS=12.4u PD=7u
* device instance $1882 r0 *1 533.6,301.7 NMOS
XM$1882 \$I4205 \$I4204 VSS VSS NMOS L=1u W=3.4u AS=6.12p AD=6.46p PS=7u PD=7.2u
* device instance $1883 r0 *1 538.4,301.7 NMOS
XM$1883 VSS \$I4205 \$I4204 VSS NMOS L=1u W=3.4u AS=6.46p AD=6.12p PS=7.2u PD=7u
* device instance $1884 r0 *1 543,301.7 NMOS
XM$1884 \$I4204 WL10 BLB22 VSS NMOS L=1u W=3.4u AS=6.12p AD=9.52p PS=7u PD=12.4u
* device instance $1885 r0 *1 533.6,203.7 PMOS
XM$1885 \$I4207 \$I4206 VDD VDD PMOS L=1u W=3.4u AS=10.88p AD=6.46p PS=13.2u
+ PD=7.2u
* device instance $1886 r0 *1 538.4,203.7 PMOS
XM$1886 VDD \$I4207 \$I4206 VDD PMOS L=1u W=3.4u AS=6.46p AD=10.88p PS=7.2u
+ PD=13.2u
* device instance $1887 r0 *1 529,183.3 NMOS
XM$1887 BL22 WL6 \$I4207 VSS NMOS L=1u W=3.4u AS=9.52p AD=6.12p PS=12.4u PD=7u
* device instance $1888 r0 *1 533.6,183.3 NMOS
XM$1888 \$I4207 \$I4206 VSS VSS NMOS L=1u W=3.4u AS=6.12p AD=6.46p PS=7u PD=7.2u
* device instance $1889 r0 *1 538.4,183.3 NMOS
XM$1889 VSS \$I4207 \$I4206 VSS NMOS L=1u W=3.4u AS=6.46p AD=6.12p PS=7.2u PD=7u
* device instance $1890 r0 *1 543,183.3 NMOS
XM$1890 \$I4206 WL6 BLB22 VSS NMOS L=1u W=3.4u AS=6.12p AD=9.52p PS=7u PD=12.4u
* device instance $1891 r0 *1 533.6,144.5 PMOS
XM$1891 \$I4209 \$I4208 VDD VDD PMOS L=1u W=3.4u AS=10.88p AD=6.46p PS=13.2u
+ PD=7.2u
* device instance $1892 r0 *1 538.4,144.5 PMOS
XM$1892 VDD \$I4209 \$I4208 VDD PMOS L=1u W=3.4u AS=6.46p AD=10.88p PS=7.2u
+ PD=13.2u
* device instance $1893 r0 *1 529,124.1 NMOS
XM$1893 BL22 WL4 \$I4209 VSS NMOS L=1u W=3.4u AS=9.52p AD=6.12p PS=12.4u PD=7u
* device instance $1894 r0 *1 533.6,124.1 NMOS
XM$1894 \$I4209 \$I4208 VSS VSS NMOS L=1u W=3.4u AS=6.12p AD=6.46p PS=7u PD=7.2u
* device instance $1895 r0 *1 538.4,124.1 NMOS
XM$1895 VSS \$I4209 \$I4208 VSS NMOS L=1u W=3.4u AS=6.46p AD=6.12p PS=7.2u PD=7u
* device instance $1896 r0 *1 543,124.1 NMOS
XM$1896 \$I4208 WL4 BLB22 VSS NMOS L=1u W=3.4u AS=6.12p AD=9.52p PS=7u PD=12.4u
* device instance $1897 r0 *1 533.6,85.3 PMOS
XM$1897 \$I4211 \$I4210 VDD VDD PMOS L=1u W=3.4u AS=10.88p AD=6.46p PS=13.2u
+ PD=7.2u
* device instance $1898 r0 *1 538.4,85.3 PMOS
XM$1898 VDD \$I4211 \$I4210 VDD PMOS L=1u W=3.4u AS=6.46p AD=10.88p PS=7.2u
+ PD=13.2u
* device instance $1899 r0 *1 529,64.9 NMOS
XM$1899 BL22 WL2 \$I4211 VSS NMOS L=1u W=3.4u AS=9.52p AD=6.12p PS=12.4u PD=7u
* device instance $1900 r0 *1 533.6,64.9 NMOS
XM$1900 \$I4211 \$I4210 VSS VSS NMOS L=1u W=3.4u AS=6.12p AD=6.46p PS=7u PD=7.2u
* device instance $1901 r0 *1 538.4,64.9 NMOS
XM$1901 VSS \$I4211 \$I4210 VSS NMOS L=1u W=3.4u AS=6.46p AD=6.12p PS=7.2u PD=7u
* device instance $1902 r0 *1 543,64.9 NMOS
XM$1902 \$I4210 WL2 BLB22 VSS NMOS L=1u W=3.4u AS=6.12p AD=9.52p PS=7u PD=12.4u
* device instance $1903 m0 *1 555.6,329.1 PMOS
XM$1903 \$I4213 \$I4212 VDD VDD PMOS L=1u W=3.4u AS=10.88p AD=6.46p PS=13.2u
+ PD=7.2u
* device instance $1904 m0 *1 560.4,329.1 PMOS
XM$1904 VDD \$I4213 \$I4212 VDD PMOS L=1u W=3.4u AS=6.46p AD=10.88p PS=7.2u
+ PD=13.2u
* device instance $1905 m0 *1 551,349.5 NMOS
XM$1905 BL23 WL11 \$I4213 VSS NMOS L=1u W=3.4u AS=9.52p AD=6.12p PS=12.4u PD=7u
* device instance $1906 m0 *1 555.6,349.5 NMOS
XM$1906 \$I4213 \$I4212 VSS VSS NMOS L=1u W=3.4u AS=6.12p AD=6.46p PS=7u PD=7.2u
* device instance $1907 m0 *1 560.4,349.5 NMOS
XM$1907 VSS \$I4213 \$I4212 VSS NMOS L=1u W=3.4u AS=6.46p AD=6.12p PS=7.2u PD=7u
* device instance $1908 m0 *1 565,349.5 NMOS
XM$1908 \$I4212 WL11 BLB23 VSS NMOS L=1u W=3.4u AS=6.12p AD=9.52p PS=7u PD=12.4u
* device instance $1909 m0 *1 555.6,269.9 PMOS
XM$1909 \$I4215 \$I4214 VDD VDD PMOS L=1u W=3.4u AS=10.88p AD=6.46p PS=13.2u
+ PD=7.2u
* device instance $1910 m0 *1 560.4,269.9 PMOS
XM$1910 VDD \$I4215 \$I4214 VDD PMOS L=1u W=3.4u AS=6.46p AD=10.88p PS=7.2u
+ PD=13.2u
* device instance $1911 m0 *1 551,290.3 NMOS
XM$1911 BL23 WL9 \$I4215 VSS NMOS L=1u W=3.4u AS=9.52p AD=6.12p PS=12.4u PD=7u
* device instance $1912 m0 *1 555.6,290.3 NMOS
XM$1912 \$I4215 \$I4214 VSS VSS NMOS L=1u W=3.4u AS=6.12p AD=6.46p PS=7u PD=7.2u
* device instance $1913 m0 *1 560.4,290.3 NMOS
XM$1913 VSS \$I4215 \$I4214 VSS NMOS L=1u W=3.4u AS=6.46p AD=6.12p PS=7.2u PD=7u
* device instance $1914 m0 *1 565,290.3 NMOS
XM$1914 \$I4214 WL9 BLB23 VSS NMOS L=1u W=3.4u AS=6.12p AD=9.52p PS=7u PD=12.4u
* device instance $1915 m0 *1 555.6,33.1 PMOS
XM$1915 \$I4217 \$I4216 VDD VDD PMOS L=1u W=3.4u AS=10.88p AD=6.46p PS=13.2u
+ PD=7.2u
* device instance $1916 m0 *1 560.4,33.1 PMOS
XM$1916 VDD \$I4217 \$I4216 VDD PMOS L=1u W=3.4u AS=6.46p AD=10.88p PS=7.2u
+ PD=13.2u
* device instance $1917 m0 *1 551,53.5 NMOS
XM$1917 BL23 WL1 \$I4217 VSS NMOS L=1u W=3.4u AS=9.52p AD=6.12p PS=12.4u PD=7u
* device instance $1918 m0 *1 555.6,53.5 NMOS
XM$1918 \$I4217 \$I4216 VSS VSS NMOS L=1u W=3.4u AS=6.12p AD=6.46p PS=7u PD=7.2u
* device instance $1919 m0 *1 560.4,53.5 NMOS
XM$1919 VSS \$I4217 \$I4216 VSS NMOS L=1u W=3.4u AS=6.46p AD=6.12p PS=7.2u PD=7u
* device instance $1920 m0 *1 565,53.5 NMOS
XM$1920 \$I4216 WL1 BLB23 VSS NMOS L=1u W=3.4u AS=6.12p AD=9.52p PS=7u PD=12.4u
* device instance $1921 m0 *1 555.6,92.3 PMOS
XM$1921 \$I4219 \$I4218 VDD VDD PMOS L=1u W=3.4u AS=10.88p AD=6.46p PS=13.2u
+ PD=7.2u
* device instance $1922 m0 *1 560.4,92.3 PMOS
XM$1922 VDD \$I4219 \$I4218 VDD PMOS L=1u W=3.4u AS=6.46p AD=10.88p PS=7.2u
+ PD=13.2u
* device instance $1923 m0 *1 551,112.7 NMOS
XM$1923 BL23 WL3 \$I4219 VSS NMOS L=1u W=3.4u AS=9.52p AD=6.12p PS=12.4u PD=7u
* device instance $1924 m0 *1 555.6,112.7 NMOS
XM$1924 \$I4219 \$I4218 VSS VSS NMOS L=1u W=3.4u AS=6.12p AD=6.46p PS=7u PD=7.2u
* device instance $1925 m0 *1 560.4,112.7 NMOS
XM$1925 VSS \$I4219 \$I4218 VSS NMOS L=1u W=3.4u AS=6.46p AD=6.12p PS=7.2u PD=7u
* device instance $1926 m0 *1 565,112.7 NMOS
XM$1926 \$I4218 WL3 BLB23 VSS NMOS L=1u W=3.4u AS=6.12p AD=9.52p PS=7u PD=12.4u
* device instance $1927 m0 *1 555.6,447.5 PMOS
XM$1927 \$I4221 \$I4220 VDD VDD PMOS L=1u W=3.4u AS=10.88p AD=6.46p PS=13.2u
+ PD=7.2u
* device instance $1928 m0 *1 560.4,447.5 PMOS
XM$1928 VDD \$I4221 \$I4220 VDD PMOS L=1u W=3.4u AS=6.46p AD=10.88p PS=7.2u
+ PD=13.2u
* device instance $1929 m0 *1 551,467.9 NMOS
XM$1929 BL23 WL15 \$I4221 VSS NMOS L=1u W=3.4u AS=9.52p AD=6.12p PS=12.4u PD=7u
* device instance $1930 m0 *1 555.6,467.9 NMOS
XM$1930 \$I4221 \$I4220 VSS VSS NMOS L=1u W=3.4u AS=6.12p AD=6.46p PS=7u PD=7.2u
* device instance $1931 m0 *1 560.4,467.9 NMOS
XM$1931 VSS \$I4221 \$I4220 VSS NMOS L=1u W=3.4u AS=6.46p AD=6.12p PS=7.2u PD=7u
* device instance $1932 m0 *1 565,467.9 NMOS
XM$1932 \$I4220 WL15 BLB23 VSS NMOS L=1u W=3.4u AS=6.12p AD=9.52p PS=7u PD=12.4u
* device instance $1933 m0 *1 555.6,210.7 PMOS
XM$1933 \$I4223 \$I4222 VDD VDD PMOS L=1u W=3.4u AS=10.88p AD=6.46p PS=13.2u
+ PD=7.2u
* device instance $1934 m0 *1 560.4,210.7 PMOS
XM$1934 VDD \$I4223 \$I4222 VDD PMOS L=1u W=3.4u AS=6.46p AD=10.88p PS=7.2u
+ PD=13.2u
* device instance $1935 m0 *1 551,231.1 NMOS
XM$1935 BL23 WL7 \$I4223 VSS NMOS L=1u W=3.4u AS=9.52p AD=6.12p PS=12.4u PD=7u
* device instance $1936 m0 *1 555.6,231.1 NMOS
XM$1936 \$I4223 \$I4222 VSS VSS NMOS L=1u W=3.4u AS=6.12p AD=6.46p PS=7u PD=7.2u
* device instance $1937 m0 *1 560.4,231.1 NMOS
XM$1937 VSS \$I4223 \$I4222 VSS NMOS L=1u W=3.4u AS=6.46p AD=6.12p PS=7.2u PD=7u
* device instance $1938 m0 *1 565,231.1 NMOS
XM$1938 \$I4222 WL7 BLB23 VSS NMOS L=1u W=3.4u AS=6.12p AD=9.52p PS=7u PD=12.4u
* device instance $1939 m0 *1 555.6,151.5 PMOS
XM$1939 \$I4225 \$I4224 VDD VDD PMOS L=1u W=3.4u AS=10.88p AD=6.46p PS=13.2u
+ PD=7.2u
* device instance $1940 m0 *1 560.4,151.5 PMOS
XM$1940 VDD \$I4225 \$I4224 VDD PMOS L=1u W=3.4u AS=6.46p AD=10.88p PS=7.2u
+ PD=13.2u
* device instance $1941 m0 *1 551,171.9 NMOS
XM$1941 BL23 WL5 \$I4225 VSS NMOS L=1u W=3.4u AS=9.52p AD=6.12p PS=12.4u PD=7u
* device instance $1942 m0 *1 555.6,171.9 NMOS
XM$1942 \$I4225 \$I4224 VSS VSS NMOS L=1u W=3.4u AS=6.12p AD=6.46p PS=7u PD=7.2u
* device instance $1943 m0 *1 560.4,171.9 NMOS
XM$1943 VSS \$I4225 \$I4224 VSS NMOS L=1u W=3.4u AS=6.46p AD=6.12p PS=7.2u PD=7u
* device instance $1944 m0 *1 565,171.9 NMOS
XM$1944 \$I4224 WL5 BLB23 VSS NMOS L=1u W=3.4u AS=6.12p AD=9.52p PS=7u PD=12.4u
* device instance $1945 m0 *1 555.6,388.3 PMOS
XM$1945 \$I4227 \$I4226 VDD VDD PMOS L=1u W=3.4u AS=10.88p AD=6.46p PS=13.2u
+ PD=7.2u
* device instance $1946 m0 *1 560.4,388.3 PMOS
XM$1946 VDD \$I4227 \$I4226 VDD PMOS L=1u W=3.4u AS=6.46p AD=10.88p PS=7.2u
+ PD=13.2u
* device instance $1947 m0 *1 551,408.7 NMOS
XM$1947 BL23 WL13 \$I4227 VSS NMOS L=1u W=3.4u AS=9.52p AD=6.12p PS=12.4u PD=7u
* device instance $1948 m0 *1 555.6,408.7 NMOS
XM$1948 \$I4227 \$I4226 VSS VSS NMOS L=1u W=3.4u AS=6.12p AD=6.46p PS=7u PD=7.2u
* device instance $1949 m0 *1 560.4,408.7 NMOS
XM$1949 VSS \$I4227 \$I4226 VSS NMOS L=1u W=3.4u AS=6.46p AD=6.12p PS=7.2u PD=7u
* device instance $1950 m0 *1 565,408.7 NMOS
XM$1950 \$I4226 WL13 BLB23 VSS NMOS L=1u W=3.4u AS=6.12p AD=9.52p PS=7u PD=12.4u
* device instance $1951 r0 *1 555.6,440.5 PMOS
XM$1951 \$I4229 \$I4228 VDD VDD PMOS L=1u W=3.4u AS=10.88p AD=6.46p PS=13.2u
+ PD=7.2u
* device instance $1952 r0 *1 560.4,440.5 PMOS
XM$1952 VDD \$I4229 \$I4228 VDD PMOS L=1u W=3.4u AS=6.46p AD=10.88p PS=7.2u
+ PD=13.2u
* device instance $1953 r0 *1 551,420.1 NMOS
XM$1953 BL23 WL14 \$I4229 VSS NMOS L=1u W=3.4u AS=9.52p AD=6.12p PS=12.4u PD=7u
* device instance $1954 r0 *1 555.6,420.1 NMOS
XM$1954 \$I4229 \$I4228 VSS VSS NMOS L=1u W=3.4u AS=6.12p AD=6.46p PS=7u PD=7.2u
* device instance $1955 r0 *1 560.4,420.1 NMOS
XM$1955 VSS \$I4229 \$I4228 VSS NMOS L=1u W=3.4u AS=6.46p AD=6.12p PS=7.2u PD=7u
* device instance $1956 r0 *1 565,420.1 NMOS
XM$1956 \$I4228 WL14 BLB23 VSS NMOS L=1u W=3.4u AS=6.12p AD=9.52p PS=7u PD=12.4u
* device instance $1957 r0 *1 555.6,381.3 PMOS
XM$1957 \$I4231 \$I4230 VDD VDD PMOS L=1u W=3.4u AS=10.88p AD=6.46p PS=13.2u
+ PD=7.2u
* device instance $1958 r0 *1 560.4,381.3 PMOS
XM$1958 VDD \$I4231 \$I4230 VDD PMOS L=1u W=3.4u AS=6.46p AD=10.88p PS=7.2u
+ PD=13.2u
* device instance $1959 r0 *1 551,360.9 NMOS
XM$1959 BL23 WL12 \$I4231 VSS NMOS L=1u W=3.4u AS=9.52p AD=6.12p PS=12.4u PD=7u
* device instance $1960 r0 *1 555.6,360.9 NMOS
XM$1960 \$I4231 \$I4230 VSS VSS NMOS L=1u W=3.4u AS=6.12p AD=6.46p PS=7u PD=7.2u
* device instance $1961 r0 *1 560.4,360.9 NMOS
XM$1961 VSS \$I4231 \$I4230 VSS NMOS L=1u W=3.4u AS=6.46p AD=6.12p PS=7.2u PD=7u
* device instance $1962 r0 *1 565,360.9 NMOS
XM$1962 \$I4230 WL12 BLB23 VSS NMOS L=1u W=3.4u AS=6.12p AD=9.52p PS=7u PD=12.4u
* device instance $1963 r0 *1 555.6,262.9 PMOS
XM$1963 \$I4233 \$I4232 VDD VDD PMOS L=1u W=3.4u AS=10.88p AD=6.46p PS=13.2u
+ PD=7.2u
* device instance $1964 r0 *1 560.4,262.9 PMOS
XM$1964 VDD \$I4233 \$I4232 VDD PMOS L=1u W=3.4u AS=6.46p AD=10.88p PS=7.2u
+ PD=13.2u
* device instance $1965 r0 *1 551,242.5 NMOS
XM$1965 BL23 WL8 \$I4233 VSS NMOS L=1u W=3.4u AS=9.52p AD=6.12p PS=12.4u PD=7u
* device instance $1966 r0 *1 555.6,242.5 NMOS
XM$1966 \$I4233 \$I4232 VSS VSS NMOS L=1u W=3.4u AS=6.12p AD=6.46p PS=7u PD=7.2u
* device instance $1967 r0 *1 560.4,242.5 NMOS
XM$1967 VSS \$I4233 \$I4232 VSS NMOS L=1u W=3.4u AS=6.46p AD=6.12p PS=7.2u PD=7u
* device instance $1968 r0 *1 565,242.5 NMOS
XM$1968 \$I4232 WL8 BLB23 VSS NMOS L=1u W=3.4u AS=6.12p AD=9.52p PS=7u PD=12.4u
* device instance $1969 r0 *1 555.6,322.1 PMOS
XM$1969 \$I4235 \$I4234 VDD VDD PMOS L=1u W=3.4u AS=10.88p AD=6.46p PS=13.2u
+ PD=7.2u
* device instance $1970 r0 *1 560.4,322.1 PMOS
XM$1970 VDD \$I4235 \$I4234 VDD PMOS L=1u W=3.4u AS=6.46p AD=10.88p PS=7.2u
+ PD=13.2u
* device instance $1971 r0 *1 551,301.7 NMOS
XM$1971 BL23 WL10 \$I4235 VSS NMOS L=1u W=3.4u AS=9.52p AD=6.12p PS=12.4u PD=7u
* device instance $1972 r0 *1 555.6,301.7 NMOS
XM$1972 \$I4235 \$I4234 VSS VSS NMOS L=1u W=3.4u AS=6.12p AD=6.46p PS=7u PD=7.2u
* device instance $1973 r0 *1 560.4,301.7 NMOS
XM$1973 VSS \$I4235 \$I4234 VSS NMOS L=1u W=3.4u AS=6.46p AD=6.12p PS=7.2u PD=7u
* device instance $1974 r0 *1 565,301.7 NMOS
XM$1974 \$I4234 WL10 BLB23 VSS NMOS L=1u W=3.4u AS=6.12p AD=9.52p PS=7u PD=12.4u
* device instance $1975 r0 *1 555.6,203.7 PMOS
XM$1975 \$I4237 \$I4236 VDD VDD PMOS L=1u W=3.4u AS=10.88p AD=6.46p PS=13.2u
+ PD=7.2u
* device instance $1976 r0 *1 560.4,203.7 PMOS
XM$1976 VDD \$I4237 \$I4236 VDD PMOS L=1u W=3.4u AS=6.46p AD=10.88p PS=7.2u
+ PD=13.2u
* device instance $1977 r0 *1 551,183.3 NMOS
XM$1977 BL23 WL6 \$I4237 VSS NMOS L=1u W=3.4u AS=9.52p AD=6.12p PS=12.4u PD=7u
* device instance $1978 r0 *1 555.6,183.3 NMOS
XM$1978 \$I4237 \$I4236 VSS VSS NMOS L=1u W=3.4u AS=6.12p AD=6.46p PS=7u PD=7.2u
* device instance $1979 r0 *1 560.4,183.3 NMOS
XM$1979 VSS \$I4237 \$I4236 VSS NMOS L=1u W=3.4u AS=6.46p AD=6.12p PS=7.2u PD=7u
* device instance $1980 r0 *1 565,183.3 NMOS
XM$1980 \$I4236 WL6 BLB23 VSS NMOS L=1u W=3.4u AS=6.12p AD=9.52p PS=7u PD=12.4u
* device instance $1981 r0 *1 555.6,144.5 PMOS
XM$1981 \$I4239 \$I4238 VDD VDD PMOS L=1u W=3.4u AS=10.88p AD=6.46p PS=13.2u
+ PD=7.2u
* device instance $1982 r0 *1 560.4,144.5 PMOS
XM$1982 VDD \$I4239 \$I4238 VDD PMOS L=1u W=3.4u AS=6.46p AD=10.88p PS=7.2u
+ PD=13.2u
* device instance $1983 r0 *1 551,124.1 NMOS
XM$1983 BL23 WL4 \$I4239 VSS NMOS L=1u W=3.4u AS=9.52p AD=6.12p PS=12.4u PD=7u
* device instance $1984 r0 *1 555.6,124.1 NMOS
XM$1984 \$I4239 \$I4238 VSS VSS NMOS L=1u W=3.4u AS=6.12p AD=6.46p PS=7u PD=7.2u
* device instance $1985 r0 *1 560.4,124.1 NMOS
XM$1985 VSS \$I4239 \$I4238 VSS NMOS L=1u W=3.4u AS=6.46p AD=6.12p PS=7.2u PD=7u
* device instance $1986 r0 *1 565,124.1 NMOS
XM$1986 \$I4238 WL4 BLB23 VSS NMOS L=1u W=3.4u AS=6.12p AD=9.52p PS=7u PD=12.4u
* device instance $1987 r0 *1 555.6,85.3 PMOS
XM$1987 \$I4241 \$I4240 VDD VDD PMOS L=1u W=3.4u AS=10.88p AD=6.46p PS=13.2u
+ PD=7.2u
* device instance $1988 r0 *1 560.4,85.3 PMOS
XM$1988 VDD \$I4241 \$I4240 VDD PMOS L=1u W=3.4u AS=6.46p AD=10.88p PS=7.2u
+ PD=13.2u
* device instance $1989 r0 *1 551,64.9 NMOS
XM$1989 BL23 WL2 \$I4241 VSS NMOS L=1u W=3.4u AS=9.52p AD=6.12p PS=12.4u PD=7u
* device instance $1990 r0 *1 555.6,64.9 NMOS
XM$1990 \$I4241 \$I4240 VSS VSS NMOS L=1u W=3.4u AS=6.12p AD=6.46p PS=7u PD=7.2u
* device instance $1991 r0 *1 560.4,64.9 NMOS
XM$1991 VSS \$I4241 \$I4240 VSS NMOS L=1u W=3.4u AS=6.46p AD=6.12p PS=7.2u PD=7u
* device instance $1992 r0 *1 565,64.9 NMOS
XM$1992 \$I4240 WL2 BLB23 VSS NMOS L=1u W=3.4u AS=6.12p AD=9.52p PS=7u PD=12.4u
* device instance $1993 m0 *1 445.6,329.1 PMOS
XM$1993 \$I4243 \$I4242 VDD VDD PMOS L=1u W=3.4u AS=10.88p AD=6.46p PS=13.2u
+ PD=7.2u
* device instance $1994 m0 *1 450.4,329.1 PMOS
XM$1994 VDD \$I4243 \$I4242 VDD PMOS L=1u W=3.4u AS=6.46p AD=10.88p PS=7.2u
+ PD=13.2u
* device instance $1995 m0 *1 441,349.5 NMOS
XM$1995 BL18 WL11 \$I4243 VSS NMOS L=1u W=3.4u AS=9.52p AD=6.12p PS=12.4u PD=7u
* device instance $1996 m0 *1 445.6,349.5 NMOS
XM$1996 \$I4243 \$I4242 VSS VSS NMOS L=1u W=3.4u AS=6.12p AD=6.46p PS=7u PD=7.2u
* device instance $1997 m0 *1 450.4,349.5 NMOS
XM$1997 VSS \$I4243 \$I4242 VSS NMOS L=1u W=3.4u AS=6.46p AD=6.12p PS=7.2u PD=7u
* device instance $1998 m0 *1 455,349.5 NMOS
XM$1998 \$I4242 WL11 BLB18 VSS NMOS L=1u W=3.4u AS=6.12p AD=9.52p PS=7u PD=12.4u
* device instance $1999 m0 *1 445.6,269.9 PMOS
XM$1999 \$I4245 \$I4244 VDD VDD PMOS L=1u W=3.4u AS=10.88p AD=6.46p PS=13.2u
+ PD=7.2u
* device instance $2000 m0 *1 450.4,269.9 PMOS
XM$2000 VDD \$I4245 \$I4244 VDD PMOS L=1u W=3.4u AS=6.46p AD=10.88p PS=7.2u
+ PD=13.2u
* device instance $2001 m0 *1 441,290.3 NMOS
XM$2001 BL18 WL9 \$I4245 VSS NMOS L=1u W=3.4u AS=9.52p AD=6.12p PS=12.4u PD=7u
* device instance $2002 m0 *1 445.6,290.3 NMOS
XM$2002 \$I4245 \$I4244 VSS VSS NMOS L=1u W=3.4u AS=6.12p AD=6.46p PS=7u PD=7.2u
* device instance $2003 m0 *1 450.4,290.3 NMOS
XM$2003 VSS \$I4245 \$I4244 VSS NMOS L=1u W=3.4u AS=6.46p AD=6.12p PS=7.2u PD=7u
* device instance $2004 m0 *1 455,290.3 NMOS
XM$2004 \$I4244 WL9 BLB18 VSS NMOS L=1u W=3.4u AS=6.12p AD=9.52p PS=7u PD=12.4u
* device instance $2005 m0 *1 445.6,33.1 PMOS
XM$2005 \$I4247 \$I4246 VDD VDD PMOS L=1u W=3.4u AS=10.88p AD=6.46p PS=13.2u
+ PD=7.2u
* device instance $2006 m0 *1 450.4,33.1 PMOS
XM$2006 VDD \$I4247 \$I4246 VDD PMOS L=1u W=3.4u AS=6.46p AD=10.88p PS=7.2u
+ PD=13.2u
* device instance $2007 m0 *1 441,53.5 NMOS
XM$2007 BL18 WL1 \$I4247 VSS NMOS L=1u W=3.4u AS=9.52p AD=6.12p PS=12.4u PD=7u
* device instance $2008 m0 *1 445.6,53.5 NMOS
XM$2008 \$I4247 \$I4246 VSS VSS NMOS L=1u W=3.4u AS=6.12p AD=6.46p PS=7u PD=7.2u
* device instance $2009 m0 *1 450.4,53.5 NMOS
XM$2009 VSS \$I4247 \$I4246 VSS NMOS L=1u W=3.4u AS=6.46p AD=6.12p PS=7.2u PD=7u
* device instance $2010 m0 *1 455,53.5 NMOS
XM$2010 \$I4246 WL1 BLB18 VSS NMOS L=1u W=3.4u AS=6.12p AD=9.52p PS=7u PD=12.4u
* device instance $2011 m0 *1 445.6,92.3 PMOS
XM$2011 \$I4249 \$I4248 VDD VDD PMOS L=1u W=3.4u AS=10.88p AD=6.46p PS=13.2u
+ PD=7.2u
* device instance $2012 m0 *1 450.4,92.3 PMOS
XM$2012 VDD \$I4249 \$I4248 VDD PMOS L=1u W=3.4u AS=6.46p AD=10.88p PS=7.2u
+ PD=13.2u
* device instance $2013 m0 *1 441,112.7 NMOS
XM$2013 BL18 WL3 \$I4249 VSS NMOS L=1u W=3.4u AS=9.52p AD=6.12p PS=12.4u PD=7u
* device instance $2014 m0 *1 445.6,112.7 NMOS
XM$2014 \$I4249 \$I4248 VSS VSS NMOS L=1u W=3.4u AS=6.12p AD=6.46p PS=7u PD=7.2u
* device instance $2015 m0 *1 450.4,112.7 NMOS
XM$2015 VSS \$I4249 \$I4248 VSS NMOS L=1u W=3.4u AS=6.46p AD=6.12p PS=7.2u PD=7u
* device instance $2016 m0 *1 455,112.7 NMOS
XM$2016 \$I4248 WL3 BLB18 VSS NMOS L=1u W=3.4u AS=6.12p AD=9.52p PS=7u PD=12.4u
* device instance $2017 m0 *1 445.6,447.5 PMOS
XM$2017 \$I4251 \$I4250 VDD VDD PMOS L=1u W=3.4u AS=10.88p AD=6.46p PS=13.2u
+ PD=7.2u
* device instance $2018 m0 *1 450.4,447.5 PMOS
XM$2018 VDD \$I4251 \$I4250 VDD PMOS L=1u W=3.4u AS=6.46p AD=10.88p PS=7.2u
+ PD=13.2u
* device instance $2019 m0 *1 441,467.9 NMOS
XM$2019 BL18 WL15 \$I4251 VSS NMOS L=1u W=3.4u AS=9.52p AD=6.12p PS=12.4u PD=7u
* device instance $2020 m0 *1 445.6,467.9 NMOS
XM$2020 \$I4251 \$I4250 VSS VSS NMOS L=1u W=3.4u AS=6.12p AD=6.46p PS=7u PD=7.2u
* device instance $2021 m0 *1 450.4,467.9 NMOS
XM$2021 VSS \$I4251 \$I4250 VSS NMOS L=1u W=3.4u AS=6.46p AD=6.12p PS=7.2u PD=7u
* device instance $2022 m0 *1 455,467.9 NMOS
XM$2022 \$I4250 WL15 BLB18 VSS NMOS L=1u W=3.4u AS=6.12p AD=9.52p PS=7u PD=12.4u
* device instance $2023 m0 *1 445.6,210.7 PMOS
XM$2023 \$I4253 \$I4252 VDD VDD PMOS L=1u W=3.4u AS=10.88p AD=6.46p PS=13.2u
+ PD=7.2u
* device instance $2024 m0 *1 450.4,210.7 PMOS
XM$2024 VDD \$I4253 \$I4252 VDD PMOS L=1u W=3.4u AS=6.46p AD=10.88p PS=7.2u
+ PD=13.2u
* device instance $2025 m0 *1 441,231.1 NMOS
XM$2025 BL18 WL7 \$I4253 VSS NMOS L=1u W=3.4u AS=9.52p AD=6.12p PS=12.4u PD=7u
* device instance $2026 m0 *1 445.6,231.1 NMOS
XM$2026 \$I4253 \$I4252 VSS VSS NMOS L=1u W=3.4u AS=6.12p AD=6.46p PS=7u PD=7.2u
* device instance $2027 m0 *1 450.4,231.1 NMOS
XM$2027 VSS \$I4253 \$I4252 VSS NMOS L=1u W=3.4u AS=6.46p AD=6.12p PS=7.2u PD=7u
* device instance $2028 m0 *1 455,231.1 NMOS
XM$2028 \$I4252 WL7 BLB18 VSS NMOS L=1u W=3.4u AS=6.12p AD=9.52p PS=7u PD=12.4u
* device instance $2029 m0 *1 445.6,388.3 PMOS
XM$2029 \$I4255 \$I4254 VDD VDD PMOS L=1u W=3.4u AS=10.88p AD=6.46p PS=13.2u
+ PD=7.2u
* device instance $2030 m0 *1 450.4,388.3 PMOS
XM$2030 VDD \$I4255 \$I4254 VDD PMOS L=1u W=3.4u AS=6.46p AD=10.88p PS=7.2u
+ PD=13.2u
* device instance $2031 m0 *1 441,408.7 NMOS
XM$2031 BL18 WL13 \$I4255 VSS NMOS L=1u W=3.4u AS=9.52p AD=6.12p PS=12.4u PD=7u
* device instance $2032 m0 *1 445.6,408.7 NMOS
XM$2032 \$I4255 \$I4254 VSS VSS NMOS L=1u W=3.4u AS=6.12p AD=6.46p PS=7u PD=7.2u
* device instance $2033 m0 *1 450.4,408.7 NMOS
XM$2033 VSS \$I4255 \$I4254 VSS NMOS L=1u W=3.4u AS=6.46p AD=6.12p PS=7.2u PD=7u
* device instance $2034 m0 *1 455,408.7 NMOS
XM$2034 \$I4254 WL13 BLB18 VSS NMOS L=1u W=3.4u AS=6.12p AD=9.52p PS=7u PD=12.4u
* device instance $2035 m0 *1 445.6,151.5 PMOS
XM$2035 \$I4257 \$I4256 VDD VDD PMOS L=1u W=3.4u AS=10.88p AD=6.46p PS=13.2u
+ PD=7.2u
* device instance $2036 m0 *1 450.4,151.5 PMOS
XM$2036 VDD \$I4257 \$I4256 VDD PMOS L=1u W=3.4u AS=6.46p AD=10.88p PS=7.2u
+ PD=13.2u
* device instance $2037 m0 *1 441,171.9 NMOS
XM$2037 BL18 WL5 \$I4257 VSS NMOS L=1u W=3.4u AS=9.52p AD=6.12p PS=12.4u PD=7u
* device instance $2038 m0 *1 445.6,171.9 NMOS
XM$2038 \$I4257 \$I4256 VSS VSS NMOS L=1u W=3.4u AS=6.12p AD=6.46p PS=7u PD=7.2u
* device instance $2039 m0 *1 450.4,171.9 NMOS
XM$2039 VSS \$I4257 \$I4256 VSS NMOS L=1u W=3.4u AS=6.46p AD=6.12p PS=7.2u PD=7u
* device instance $2040 m0 *1 455,171.9 NMOS
XM$2040 \$I4256 WL5 BLB18 VSS NMOS L=1u W=3.4u AS=6.12p AD=9.52p PS=7u PD=12.4u
* device instance $2041 r0 *1 445.6,262.9 PMOS
XM$2041 \$I4259 \$I4258 VDD VDD PMOS L=1u W=3.4u AS=10.88p AD=6.46p PS=13.2u
+ PD=7.2u
* device instance $2042 r0 *1 450.4,262.9 PMOS
XM$2042 VDD \$I4259 \$I4258 VDD PMOS L=1u W=3.4u AS=6.46p AD=10.88p PS=7.2u
+ PD=13.2u
* device instance $2043 r0 *1 441,242.5 NMOS
XM$2043 BL18 WL8 \$I4259 VSS NMOS L=1u W=3.4u AS=9.52p AD=6.12p PS=12.4u PD=7u
* device instance $2044 r0 *1 445.6,242.5 NMOS
XM$2044 \$I4259 \$I4258 VSS VSS NMOS L=1u W=3.4u AS=6.12p AD=6.46p PS=7u PD=7.2u
* device instance $2045 r0 *1 450.4,242.5 NMOS
XM$2045 VSS \$I4259 \$I4258 VSS NMOS L=1u W=3.4u AS=6.46p AD=6.12p PS=7.2u PD=7u
* device instance $2046 r0 *1 455,242.5 NMOS
XM$2046 \$I4258 WL8 BLB18 VSS NMOS L=1u W=3.4u AS=6.12p AD=9.52p PS=7u PD=12.4u
* device instance $2047 r0 *1 445.6,381.3 PMOS
XM$2047 \$I4261 \$I4260 VDD VDD PMOS L=1u W=3.4u AS=10.88p AD=6.46p PS=13.2u
+ PD=7.2u
* device instance $2048 r0 *1 450.4,381.3 PMOS
XM$2048 VDD \$I4261 \$I4260 VDD PMOS L=1u W=3.4u AS=6.46p AD=10.88p PS=7.2u
+ PD=13.2u
* device instance $2049 r0 *1 441,360.9 NMOS
XM$2049 BL18 WL12 \$I4261 VSS NMOS L=1u W=3.4u AS=9.52p AD=6.12p PS=12.4u PD=7u
* device instance $2050 r0 *1 445.6,360.9 NMOS
XM$2050 \$I4261 \$I4260 VSS VSS NMOS L=1u W=3.4u AS=6.12p AD=6.46p PS=7u PD=7.2u
* device instance $2051 r0 *1 450.4,360.9 NMOS
XM$2051 VSS \$I4261 \$I4260 VSS NMOS L=1u W=3.4u AS=6.46p AD=6.12p PS=7.2u PD=7u
* device instance $2052 r0 *1 455,360.9 NMOS
XM$2052 \$I4260 WL12 BLB18 VSS NMOS L=1u W=3.4u AS=6.12p AD=9.52p PS=7u PD=12.4u
* device instance $2053 r0 *1 445.6,440.5 PMOS
XM$2053 \$I4263 \$I4262 VDD VDD PMOS L=1u W=3.4u AS=10.88p AD=6.46p PS=13.2u
+ PD=7.2u
* device instance $2054 r0 *1 450.4,440.5 PMOS
XM$2054 VDD \$I4263 \$I4262 VDD PMOS L=1u W=3.4u AS=6.46p AD=10.88p PS=7.2u
+ PD=13.2u
* device instance $2055 r0 *1 441,420.1 NMOS
XM$2055 BL18 WL14 \$I4263 VSS NMOS L=1u W=3.4u AS=9.52p AD=6.12p PS=12.4u PD=7u
* device instance $2056 r0 *1 445.6,420.1 NMOS
XM$2056 \$I4263 \$I4262 VSS VSS NMOS L=1u W=3.4u AS=6.12p AD=6.46p PS=7u PD=7.2u
* device instance $2057 r0 *1 450.4,420.1 NMOS
XM$2057 VSS \$I4263 \$I4262 VSS NMOS L=1u W=3.4u AS=6.46p AD=6.12p PS=7.2u PD=7u
* device instance $2058 r0 *1 455,420.1 NMOS
XM$2058 \$I4262 WL14 BLB18 VSS NMOS L=1u W=3.4u AS=6.12p AD=9.52p PS=7u PD=12.4u
* device instance $2059 r0 *1 445.6,322.1 PMOS
XM$2059 \$I4265 \$I4264 VDD VDD PMOS L=1u W=3.4u AS=10.88p AD=6.46p PS=13.2u
+ PD=7.2u
* device instance $2060 r0 *1 450.4,322.1 PMOS
XM$2060 VDD \$I4265 \$I4264 VDD PMOS L=1u W=3.4u AS=6.46p AD=10.88p PS=7.2u
+ PD=13.2u
* device instance $2061 r0 *1 441,301.7 NMOS
XM$2061 BL18 WL10 \$I4265 VSS NMOS L=1u W=3.4u AS=9.52p AD=6.12p PS=12.4u PD=7u
* device instance $2062 r0 *1 445.6,301.7 NMOS
XM$2062 \$I4265 \$I4264 VSS VSS NMOS L=1u W=3.4u AS=6.12p AD=6.46p PS=7u PD=7.2u
* device instance $2063 r0 *1 450.4,301.7 NMOS
XM$2063 VSS \$I4265 \$I4264 VSS NMOS L=1u W=3.4u AS=6.46p AD=6.12p PS=7.2u PD=7u
* device instance $2064 r0 *1 455,301.7 NMOS
XM$2064 \$I4264 WL10 BLB18 VSS NMOS L=1u W=3.4u AS=6.12p AD=9.52p PS=7u PD=12.4u
* device instance $2065 r0 *1 445.6,203.7 PMOS
XM$2065 \$I4267 \$I4266 VDD VDD PMOS L=1u W=3.4u AS=10.88p AD=6.46p PS=13.2u
+ PD=7.2u
* device instance $2066 r0 *1 450.4,203.7 PMOS
XM$2066 VDD \$I4267 \$I4266 VDD PMOS L=1u W=3.4u AS=6.46p AD=10.88p PS=7.2u
+ PD=13.2u
* device instance $2067 r0 *1 441,183.3 NMOS
XM$2067 BL18 WL6 \$I4267 VSS NMOS L=1u W=3.4u AS=9.52p AD=6.12p PS=12.4u PD=7u
* device instance $2068 r0 *1 445.6,183.3 NMOS
XM$2068 \$I4267 \$I4266 VSS VSS NMOS L=1u W=3.4u AS=6.12p AD=6.46p PS=7u PD=7.2u
* device instance $2069 r0 *1 450.4,183.3 NMOS
XM$2069 VSS \$I4267 \$I4266 VSS NMOS L=1u W=3.4u AS=6.46p AD=6.12p PS=7.2u PD=7u
* device instance $2070 r0 *1 455,183.3 NMOS
XM$2070 \$I4266 WL6 BLB18 VSS NMOS L=1u W=3.4u AS=6.12p AD=9.52p PS=7u PD=12.4u
* device instance $2071 r0 *1 445.6,144.5 PMOS
XM$2071 \$I4269 \$I4268 VDD VDD PMOS L=1u W=3.4u AS=10.88p AD=6.46p PS=13.2u
+ PD=7.2u
* device instance $2072 r0 *1 450.4,144.5 PMOS
XM$2072 VDD \$I4269 \$I4268 VDD PMOS L=1u W=3.4u AS=6.46p AD=10.88p PS=7.2u
+ PD=13.2u
* device instance $2073 r0 *1 441,124.1 NMOS
XM$2073 BL18 WL4 \$I4269 VSS NMOS L=1u W=3.4u AS=9.52p AD=6.12p PS=12.4u PD=7u
* device instance $2074 r0 *1 445.6,124.1 NMOS
XM$2074 \$I4269 \$I4268 VSS VSS NMOS L=1u W=3.4u AS=6.12p AD=6.46p PS=7u PD=7.2u
* device instance $2075 r0 *1 450.4,124.1 NMOS
XM$2075 VSS \$I4269 \$I4268 VSS NMOS L=1u W=3.4u AS=6.46p AD=6.12p PS=7.2u PD=7u
* device instance $2076 r0 *1 455,124.1 NMOS
XM$2076 \$I4268 WL4 BLB18 VSS NMOS L=1u W=3.4u AS=6.12p AD=9.52p PS=7u PD=12.4u
* device instance $2077 r0 *1 445.6,85.3 PMOS
XM$2077 \$I4271 \$I4270 VDD VDD PMOS L=1u W=3.4u AS=10.88p AD=6.46p PS=13.2u
+ PD=7.2u
* device instance $2078 r0 *1 450.4,85.3 PMOS
XM$2078 VDD \$I4271 \$I4270 VDD PMOS L=1u W=3.4u AS=6.46p AD=10.88p PS=7.2u
+ PD=13.2u
* device instance $2079 r0 *1 441,64.9 NMOS
XM$2079 BL18 WL2 \$I4271 VSS NMOS L=1u W=3.4u AS=9.52p AD=6.12p PS=12.4u PD=7u
* device instance $2080 r0 *1 445.6,64.9 NMOS
XM$2080 \$I4271 \$I4270 VSS VSS NMOS L=1u W=3.4u AS=6.12p AD=6.46p PS=7u PD=7.2u
* device instance $2081 r0 *1 450.4,64.9 NMOS
XM$2081 VSS \$I4271 \$I4270 VSS NMOS L=1u W=3.4u AS=6.46p AD=6.12p PS=7.2u PD=7u
* device instance $2082 r0 *1 455,64.9 NMOS
XM$2082 \$I4270 WL2 BLB18 VSS NMOS L=1u W=3.4u AS=6.12p AD=9.52p PS=7u PD=12.4u
* device instance $2083 m0 *1 467.6,329.1 PMOS
XM$2083 \$I4273 \$I4272 VDD VDD PMOS L=1u W=3.4u AS=10.88p AD=6.46p PS=13.2u
+ PD=7.2u
* device instance $2084 m0 *1 472.4,329.1 PMOS
XM$2084 VDD \$I4273 \$I4272 VDD PMOS L=1u W=3.4u AS=6.46p AD=10.88p PS=7.2u
+ PD=13.2u
* device instance $2085 m0 *1 463,349.5 NMOS
XM$2085 BL19 WL11 \$I4273 VSS NMOS L=1u W=3.4u AS=9.52p AD=6.12p PS=12.4u PD=7u
* device instance $2086 m0 *1 467.6,349.5 NMOS
XM$2086 \$I4273 \$I4272 VSS VSS NMOS L=1u W=3.4u AS=6.12p AD=6.46p PS=7u PD=7.2u
* device instance $2087 m0 *1 472.4,349.5 NMOS
XM$2087 VSS \$I4273 \$I4272 VSS NMOS L=1u W=3.4u AS=6.46p AD=6.12p PS=7.2u PD=7u
* device instance $2088 m0 *1 477,349.5 NMOS
XM$2088 \$I4272 WL11 BLB19 VSS NMOS L=1u W=3.4u AS=6.12p AD=9.52p PS=7u PD=12.4u
* device instance $2089 m0 *1 467.6,269.9 PMOS
XM$2089 \$I4275 \$I4274 VDD VDD PMOS L=1u W=3.4u AS=10.88p AD=6.46p PS=13.2u
+ PD=7.2u
* device instance $2090 m0 *1 472.4,269.9 PMOS
XM$2090 VDD \$I4275 \$I4274 VDD PMOS L=1u W=3.4u AS=6.46p AD=10.88p PS=7.2u
+ PD=13.2u
* device instance $2091 m0 *1 463,290.3 NMOS
XM$2091 BL19 WL9 \$I4275 VSS NMOS L=1u W=3.4u AS=9.52p AD=6.12p PS=12.4u PD=7u
* device instance $2092 m0 *1 467.6,290.3 NMOS
XM$2092 \$I4275 \$I4274 VSS VSS NMOS L=1u W=3.4u AS=6.12p AD=6.46p PS=7u PD=7.2u
* device instance $2093 m0 *1 472.4,290.3 NMOS
XM$2093 VSS \$I4275 \$I4274 VSS NMOS L=1u W=3.4u AS=6.46p AD=6.12p PS=7.2u PD=7u
* device instance $2094 m0 *1 477,290.3 NMOS
XM$2094 \$I4274 WL9 BLB19 VSS NMOS L=1u W=3.4u AS=6.12p AD=9.52p PS=7u PD=12.4u
* device instance $2095 m0 *1 467.6,33.1 PMOS
XM$2095 \$I4277 \$I4276 VDD VDD PMOS L=1u W=3.4u AS=10.88p AD=6.46p PS=13.2u
+ PD=7.2u
* device instance $2096 m0 *1 472.4,33.1 PMOS
XM$2096 VDD \$I4277 \$I4276 VDD PMOS L=1u W=3.4u AS=6.46p AD=10.88p PS=7.2u
+ PD=13.2u
* device instance $2097 m0 *1 463,53.5 NMOS
XM$2097 BL19 WL1 \$I4277 VSS NMOS L=1u W=3.4u AS=9.52p AD=6.12p PS=12.4u PD=7u
* device instance $2098 m0 *1 467.6,53.5 NMOS
XM$2098 \$I4277 \$I4276 VSS VSS NMOS L=1u W=3.4u AS=6.12p AD=6.46p PS=7u PD=7.2u
* device instance $2099 m0 *1 472.4,53.5 NMOS
XM$2099 VSS \$I4277 \$I4276 VSS NMOS L=1u W=3.4u AS=6.46p AD=6.12p PS=7.2u PD=7u
* device instance $2100 m0 *1 477,53.5 NMOS
XM$2100 \$I4276 WL1 BLB19 VSS NMOS L=1u W=3.4u AS=6.12p AD=9.52p PS=7u PD=12.4u
* device instance $2101 m0 *1 467.6,92.3 PMOS
XM$2101 \$I4279 \$I4278 VDD VDD PMOS L=1u W=3.4u AS=10.88p AD=6.46p PS=13.2u
+ PD=7.2u
* device instance $2102 m0 *1 472.4,92.3 PMOS
XM$2102 VDD \$I4279 \$I4278 VDD PMOS L=1u W=3.4u AS=6.46p AD=10.88p PS=7.2u
+ PD=13.2u
* device instance $2103 m0 *1 463,112.7 NMOS
XM$2103 BL19 WL3 \$I4279 VSS NMOS L=1u W=3.4u AS=9.52p AD=6.12p PS=12.4u PD=7u
* device instance $2104 m0 *1 467.6,112.7 NMOS
XM$2104 \$I4279 \$I4278 VSS VSS NMOS L=1u W=3.4u AS=6.12p AD=6.46p PS=7u PD=7.2u
* device instance $2105 m0 *1 472.4,112.7 NMOS
XM$2105 VSS \$I4279 \$I4278 VSS NMOS L=1u W=3.4u AS=6.46p AD=6.12p PS=7.2u PD=7u
* device instance $2106 m0 *1 477,112.7 NMOS
XM$2106 \$I4278 WL3 BLB19 VSS NMOS L=1u W=3.4u AS=6.12p AD=9.52p PS=7u PD=12.4u
* device instance $2107 m0 *1 467.6,447.5 PMOS
XM$2107 \$I4281 \$I4280 VDD VDD PMOS L=1u W=3.4u AS=10.88p AD=6.46p PS=13.2u
+ PD=7.2u
* device instance $2108 m0 *1 472.4,447.5 PMOS
XM$2108 VDD \$I4281 \$I4280 VDD PMOS L=1u W=3.4u AS=6.46p AD=10.88p PS=7.2u
+ PD=13.2u
* device instance $2109 m0 *1 463,467.9 NMOS
XM$2109 BL19 WL15 \$I4281 VSS NMOS L=1u W=3.4u AS=9.52p AD=6.12p PS=12.4u PD=7u
* device instance $2110 m0 *1 467.6,467.9 NMOS
XM$2110 \$I4281 \$I4280 VSS VSS NMOS L=1u W=3.4u AS=6.12p AD=6.46p PS=7u PD=7.2u
* device instance $2111 m0 *1 472.4,467.9 NMOS
XM$2111 VSS \$I4281 \$I4280 VSS NMOS L=1u W=3.4u AS=6.46p AD=6.12p PS=7.2u PD=7u
* device instance $2112 m0 *1 477,467.9 NMOS
XM$2112 \$I4280 WL15 BLB19 VSS NMOS L=1u W=3.4u AS=6.12p AD=9.52p PS=7u PD=12.4u
* device instance $2113 m0 *1 467.6,210.7 PMOS
XM$2113 \$I4283 \$I4282 VDD VDD PMOS L=1u W=3.4u AS=10.88p AD=6.46p PS=13.2u
+ PD=7.2u
* device instance $2114 m0 *1 472.4,210.7 PMOS
XM$2114 VDD \$I4283 \$I4282 VDD PMOS L=1u W=3.4u AS=6.46p AD=10.88p PS=7.2u
+ PD=13.2u
* device instance $2115 m0 *1 463,231.1 NMOS
XM$2115 BL19 WL7 \$I4283 VSS NMOS L=1u W=3.4u AS=9.52p AD=6.12p PS=12.4u PD=7u
* device instance $2116 m0 *1 467.6,231.1 NMOS
XM$2116 \$I4283 \$I4282 VSS VSS NMOS L=1u W=3.4u AS=6.12p AD=6.46p PS=7u PD=7.2u
* device instance $2117 m0 *1 472.4,231.1 NMOS
XM$2117 VSS \$I4283 \$I4282 VSS NMOS L=1u W=3.4u AS=6.46p AD=6.12p PS=7.2u PD=7u
* device instance $2118 m0 *1 477,231.1 NMOS
XM$2118 \$I4282 WL7 BLB19 VSS NMOS L=1u W=3.4u AS=6.12p AD=9.52p PS=7u PD=12.4u
* device instance $2119 m0 *1 467.6,388.3 PMOS
XM$2119 \$I4285 \$I4284 VDD VDD PMOS L=1u W=3.4u AS=10.88p AD=6.46p PS=13.2u
+ PD=7.2u
* device instance $2120 m0 *1 472.4,388.3 PMOS
XM$2120 VDD \$I4285 \$I4284 VDD PMOS L=1u W=3.4u AS=6.46p AD=10.88p PS=7.2u
+ PD=13.2u
* device instance $2121 m0 *1 463,408.7 NMOS
XM$2121 BL19 WL13 \$I4285 VSS NMOS L=1u W=3.4u AS=9.52p AD=6.12p PS=12.4u PD=7u
* device instance $2122 m0 *1 467.6,408.7 NMOS
XM$2122 \$I4285 \$I4284 VSS VSS NMOS L=1u W=3.4u AS=6.12p AD=6.46p PS=7u PD=7.2u
* device instance $2123 m0 *1 472.4,408.7 NMOS
XM$2123 VSS \$I4285 \$I4284 VSS NMOS L=1u W=3.4u AS=6.46p AD=6.12p PS=7.2u PD=7u
* device instance $2124 m0 *1 477,408.7 NMOS
XM$2124 \$I4284 WL13 BLB19 VSS NMOS L=1u W=3.4u AS=6.12p AD=9.52p PS=7u PD=12.4u
* device instance $2125 m0 *1 467.6,151.5 PMOS
XM$2125 \$I4287 \$I4286 VDD VDD PMOS L=1u W=3.4u AS=10.88p AD=6.46p PS=13.2u
+ PD=7.2u
* device instance $2126 m0 *1 472.4,151.5 PMOS
XM$2126 VDD \$I4287 \$I4286 VDD PMOS L=1u W=3.4u AS=6.46p AD=10.88p PS=7.2u
+ PD=13.2u
* device instance $2127 m0 *1 463,171.9 NMOS
XM$2127 BL19 WL5 \$I4287 VSS NMOS L=1u W=3.4u AS=9.52p AD=6.12p PS=12.4u PD=7u
* device instance $2128 m0 *1 467.6,171.9 NMOS
XM$2128 \$I4287 \$I4286 VSS VSS NMOS L=1u W=3.4u AS=6.12p AD=6.46p PS=7u PD=7.2u
* device instance $2129 m0 *1 472.4,171.9 NMOS
XM$2129 VSS \$I4287 \$I4286 VSS NMOS L=1u W=3.4u AS=6.46p AD=6.12p PS=7.2u PD=7u
* device instance $2130 m0 *1 477,171.9 NMOS
XM$2130 \$I4286 WL5 BLB19 VSS NMOS L=1u W=3.4u AS=6.12p AD=9.52p PS=7u PD=12.4u
* device instance $2131 r0 *1 467.6,440.5 PMOS
XM$2131 \$I4289 \$I4288 VDD VDD PMOS L=1u W=3.4u AS=10.88p AD=6.46p PS=13.2u
+ PD=7.2u
* device instance $2132 r0 *1 472.4,440.5 PMOS
XM$2132 VDD \$I4289 \$I4288 VDD PMOS L=1u W=3.4u AS=6.46p AD=10.88p PS=7.2u
+ PD=13.2u
* device instance $2133 r0 *1 463,420.1 NMOS
XM$2133 BL19 WL14 \$I4289 VSS NMOS L=1u W=3.4u AS=9.52p AD=6.12p PS=12.4u PD=7u
* device instance $2134 r0 *1 467.6,420.1 NMOS
XM$2134 \$I4289 \$I4288 VSS VSS NMOS L=1u W=3.4u AS=6.12p AD=6.46p PS=7u PD=7.2u
* device instance $2135 r0 *1 472.4,420.1 NMOS
XM$2135 VSS \$I4289 \$I4288 VSS NMOS L=1u W=3.4u AS=6.46p AD=6.12p PS=7.2u PD=7u
* device instance $2136 r0 *1 477,420.1 NMOS
XM$2136 \$I4288 WL14 BLB19 VSS NMOS L=1u W=3.4u AS=6.12p AD=9.52p PS=7u PD=12.4u
* device instance $2137 r0 *1 467.6,381.3 PMOS
XM$2137 \$I4291 \$I4290 VDD VDD PMOS L=1u W=3.4u AS=10.88p AD=6.46p PS=13.2u
+ PD=7.2u
* device instance $2138 r0 *1 472.4,381.3 PMOS
XM$2138 VDD \$I4291 \$I4290 VDD PMOS L=1u W=3.4u AS=6.46p AD=10.88p PS=7.2u
+ PD=13.2u
* device instance $2139 r0 *1 463,360.9 NMOS
XM$2139 BL19 WL12 \$I4291 VSS NMOS L=1u W=3.4u AS=9.52p AD=6.12p PS=12.4u PD=7u
* device instance $2140 r0 *1 467.6,360.9 NMOS
XM$2140 \$I4291 \$I4290 VSS VSS NMOS L=1u W=3.4u AS=6.12p AD=6.46p PS=7u PD=7.2u
* device instance $2141 r0 *1 472.4,360.9 NMOS
XM$2141 VSS \$I4291 \$I4290 VSS NMOS L=1u W=3.4u AS=6.46p AD=6.12p PS=7.2u PD=7u
* device instance $2142 r0 *1 477,360.9 NMOS
XM$2142 \$I4290 WL12 BLB19 VSS NMOS L=1u W=3.4u AS=6.12p AD=9.52p PS=7u PD=12.4u
* device instance $2143 r0 *1 467.6,262.9 PMOS
XM$2143 \$I4293 \$I4292 VDD VDD PMOS L=1u W=3.4u AS=10.88p AD=6.46p PS=13.2u
+ PD=7.2u
* device instance $2144 r0 *1 472.4,262.9 PMOS
XM$2144 VDD \$I4293 \$I4292 VDD PMOS L=1u W=3.4u AS=6.46p AD=10.88p PS=7.2u
+ PD=13.2u
* device instance $2145 r0 *1 463,242.5 NMOS
XM$2145 BL19 WL8 \$I4293 VSS NMOS L=1u W=3.4u AS=9.52p AD=6.12p PS=12.4u PD=7u
* device instance $2146 r0 *1 467.6,242.5 NMOS
XM$2146 \$I4293 \$I4292 VSS VSS NMOS L=1u W=3.4u AS=6.12p AD=6.46p PS=7u PD=7.2u
* device instance $2147 r0 *1 472.4,242.5 NMOS
XM$2147 VSS \$I4293 \$I4292 VSS NMOS L=1u W=3.4u AS=6.46p AD=6.12p PS=7.2u PD=7u
* device instance $2148 r0 *1 477,242.5 NMOS
XM$2148 \$I4292 WL8 BLB19 VSS NMOS L=1u W=3.4u AS=6.12p AD=9.52p PS=7u PD=12.4u
* device instance $2149 r0 *1 467.6,322.1 PMOS
XM$2149 \$I4295 \$I4294 VDD VDD PMOS L=1u W=3.4u AS=10.88p AD=6.46p PS=13.2u
+ PD=7.2u
* device instance $2150 r0 *1 472.4,322.1 PMOS
XM$2150 VDD \$I4295 \$I4294 VDD PMOS L=1u W=3.4u AS=6.46p AD=10.88p PS=7.2u
+ PD=13.2u
* device instance $2151 r0 *1 463,301.7 NMOS
XM$2151 BL19 WL10 \$I4295 VSS NMOS L=1u W=3.4u AS=9.52p AD=6.12p PS=12.4u PD=7u
* device instance $2152 r0 *1 467.6,301.7 NMOS
XM$2152 \$I4295 \$I4294 VSS VSS NMOS L=1u W=3.4u AS=6.12p AD=6.46p PS=7u PD=7.2u
* device instance $2153 r0 *1 472.4,301.7 NMOS
XM$2153 VSS \$I4295 \$I4294 VSS NMOS L=1u W=3.4u AS=6.46p AD=6.12p PS=7.2u PD=7u
* device instance $2154 r0 *1 477,301.7 NMOS
XM$2154 \$I4294 WL10 BLB19 VSS NMOS L=1u W=3.4u AS=6.12p AD=9.52p PS=7u PD=12.4u
* device instance $2155 r0 *1 467.6,203.7 PMOS
XM$2155 \$I4297 \$I4296 VDD VDD PMOS L=1u W=3.4u AS=10.88p AD=6.46p PS=13.2u
+ PD=7.2u
* device instance $2156 r0 *1 472.4,203.7 PMOS
XM$2156 VDD \$I4297 \$I4296 VDD PMOS L=1u W=3.4u AS=6.46p AD=10.88p PS=7.2u
+ PD=13.2u
* device instance $2157 r0 *1 463,183.3 NMOS
XM$2157 BL19 WL6 \$I4297 VSS NMOS L=1u W=3.4u AS=9.52p AD=6.12p PS=12.4u PD=7u
* device instance $2158 r0 *1 467.6,183.3 NMOS
XM$2158 \$I4297 \$I4296 VSS VSS NMOS L=1u W=3.4u AS=6.12p AD=6.46p PS=7u PD=7.2u
* device instance $2159 r0 *1 472.4,183.3 NMOS
XM$2159 VSS \$I4297 \$I4296 VSS NMOS L=1u W=3.4u AS=6.46p AD=6.12p PS=7.2u PD=7u
* device instance $2160 r0 *1 477,183.3 NMOS
XM$2160 \$I4296 WL6 BLB19 VSS NMOS L=1u W=3.4u AS=6.12p AD=9.52p PS=7u PD=12.4u
* device instance $2161 r0 *1 467.6,144.5 PMOS
XM$2161 \$I4299 \$I4298 VDD VDD PMOS L=1u W=3.4u AS=10.88p AD=6.46p PS=13.2u
+ PD=7.2u
* device instance $2162 r0 *1 472.4,144.5 PMOS
XM$2162 VDD \$I4299 \$I4298 VDD PMOS L=1u W=3.4u AS=6.46p AD=10.88p PS=7.2u
+ PD=13.2u
* device instance $2163 r0 *1 463,124.1 NMOS
XM$2163 BL19 WL4 \$I4299 VSS NMOS L=1u W=3.4u AS=9.52p AD=6.12p PS=12.4u PD=7u
* device instance $2164 r0 *1 467.6,124.1 NMOS
XM$2164 \$I4299 \$I4298 VSS VSS NMOS L=1u W=3.4u AS=6.12p AD=6.46p PS=7u PD=7.2u
* device instance $2165 r0 *1 472.4,124.1 NMOS
XM$2165 VSS \$I4299 \$I4298 VSS NMOS L=1u W=3.4u AS=6.46p AD=6.12p PS=7.2u PD=7u
* device instance $2166 r0 *1 477,124.1 NMOS
XM$2166 \$I4298 WL4 BLB19 VSS NMOS L=1u W=3.4u AS=6.12p AD=9.52p PS=7u PD=12.4u
* device instance $2167 r0 *1 467.6,85.3 PMOS
XM$2167 \$I4301 \$I4300 VDD VDD PMOS L=1u W=3.4u AS=10.88p AD=6.46p PS=13.2u
+ PD=7.2u
* device instance $2168 r0 *1 472.4,85.3 PMOS
XM$2168 VDD \$I4301 \$I4300 VDD PMOS L=1u W=3.4u AS=6.46p AD=10.88p PS=7.2u
+ PD=13.2u
* device instance $2169 r0 *1 463,64.9 NMOS
XM$2169 BL19 WL2 \$I4301 VSS NMOS L=1u W=3.4u AS=9.52p AD=6.12p PS=12.4u PD=7u
* device instance $2170 r0 *1 467.6,64.9 NMOS
XM$2170 \$I4301 \$I4300 VSS VSS NMOS L=1u W=3.4u AS=6.12p AD=6.46p PS=7u PD=7.2u
* device instance $2171 r0 *1 472.4,64.9 NMOS
XM$2171 VSS \$I4301 \$I4300 VSS NMOS L=1u W=3.4u AS=6.46p AD=6.12p PS=7.2u PD=7u
* device instance $2172 r0 *1 477,64.9 NMOS
XM$2172 \$I4300 WL2 BLB19 VSS NMOS L=1u W=3.4u AS=6.12p AD=9.52p PS=7u PD=12.4u
* device instance $2173 m0 *1 270.4,92.3 PMOS
XM$2173 \$I4303 \$I4302 VDD VDD PMOS L=1u W=3.4u AS=10.88p AD=6.46p PS=13.2u
+ PD=7.2u
* device instance $2174 m0 *1 275.2,92.3 PMOS
XM$2174 VDD \$I4303 \$I4302 VDD PMOS L=1u W=3.4u AS=6.46p AD=10.88p PS=7.2u
+ PD=13.2u
* device instance $2175 m0 *1 265.8,112.7 NMOS
XM$2175 BL11 WL3 \$I4303 VSS NMOS L=1u W=3.4u AS=9.52p AD=6.12p PS=12.4u PD=7u
* device instance $2176 m0 *1 270.4,112.7 NMOS
XM$2176 \$I4303 \$I4302 VSS VSS NMOS L=1u W=3.4u AS=6.12p AD=6.46p PS=7u PD=7.2u
* device instance $2177 m0 *1 275.2,112.7 NMOS
XM$2177 VSS \$I4303 \$I4302 VSS NMOS L=1u W=3.4u AS=6.46p AD=6.12p PS=7.2u PD=7u
* device instance $2178 m0 *1 279.8,112.7 NMOS
XM$2178 \$I4302 WL3 BLB11 VSS NMOS L=1u W=3.4u AS=6.12p AD=9.52p PS=7u PD=12.4u
* device instance $2179 m0 *1 270.4,33.1 PMOS
XM$2179 \$I4305 \$I4304 VDD VDD PMOS L=1u W=3.4u AS=10.88p AD=6.46p PS=13.2u
+ PD=7.2u
* device instance $2180 m0 *1 275.2,33.1 PMOS
XM$2180 VDD \$I4305 \$I4304 VDD PMOS L=1u W=3.4u AS=6.46p AD=10.88p PS=7.2u
+ PD=13.2u
* device instance $2181 m0 *1 265.8,53.5 NMOS
XM$2181 BL11 WL1 \$I4305 VSS NMOS L=1u W=3.4u AS=9.52p AD=6.12p PS=12.4u PD=7u
* device instance $2182 m0 *1 270.4,53.5 NMOS
XM$2182 \$I4305 \$I4304 VSS VSS NMOS L=1u W=3.4u AS=6.12p AD=6.46p PS=7u PD=7.2u
* device instance $2183 m0 *1 275.2,53.5 NMOS
XM$2183 VSS \$I4305 \$I4304 VSS NMOS L=1u W=3.4u AS=6.46p AD=6.12p PS=7.2u PD=7u
* device instance $2184 m0 *1 279.8,53.5 NMOS
XM$2184 \$I4304 WL1 BLB11 VSS NMOS L=1u W=3.4u AS=6.12p AD=9.52p PS=7u PD=12.4u
* device instance $2185 m0 *1 270.4,447.5 PMOS
XM$2185 \$I4307 \$I4306 VDD VDD PMOS L=1u W=3.4u AS=10.88p AD=6.46p PS=13.2u
+ PD=7.2u
* device instance $2186 m0 *1 275.2,447.5 PMOS
XM$2186 VDD \$I4307 \$I4306 VDD PMOS L=1u W=3.4u AS=6.46p AD=10.88p PS=7.2u
+ PD=13.2u
* device instance $2187 m0 *1 265.8,467.9 NMOS
XM$2187 BL11 WL15 \$I4307 VSS NMOS L=1u W=3.4u AS=9.52p AD=6.12p PS=12.4u PD=7u
* device instance $2188 m0 *1 270.4,467.9 NMOS
XM$2188 \$I4307 \$I4306 VSS VSS NMOS L=1u W=3.4u AS=6.12p AD=6.46p PS=7u PD=7.2u
* device instance $2189 m0 *1 275.2,467.9 NMOS
XM$2189 VSS \$I4307 \$I4306 VSS NMOS L=1u W=3.4u AS=6.46p AD=6.12p PS=7.2u PD=7u
* device instance $2190 m0 *1 279.8,467.9 NMOS
XM$2190 \$I4306 WL15 BLB11 VSS NMOS L=1u W=3.4u AS=6.12p AD=9.52p PS=7u PD=12.4u
* device instance $2191 m0 *1 270.4,151.5 PMOS
XM$2191 \$I4309 \$I4308 VDD VDD PMOS L=1u W=3.4u AS=10.88p AD=6.46p PS=13.2u
+ PD=7.2u
* device instance $2192 m0 *1 275.2,151.5 PMOS
XM$2192 VDD \$I4309 \$I4308 VDD PMOS L=1u W=3.4u AS=6.46p AD=10.88p PS=7.2u
+ PD=13.2u
* device instance $2193 m0 *1 265.8,171.9 NMOS
XM$2193 BL11 WL5 \$I4309 VSS NMOS L=1u W=3.4u AS=9.52p AD=6.12p PS=12.4u PD=7u
* device instance $2194 m0 *1 270.4,171.9 NMOS
XM$2194 \$I4309 \$I4308 VSS VSS NMOS L=1u W=3.4u AS=6.12p AD=6.46p PS=7u PD=7.2u
* device instance $2195 m0 *1 275.2,171.9 NMOS
XM$2195 VSS \$I4309 \$I4308 VSS NMOS L=1u W=3.4u AS=6.46p AD=6.12p PS=7.2u PD=7u
* device instance $2196 m0 *1 279.8,171.9 NMOS
XM$2196 \$I4308 WL5 BLB11 VSS NMOS L=1u W=3.4u AS=6.12p AD=9.52p PS=7u PD=12.4u
* device instance $2197 m0 *1 270.4,329.1 PMOS
XM$2197 \$I4311 \$I4310 VDD VDD PMOS L=1u W=3.4u AS=10.88p AD=6.46p PS=13.2u
+ PD=7.2u
* device instance $2198 m0 *1 275.2,329.1 PMOS
XM$2198 VDD \$I4311 \$I4310 VDD PMOS L=1u W=3.4u AS=6.46p AD=10.88p PS=7.2u
+ PD=13.2u
* device instance $2199 m0 *1 265.8,349.5 NMOS
XM$2199 BL11 WL11 \$I4311 VSS NMOS L=1u W=3.4u AS=9.52p AD=6.12p PS=12.4u PD=7u
* device instance $2200 m0 *1 270.4,349.5 NMOS
XM$2200 \$I4311 \$I4310 VSS VSS NMOS L=1u W=3.4u AS=6.12p AD=6.46p PS=7u PD=7.2u
* device instance $2201 m0 *1 275.2,349.5 NMOS
XM$2201 VSS \$I4311 \$I4310 VSS NMOS L=1u W=3.4u AS=6.46p AD=6.12p PS=7.2u PD=7u
* device instance $2202 m0 *1 279.8,349.5 NMOS
XM$2202 \$I4310 WL11 BLB11 VSS NMOS L=1u W=3.4u AS=6.12p AD=9.52p PS=7u PD=12.4u
* device instance $2203 m0 *1 270.4,388.3 PMOS
XM$2203 \$I4313 \$I4312 VDD VDD PMOS L=1u W=3.4u AS=10.88p AD=6.46p PS=13.2u
+ PD=7.2u
* device instance $2204 m0 *1 275.2,388.3 PMOS
XM$2204 VDD \$I4313 \$I4312 VDD PMOS L=1u W=3.4u AS=6.46p AD=10.88p PS=7.2u
+ PD=13.2u
* device instance $2205 m0 *1 265.8,408.7 NMOS
XM$2205 BL11 WL13 \$I4313 VSS NMOS L=1u W=3.4u AS=9.52p AD=6.12p PS=12.4u PD=7u
* device instance $2206 m0 *1 270.4,408.7 NMOS
XM$2206 \$I4313 \$I4312 VSS VSS NMOS L=1u W=3.4u AS=6.12p AD=6.46p PS=7u PD=7.2u
* device instance $2207 m0 *1 275.2,408.7 NMOS
XM$2207 VSS \$I4313 \$I4312 VSS NMOS L=1u W=3.4u AS=6.46p AD=6.12p PS=7.2u PD=7u
* device instance $2208 m0 *1 279.8,408.7 NMOS
XM$2208 \$I4312 WL13 BLB11 VSS NMOS L=1u W=3.4u AS=6.12p AD=9.52p PS=7u PD=12.4u
* device instance $2209 m0 *1 270.4,269.9 PMOS
XM$2209 \$I4315 \$I4314 VDD VDD PMOS L=1u W=3.4u AS=10.88p AD=6.46p PS=13.2u
+ PD=7.2u
* device instance $2210 m0 *1 275.2,269.9 PMOS
XM$2210 VDD \$I4315 \$I4314 VDD PMOS L=1u W=3.4u AS=6.46p AD=10.88p PS=7.2u
+ PD=13.2u
* device instance $2211 m0 *1 265.8,290.3 NMOS
XM$2211 BL11 WL9 \$I4315 VSS NMOS L=1u W=3.4u AS=9.52p AD=6.12p PS=12.4u PD=7u
* device instance $2212 m0 *1 270.4,290.3 NMOS
XM$2212 \$I4315 \$I4314 VSS VSS NMOS L=1u W=3.4u AS=6.12p AD=6.46p PS=7u PD=7.2u
* device instance $2213 m0 *1 275.2,290.3 NMOS
XM$2213 VSS \$I4315 \$I4314 VSS NMOS L=1u W=3.4u AS=6.46p AD=6.12p PS=7.2u PD=7u
* device instance $2214 m0 *1 279.8,290.3 NMOS
XM$2214 \$I4314 WL9 BLB11 VSS NMOS L=1u W=3.4u AS=6.12p AD=9.52p PS=7u PD=12.4u
* device instance $2215 m0 *1 270.4,210.7 PMOS
XM$2215 \$I4317 \$I4316 VDD VDD PMOS L=1u W=3.4u AS=10.88p AD=6.46p PS=13.2u
+ PD=7.2u
* device instance $2216 m0 *1 275.2,210.7 PMOS
XM$2216 VDD \$I4317 \$I4316 VDD PMOS L=1u W=3.4u AS=6.46p AD=10.88p PS=7.2u
+ PD=13.2u
* device instance $2217 m0 *1 265.8,231.1 NMOS
XM$2217 BL11 WL7 \$I4317 VSS NMOS L=1u W=3.4u AS=9.52p AD=6.12p PS=12.4u PD=7u
* device instance $2218 m0 *1 270.4,231.1 NMOS
XM$2218 \$I4317 \$I4316 VSS VSS NMOS L=1u W=3.4u AS=6.12p AD=6.46p PS=7u PD=7.2u
* device instance $2219 m0 *1 275.2,231.1 NMOS
XM$2219 VSS \$I4317 \$I4316 VSS NMOS L=1u W=3.4u AS=6.46p AD=6.12p PS=7.2u PD=7u
* device instance $2220 m0 *1 279.8,231.1 NMOS
XM$2220 \$I4316 WL7 BLB11 VSS NMOS L=1u W=3.4u AS=6.12p AD=9.52p PS=7u PD=12.4u
* device instance $2221 r0 *1 270.4,440.5 PMOS
XM$2221 \$I4319 \$I4318 VDD VDD PMOS L=1u W=3.4u AS=10.88p AD=6.46p PS=13.2u
+ PD=7.2u
* device instance $2222 r0 *1 275.2,440.5 PMOS
XM$2222 VDD \$I4319 \$I4318 VDD PMOS L=1u W=3.4u AS=6.46p AD=10.88p PS=7.2u
+ PD=13.2u
* device instance $2223 r0 *1 265.8,420.1 NMOS
XM$2223 BL11 WL14 \$I4319 VSS NMOS L=1u W=3.4u AS=9.52p AD=6.12p PS=12.4u PD=7u
* device instance $2224 r0 *1 270.4,420.1 NMOS
XM$2224 \$I4319 \$I4318 VSS VSS NMOS L=1u W=3.4u AS=6.12p AD=6.46p PS=7u PD=7.2u
* device instance $2225 r0 *1 275.2,420.1 NMOS
XM$2225 VSS \$I4319 \$I4318 VSS NMOS L=1u W=3.4u AS=6.46p AD=6.12p PS=7.2u PD=7u
* device instance $2226 r0 *1 279.8,420.1 NMOS
XM$2226 \$I4318 WL14 BLB11 VSS NMOS L=1u W=3.4u AS=6.12p AD=9.52p PS=7u PD=12.4u
* device instance $2227 r0 *1 270.4,381.3 PMOS
XM$2227 \$I4321 \$I4320 VDD VDD PMOS L=1u W=3.4u AS=10.88p AD=6.46p PS=13.2u
+ PD=7.2u
* device instance $2228 r0 *1 275.2,381.3 PMOS
XM$2228 VDD \$I4321 \$I4320 VDD PMOS L=1u W=3.4u AS=6.46p AD=10.88p PS=7.2u
+ PD=13.2u
* device instance $2229 r0 *1 265.8,360.9 NMOS
XM$2229 BL11 WL12 \$I4321 VSS NMOS L=1u W=3.4u AS=9.52p AD=6.12p PS=12.4u PD=7u
* device instance $2230 r0 *1 270.4,360.9 NMOS
XM$2230 \$I4321 \$I4320 VSS VSS NMOS L=1u W=3.4u AS=6.12p AD=6.46p PS=7u PD=7.2u
* device instance $2231 r0 *1 275.2,360.9 NMOS
XM$2231 VSS \$I4321 \$I4320 VSS NMOS L=1u W=3.4u AS=6.46p AD=6.12p PS=7.2u PD=7u
* device instance $2232 r0 *1 279.8,360.9 NMOS
XM$2232 \$I4320 WL12 BLB11 VSS NMOS L=1u W=3.4u AS=6.12p AD=9.52p PS=7u PD=12.4u
* device instance $2233 r0 *1 270.4,85.3 PMOS
XM$2233 \$I4323 \$I4322 VDD VDD PMOS L=1u W=3.4u AS=10.88p AD=6.46p PS=13.2u
+ PD=7.2u
* device instance $2234 r0 *1 275.2,85.3 PMOS
XM$2234 VDD \$I4323 \$I4322 VDD PMOS L=1u W=3.4u AS=6.46p AD=10.88p PS=7.2u
+ PD=13.2u
* device instance $2235 r0 *1 265.8,64.9 NMOS
XM$2235 BL11 WL2 \$I4323 VSS NMOS L=1u W=3.4u AS=9.52p AD=6.12p PS=12.4u PD=7u
* device instance $2236 r0 *1 270.4,64.9 NMOS
XM$2236 \$I4323 \$I4322 VSS VSS NMOS L=1u W=3.4u AS=6.12p AD=6.46p PS=7u PD=7.2u
* device instance $2237 r0 *1 275.2,64.9 NMOS
XM$2237 VSS \$I4323 \$I4322 VSS NMOS L=1u W=3.4u AS=6.46p AD=6.12p PS=7.2u PD=7u
* device instance $2238 r0 *1 279.8,64.9 NMOS
XM$2238 \$I4322 WL2 BLB11 VSS NMOS L=1u W=3.4u AS=6.12p AD=9.52p PS=7u PD=12.4u
* device instance $2239 r0 *1 270.4,322.1 PMOS
XM$2239 \$I4325 \$I4324 VDD VDD PMOS L=1u W=3.4u AS=10.88p AD=6.46p PS=13.2u
+ PD=7.2u
* device instance $2240 r0 *1 275.2,322.1 PMOS
XM$2240 VDD \$I4325 \$I4324 VDD PMOS L=1u W=3.4u AS=6.46p AD=10.88p PS=7.2u
+ PD=13.2u
* device instance $2241 r0 *1 265.8,301.7 NMOS
XM$2241 BL11 WL10 \$I4325 VSS NMOS L=1u W=3.4u AS=9.52p AD=6.12p PS=12.4u PD=7u
* device instance $2242 r0 *1 270.4,301.7 NMOS
XM$2242 \$I4325 \$I4324 VSS VSS NMOS L=1u W=3.4u AS=6.12p AD=6.46p PS=7u PD=7.2u
* device instance $2243 r0 *1 275.2,301.7 NMOS
XM$2243 VSS \$I4325 \$I4324 VSS NMOS L=1u W=3.4u AS=6.46p AD=6.12p PS=7.2u PD=7u
* device instance $2244 r0 *1 279.8,301.7 NMOS
XM$2244 \$I4324 WL10 BLB11 VSS NMOS L=1u W=3.4u AS=6.12p AD=9.52p PS=7u PD=12.4u
* device instance $2245 r0 *1 270.4,262.9 PMOS
XM$2245 \$I4327 \$I4326 VDD VDD PMOS L=1u W=3.4u AS=10.88p AD=6.46p PS=13.2u
+ PD=7.2u
* device instance $2246 r0 *1 275.2,262.9 PMOS
XM$2246 VDD \$I4327 \$I4326 VDD PMOS L=1u W=3.4u AS=6.46p AD=10.88p PS=7.2u
+ PD=13.2u
* device instance $2247 r0 *1 265.8,242.5 NMOS
XM$2247 BL11 WL8 \$I4327 VSS NMOS L=1u W=3.4u AS=9.52p AD=6.12p PS=12.4u PD=7u
* device instance $2248 r0 *1 270.4,242.5 NMOS
XM$2248 \$I4327 \$I4326 VSS VSS NMOS L=1u W=3.4u AS=6.12p AD=6.46p PS=7u PD=7.2u
* device instance $2249 r0 *1 275.2,242.5 NMOS
XM$2249 VSS \$I4327 \$I4326 VSS NMOS L=1u W=3.4u AS=6.46p AD=6.12p PS=7.2u PD=7u
* device instance $2250 r0 *1 279.8,242.5 NMOS
XM$2250 \$I4326 WL8 BLB11 VSS NMOS L=1u W=3.4u AS=6.12p AD=9.52p PS=7u PD=12.4u
* device instance $2251 r0 *1 270.4,144.5 PMOS
XM$2251 \$I4329 \$I4328 VDD VDD PMOS L=1u W=3.4u AS=10.88p AD=6.46p PS=13.2u
+ PD=7.2u
* device instance $2252 r0 *1 275.2,144.5 PMOS
XM$2252 VDD \$I4329 \$I4328 VDD PMOS L=1u W=3.4u AS=6.46p AD=10.88p PS=7.2u
+ PD=13.2u
* device instance $2253 r0 *1 265.8,124.1 NMOS
XM$2253 BL11 WL4 \$I4329 VSS NMOS L=1u W=3.4u AS=9.52p AD=6.12p PS=12.4u PD=7u
* device instance $2254 r0 *1 270.4,124.1 NMOS
XM$2254 \$I4329 \$I4328 VSS VSS NMOS L=1u W=3.4u AS=6.12p AD=6.46p PS=7u PD=7.2u
* device instance $2255 r0 *1 275.2,124.1 NMOS
XM$2255 VSS \$I4329 \$I4328 VSS NMOS L=1u W=3.4u AS=6.46p AD=6.12p PS=7.2u PD=7u
* device instance $2256 r0 *1 279.8,124.1 NMOS
XM$2256 \$I4328 WL4 BLB11 VSS NMOS L=1u W=3.4u AS=6.12p AD=9.52p PS=7u PD=12.4u
* device instance $2257 r0 *1 270.4,203.7 PMOS
XM$2257 \$I4331 \$I4330 VDD VDD PMOS L=1u W=3.4u AS=10.88p AD=6.46p PS=13.2u
+ PD=7.2u
* device instance $2258 r0 *1 275.2,203.7 PMOS
XM$2258 VDD \$I4331 \$I4330 VDD PMOS L=1u W=3.4u AS=6.46p AD=10.88p PS=7.2u
+ PD=13.2u
* device instance $2259 r0 *1 265.8,183.3 NMOS
XM$2259 BL11 WL6 \$I4331 VSS NMOS L=1u W=3.4u AS=9.52p AD=6.12p PS=12.4u PD=7u
* device instance $2260 r0 *1 270.4,183.3 NMOS
XM$2260 \$I4331 \$I4330 VSS VSS NMOS L=1u W=3.4u AS=6.12p AD=6.46p PS=7u PD=7.2u
* device instance $2261 r0 *1 275.2,183.3 NMOS
XM$2261 VSS \$I4331 \$I4330 VSS NMOS L=1u W=3.4u AS=6.46p AD=6.12p PS=7.2u PD=7u
* device instance $2262 r0 *1 279.8,183.3 NMOS
XM$2262 \$I4330 WL6 BLB11 VSS NMOS L=1u W=3.4u AS=6.12p AD=9.52p PS=7u PD=12.4u
* device instance $2263 m0 *1 248.4,92.3 PMOS
XM$2263 \$I4333 \$I4332 VDD VDD PMOS L=1u W=3.4u AS=10.88p AD=6.46p PS=13.2u
+ PD=7.2u
* device instance $2264 m0 *1 253.2,92.3 PMOS
XM$2264 VDD \$I4333 \$I4332 VDD PMOS L=1u W=3.4u AS=6.46p AD=10.88p PS=7.2u
+ PD=13.2u
* device instance $2265 m0 *1 243.8,112.7 NMOS
XM$2265 BL10 WL3 \$I4333 VSS NMOS L=1u W=3.4u AS=9.52p AD=6.12p PS=12.4u PD=7u
* device instance $2266 m0 *1 248.4,112.7 NMOS
XM$2266 \$I4333 \$I4332 VSS VSS NMOS L=1u W=3.4u AS=6.12p AD=6.46p PS=7u PD=7.2u
* device instance $2267 m0 *1 253.2,112.7 NMOS
XM$2267 VSS \$I4333 \$I4332 VSS NMOS L=1u W=3.4u AS=6.46p AD=6.12p PS=7.2u PD=7u
* device instance $2268 m0 *1 257.8,112.7 NMOS
XM$2268 \$I4332 WL3 BLB10 VSS NMOS L=1u W=3.4u AS=6.12p AD=9.52p PS=7u PD=12.4u
* device instance $2269 m0 *1 248.4,33.1 PMOS
XM$2269 \$I4335 \$I4334 VDD VDD PMOS L=1u W=3.4u AS=10.88p AD=6.46p PS=13.2u
+ PD=7.2u
* device instance $2270 m0 *1 253.2,33.1 PMOS
XM$2270 VDD \$I4335 \$I4334 VDD PMOS L=1u W=3.4u AS=6.46p AD=10.88p PS=7.2u
+ PD=13.2u
* device instance $2271 m0 *1 243.8,53.5 NMOS
XM$2271 BL10 WL1 \$I4335 VSS NMOS L=1u W=3.4u AS=9.52p AD=6.12p PS=12.4u PD=7u
* device instance $2272 m0 *1 248.4,53.5 NMOS
XM$2272 \$I4335 \$I4334 VSS VSS NMOS L=1u W=3.4u AS=6.12p AD=6.46p PS=7u PD=7.2u
* device instance $2273 m0 *1 253.2,53.5 NMOS
XM$2273 VSS \$I4335 \$I4334 VSS NMOS L=1u W=3.4u AS=6.46p AD=6.12p PS=7.2u PD=7u
* device instance $2274 m0 *1 257.8,53.5 NMOS
XM$2274 \$I4334 WL1 BLB10 VSS NMOS L=1u W=3.4u AS=6.12p AD=9.52p PS=7u PD=12.4u
* device instance $2275 m0 *1 248.4,447.5 PMOS
XM$2275 \$I4337 \$I4336 VDD VDD PMOS L=1u W=3.4u AS=10.88p AD=6.46p PS=13.2u
+ PD=7.2u
* device instance $2276 m0 *1 253.2,447.5 PMOS
XM$2276 VDD \$I4337 \$I4336 VDD PMOS L=1u W=3.4u AS=6.46p AD=10.88p PS=7.2u
+ PD=13.2u
* device instance $2277 m0 *1 243.8,467.9 NMOS
XM$2277 BL10 WL15 \$I4337 VSS NMOS L=1u W=3.4u AS=9.52p AD=6.12p PS=12.4u PD=7u
* device instance $2278 m0 *1 248.4,467.9 NMOS
XM$2278 \$I4337 \$I4336 VSS VSS NMOS L=1u W=3.4u AS=6.12p AD=6.46p PS=7u PD=7.2u
* device instance $2279 m0 *1 253.2,467.9 NMOS
XM$2279 VSS \$I4337 \$I4336 VSS NMOS L=1u W=3.4u AS=6.46p AD=6.12p PS=7.2u PD=7u
* device instance $2280 m0 *1 257.8,467.9 NMOS
XM$2280 \$I4336 WL15 BLB10 VSS NMOS L=1u W=3.4u AS=6.12p AD=9.52p PS=7u PD=12.4u
* device instance $2281 m0 *1 248.4,151.5 PMOS
XM$2281 \$I4339 \$I4338 VDD VDD PMOS L=1u W=3.4u AS=10.88p AD=6.46p PS=13.2u
+ PD=7.2u
* device instance $2282 m0 *1 253.2,151.5 PMOS
XM$2282 VDD \$I4339 \$I4338 VDD PMOS L=1u W=3.4u AS=6.46p AD=10.88p PS=7.2u
+ PD=13.2u
* device instance $2283 m0 *1 243.8,171.9 NMOS
XM$2283 BL10 WL5 \$I4339 VSS NMOS L=1u W=3.4u AS=9.52p AD=6.12p PS=12.4u PD=7u
* device instance $2284 m0 *1 248.4,171.9 NMOS
XM$2284 \$I4339 \$I4338 VSS VSS NMOS L=1u W=3.4u AS=6.12p AD=6.46p PS=7u PD=7.2u
* device instance $2285 m0 *1 253.2,171.9 NMOS
XM$2285 VSS \$I4339 \$I4338 VSS NMOS L=1u W=3.4u AS=6.46p AD=6.12p PS=7.2u PD=7u
* device instance $2286 m0 *1 257.8,171.9 NMOS
XM$2286 \$I4338 WL5 BLB10 VSS NMOS L=1u W=3.4u AS=6.12p AD=9.52p PS=7u PD=12.4u
* device instance $2287 m0 *1 248.4,329.1 PMOS
XM$2287 \$I4341 \$I4340 VDD VDD PMOS L=1u W=3.4u AS=10.88p AD=6.46p PS=13.2u
+ PD=7.2u
* device instance $2288 m0 *1 253.2,329.1 PMOS
XM$2288 VDD \$I4341 \$I4340 VDD PMOS L=1u W=3.4u AS=6.46p AD=10.88p PS=7.2u
+ PD=13.2u
* device instance $2289 m0 *1 243.8,349.5 NMOS
XM$2289 BL10 WL11 \$I4341 VSS NMOS L=1u W=3.4u AS=9.52p AD=6.12p PS=12.4u PD=7u
* device instance $2290 m0 *1 248.4,349.5 NMOS
XM$2290 \$I4341 \$I4340 VSS VSS NMOS L=1u W=3.4u AS=6.12p AD=6.46p PS=7u PD=7.2u
* device instance $2291 m0 *1 253.2,349.5 NMOS
XM$2291 VSS \$I4341 \$I4340 VSS NMOS L=1u W=3.4u AS=6.46p AD=6.12p PS=7.2u PD=7u
* device instance $2292 m0 *1 257.8,349.5 NMOS
XM$2292 \$I4340 WL11 BLB10 VSS NMOS L=1u W=3.4u AS=6.12p AD=9.52p PS=7u PD=12.4u
* device instance $2293 m0 *1 248.4,388.3 PMOS
XM$2293 \$I4343 \$I4342 VDD VDD PMOS L=1u W=3.4u AS=10.88p AD=6.46p PS=13.2u
+ PD=7.2u
* device instance $2294 m0 *1 253.2,388.3 PMOS
XM$2294 VDD \$I4343 \$I4342 VDD PMOS L=1u W=3.4u AS=6.46p AD=10.88p PS=7.2u
+ PD=13.2u
* device instance $2295 m0 *1 243.8,408.7 NMOS
XM$2295 BL10 WL13 \$I4343 VSS NMOS L=1u W=3.4u AS=9.52p AD=6.12p PS=12.4u PD=7u
* device instance $2296 m0 *1 248.4,408.7 NMOS
XM$2296 \$I4343 \$I4342 VSS VSS NMOS L=1u W=3.4u AS=6.12p AD=6.46p PS=7u PD=7.2u
* device instance $2297 m0 *1 253.2,408.7 NMOS
XM$2297 VSS \$I4343 \$I4342 VSS NMOS L=1u W=3.4u AS=6.46p AD=6.12p PS=7.2u PD=7u
* device instance $2298 m0 *1 257.8,408.7 NMOS
XM$2298 \$I4342 WL13 BLB10 VSS NMOS L=1u W=3.4u AS=6.12p AD=9.52p PS=7u PD=12.4u
* device instance $2299 m0 *1 248.4,269.9 PMOS
XM$2299 \$I4345 \$I4344 VDD VDD PMOS L=1u W=3.4u AS=10.88p AD=6.46p PS=13.2u
+ PD=7.2u
* device instance $2300 m0 *1 253.2,269.9 PMOS
XM$2300 VDD \$I4345 \$I4344 VDD PMOS L=1u W=3.4u AS=6.46p AD=10.88p PS=7.2u
+ PD=13.2u
* device instance $2301 m0 *1 243.8,290.3 NMOS
XM$2301 BL10 WL9 \$I4345 VSS NMOS L=1u W=3.4u AS=9.52p AD=6.12p PS=12.4u PD=7u
* device instance $2302 m0 *1 248.4,290.3 NMOS
XM$2302 \$I4345 \$I4344 VSS VSS NMOS L=1u W=3.4u AS=6.12p AD=6.46p PS=7u PD=7.2u
* device instance $2303 m0 *1 253.2,290.3 NMOS
XM$2303 VSS \$I4345 \$I4344 VSS NMOS L=1u W=3.4u AS=6.46p AD=6.12p PS=7.2u PD=7u
* device instance $2304 m0 *1 257.8,290.3 NMOS
XM$2304 \$I4344 WL9 BLB10 VSS NMOS L=1u W=3.4u AS=6.12p AD=9.52p PS=7u PD=12.4u
* device instance $2305 m0 *1 248.4,210.7 PMOS
XM$2305 \$I4347 \$I4346 VDD VDD PMOS L=1u W=3.4u AS=10.88p AD=6.46p PS=13.2u
+ PD=7.2u
* device instance $2306 m0 *1 253.2,210.7 PMOS
XM$2306 VDD \$I4347 \$I4346 VDD PMOS L=1u W=3.4u AS=6.46p AD=10.88p PS=7.2u
+ PD=13.2u
* device instance $2307 m0 *1 243.8,231.1 NMOS
XM$2307 BL10 WL7 \$I4347 VSS NMOS L=1u W=3.4u AS=9.52p AD=6.12p PS=12.4u PD=7u
* device instance $2308 m0 *1 248.4,231.1 NMOS
XM$2308 \$I4347 \$I4346 VSS VSS NMOS L=1u W=3.4u AS=6.12p AD=6.46p PS=7u PD=7.2u
* device instance $2309 m0 *1 253.2,231.1 NMOS
XM$2309 VSS \$I4347 \$I4346 VSS NMOS L=1u W=3.4u AS=6.46p AD=6.12p PS=7.2u PD=7u
* device instance $2310 m0 *1 257.8,231.1 NMOS
XM$2310 \$I4346 WL7 BLB10 VSS NMOS L=1u W=3.4u AS=6.12p AD=9.52p PS=7u PD=12.4u
* device instance $2311 r0 *1 248.4,440.5 PMOS
XM$2311 \$I4349 \$I4348 VDD VDD PMOS L=1u W=3.4u AS=10.88p AD=6.46p PS=13.2u
+ PD=7.2u
* device instance $2312 r0 *1 253.2,440.5 PMOS
XM$2312 VDD \$I4349 \$I4348 VDD PMOS L=1u W=3.4u AS=6.46p AD=10.88p PS=7.2u
+ PD=13.2u
* device instance $2313 r0 *1 243.8,420.1 NMOS
XM$2313 BL10 WL14 \$I4349 VSS NMOS L=1u W=3.4u AS=9.52p AD=6.12p PS=12.4u PD=7u
* device instance $2314 r0 *1 248.4,420.1 NMOS
XM$2314 \$I4349 \$I4348 VSS VSS NMOS L=1u W=3.4u AS=6.12p AD=6.46p PS=7u PD=7.2u
* device instance $2315 r0 *1 253.2,420.1 NMOS
XM$2315 VSS \$I4349 \$I4348 VSS NMOS L=1u W=3.4u AS=6.46p AD=6.12p PS=7.2u PD=7u
* device instance $2316 r0 *1 257.8,420.1 NMOS
XM$2316 \$I4348 WL14 BLB10 VSS NMOS L=1u W=3.4u AS=6.12p AD=9.52p PS=7u PD=12.4u
* device instance $2317 r0 *1 248.4,381.3 PMOS
XM$2317 \$I4351 \$I4350 VDD VDD PMOS L=1u W=3.4u AS=10.88p AD=6.46p PS=13.2u
+ PD=7.2u
* device instance $2318 r0 *1 253.2,381.3 PMOS
XM$2318 VDD \$I4351 \$I4350 VDD PMOS L=1u W=3.4u AS=6.46p AD=10.88p PS=7.2u
+ PD=13.2u
* device instance $2319 r0 *1 243.8,360.9 NMOS
XM$2319 BL10 WL12 \$I4351 VSS NMOS L=1u W=3.4u AS=9.52p AD=6.12p PS=12.4u PD=7u
* device instance $2320 r0 *1 248.4,360.9 NMOS
XM$2320 \$I4351 \$I4350 VSS VSS NMOS L=1u W=3.4u AS=6.12p AD=6.46p PS=7u PD=7.2u
* device instance $2321 r0 *1 253.2,360.9 NMOS
XM$2321 VSS \$I4351 \$I4350 VSS NMOS L=1u W=3.4u AS=6.46p AD=6.12p PS=7.2u PD=7u
* device instance $2322 r0 *1 257.8,360.9 NMOS
XM$2322 \$I4350 WL12 BLB10 VSS NMOS L=1u W=3.4u AS=6.12p AD=9.52p PS=7u PD=12.4u
* device instance $2323 r0 *1 248.4,85.3 PMOS
XM$2323 \$I4353 \$I4352 VDD VDD PMOS L=1u W=3.4u AS=10.88p AD=6.46p PS=13.2u
+ PD=7.2u
* device instance $2324 r0 *1 253.2,85.3 PMOS
XM$2324 VDD \$I4353 \$I4352 VDD PMOS L=1u W=3.4u AS=6.46p AD=10.88p PS=7.2u
+ PD=13.2u
* device instance $2325 r0 *1 243.8,64.9 NMOS
XM$2325 BL10 WL2 \$I4353 VSS NMOS L=1u W=3.4u AS=9.52p AD=6.12p PS=12.4u PD=7u
* device instance $2326 r0 *1 248.4,64.9 NMOS
XM$2326 \$I4353 \$I4352 VSS VSS NMOS L=1u W=3.4u AS=6.12p AD=6.46p PS=7u PD=7.2u
* device instance $2327 r0 *1 253.2,64.9 NMOS
XM$2327 VSS \$I4353 \$I4352 VSS NMOS L=1u W=3.4u AS=6.46p AD=6.12p PS=7.2u PD=7u
* device instance $2328 r0 *1 257.8,64.9 NMOS
XM$2328 \$I4352 WL2 BLB10 VSS NMOS L=1u W=3.4u AS=6.12p AD=9.52p PS=7u PD=12.4u
* device instance $2329 r0 *1 248.4,322.1 PMOS
XM$2329 \$I4355 \$I4354 VDD VDD PMOS L=1u W=3.4u AS=10.88p AD=6.46p PS=13.2u
+ PD=7.2u
* device instance $2330 r0 *1 253.2,322.1 PMOS
XM$2330 VDD \$I4355 \$I4354 VDD PMOS L=1u W=3.4u AS=6.46p AD=10.88p PS=7.2u
+ PD=13.2u
* device instance $2331 r0 *1 243.8,301.7 NMOS
XM$2331 BL10 WL10 \$I4355 VSS NMOS L=1u W=3.4u AS=9.52p AD=6.12p PS=12.4u PD=7u
* device instance $2332 r0 *1 248.4,301.7 NMOS
XM$2332 \$I4355 \$I4354 VSS VSS NMOS L=1u W=3.4u AS=6.12p AD=6.46p PS=7u PD=7.2u
* device instance $2333 r0 *1 253.2,301.7 NMOS
XM$2333 VSS \$I4355 \$I4354 VSS NMOS L=1u W=3.4u AS=6.46p AD=6.12p PS=7.2u PD=7u
* device instance $2334 r0 *1 257.8,301.7 NMOS
XM$2334 \$I4354 WL10 BLB10 VSS NMOS L=1u W=3.4u AS=6.12p AD=9.52p PS=7u PD=12.4u
* device instance $2335 r0 *1 248.4,262.9 PMOS
XM$2335 \$I4357 \$I4356 VDD VDD PMOS L=1u W=3.4u AS=10.88p AD=6.46p PS=13.2u
+ PD=7.2u
* device instance $2336 r0 *1 253.2,262.9 PMOS
XM$2336 VDD \$I4357 \$I4356 VDD PMOS L=1u W=3.4u AS=6.46p AD=10.88p PS=7.2u
+ PD=13.2u
* device instance $2337 r0 *1 243.8,242.5 NMOS
XM$2337 BL10 WL8 \$I4357 VSS NMOS L=1u W=3.4u AS=9.52p AD=6.12p PS=12.4u PD=7u
* device instance $2338 r0 *1 248.4,242.5 NMOS
XM$2338 \$I4357 \$I4356 VSS VSS NMOS L=1u W=3.4u AS=6.12p AD=6.46p PS=7u PD=7.2u
* device instance $2339 r0 *1 253.2,242.5 NMOS
XM$2339 VSS \$I4357 \$I4356 VSS NMOS L=1u W=3.4u AS=6.46p AD=6.12p PS=7.2u PD=7u
* device instance $2340 r0 *1 257.8,242.5 NMOS
XM$2340 \$I4356 WL8 BLB10 VSS NMOS L=1u W=3.4u AS=6.12p AD=9.52p PS=7u PD=12.4u
* device instance $2341 r0 *1 248.4,144.5 PMOS
XM$2341 \$I4359 \$I4358 VDD VDD PMOS L=1u W=3.4u AS=10.88p AD=6.46p PS=13.2u
+ PD=7.2u
* device instance $2342 r0 *1 253.2,144.5 PMOS
XM$2342 VDD \$I4359 \$I4358 VDD PMOS L=1u W=3.4u AS=6.46p AD=10.88p PS=7.2u
+ PD=13.2u
* device instance $2343 r0 *1 243.8,124.1 NMOS
XM$2343 BL10 WL4 \$I4359 VSS NMOS L=1u W=3.4u AS=9.52p AD=6.12p PS=12.4u PD=7u
* device instance $2344 r0 *1 248.4,124.1 NMOS
XM$2344 \$I4359 \$I4358 VSS VSS NMOS L=1u W=3.4u AS=6.12p AD=6.46p PS=7u PD=7.2u
* device instance $2345 r0 *1 253.2,124.1 NMOS
XM$2345 VSS \$I4359 \$I4358 VSS NMOS L=1u W=3.4u AS=6.46p AD=6.12p PS=7.2u PD=7u
* device instance $2346 r0 *1 257.8,124.1 NMOS
XM$2346 \$I4358 WL4 BLB10 VSS NMOS L=1u W=3.4u AS=6.12p AD=9.52p PS=7u PD=12.4u
* device instance $2347 r0 *1 248.4,203.7 PMOS
XM$2347 \$I4361 \$I4360 VDD VDD PMOS L=1u W=3.4u AS=10.88p AD=6.46p PS=13.2u
+ PD=7.2u
* device instance $2348 r0 *1 253.2,203.7 PMOS
XM$2348 VDD \$I4361 \$I4360 VDD PMOS L=1u W=3.4u AS=6.46p AD=10.88p PS=7.2u
+ PD=13.2u
* device instance $2349 r0 *1 243.8,183.3 NMOS
XM$2349 BL10 WL6 \$I4361 VSS NMOS L=1u W=3.4u AS=9.52p AD=6.12p PS=12.4u PD=7u
* device instance $2350 r0 *1 248.4,183.3 NMOS
XM$2350 \$I4361 \$I4360 VSS VSS NMOS L=1u W=3.4u AS=6.12p AD=6.46p PS=7u PD=7.2u
* device instance $2351 r0 *1 253.2,183.3 NMOS
XM$2351 VSS \$I4361 \$I4360 VSS NMOS L=1u W=3.4u AS=6.46p AD=6.12p PS=7.2u PD=7u
* device instance $2352 r0 *1 257.8,183.3 NMOS
XM$2352 \$I4360 WL6 BLB10 VSS NMOS L=1u W=3.4u AS=6.12p AD=9.52p PS=7u PD=12.4u
* device instance $2353 m0 *1 226.4,92.3 PMOS
XM$2353 \$I4363 \$I4362 VDD VDD PMOS L=1u W=3.4u AS=10.88p AD=6.46p PS=13.2u
+ PD=7.2u
* device instance $2354 m0 *1 231.2,92.3 PMOS
XM$2354 VDD \$I4363 \$I4362 VDD PMOS L=1u W=3.4u AS=6.46p AD=10.88p PS=7.2u
+ PD=13.2u
* device instance $2355 m0 *1 221.8,112.7 NMOS
XM$2355 BL9 WL3 \$I4363 VSS NMOS L=1u W=3.4u AS=9.52p AD=6.12p PS=12.4u PD=7u
* device instance $2356 m0 *1 226.4,112.7 NMOS
XM$2356 \$I4363 \$I4362 VSS VSS NMOS L=1u W=3.4u AS=6.12p AD=6.46p PS=7u PD=7.2u
* device instance $2357 m0 *1 231.2,112.7 NMOS
XM$2357 VSS \$I4363 \$I4362 VSS NMOS L=1u W=3.4u AS=6.46p AD=6.12p PS=7.2u PD=7u
* device instance $2358 m0 *1 235.8,112.7 NMOS
XM$2358 \$I4362 WL3 BLB9 VSS NMOS L=1u W=3.4u AS=6.12p AD=9.52p PS=7u PD=12.4u
* device instance $2359 m0 *1 226.4,33.1 PMOS
XM$2359 \$I4365 \$I4364 VDD VDD PMOS L=1u W=3.4u AS=10.88p AD=6.46p PS=13.2u
+ PD=7.2u
* device instance $2360 m0 *1 231.2,33.1 PMOS
XM$2360 VDD \$I4365 \$I4364 VDD PMOS L=1u W=3.4u AS=6.46p AD=10.88p PS=7.2u
+ PD=13.2u
* device instance $2361 m0 *1 221.8,53.5 NMOS
XM$2361 BL9 WL1 \$I4365 VSS NMOS L=1u W=3.4u AS=9.52p AD=6.12p PS=12.4u PD=7u
* device instance $2362 m0 *1 226.4,53.5 NMOS
XM$2362 \$I4365 \$I4364 VSS VSS NMOS L=1u W=3.4u AS=6.12p AD=6.46p PS=7u PD=7.2u
* device instance $2363 m0 *1 231.2,53.5 NMOS
XM$2363 VSS \$I4365 \$I4364 VSS NMOS L=1u W=3.4u AS=6.46p AD=6.12p PS=7.2u PD=7u
* device instance $2364 m0 *1 235.8,53.5 NMOS
XM$2364 \$I4364 WL1 BLB9 VSS NMOS L=1u W=3.4u AS=6.12p AD=9.52p PS=7u PD=12.4u
* device instance $2365 m0 *1 226.4,447.5 PMOS
XM$2365 \$I4367 \$I4366 VDD VDD PMOS L=1u W=3.4u AS=10.88p AD=6.46p PS=13.2u
+ PD=7.2u
* device instance $2366 m0 *1 231.2,447.5 PMOS
XM$2366 VDD \$I4367 \$I4366 VDD PMOS L=1u W=3.4u AS=6.46p AD=10.88p PS=7.2u
+ PD=13.2u
* device instance $2367 m0 *1 221.8,467.9 NMOS
XM$2367 BL9 WL15 \$I4367 VSS NMOS L=1u W=3.4u AS=9.52p AD=6.12p PS=12.4u PD=7u
* device instance $2368 m0 *1 226.4,467.9 NMOS
XM$2368 \$I4367 \$I4366 VSS VSS NMOS L=1u W=3.4u AS=6.12p AD=6.46p PS=7u PD=7.2u
* device instance $2369 m0 *1 231.2,467.9 NMOS
XM$2369 VSS \$I4367 \$I4366 VSS NMOS L=1u W=3.4u AS=6.46p AD=6.12p PS=7.2u PD=7u
* device instance $2370 m0 *1 235.8,467.9 NMOS
XM$2370 \$I4366 WL15 BLB9 VSS NMOS L=1u W=3.4u AS=6.12p AD=9.52p PS=7u PD=12.4u
* device instance $2371 m0 *1 226.4,151.5 PMOS
XM$2371 \$I4369 \$I4368 VDD VDD PMOS L=1u W=3.4u AS=10.88p AD=6.46p PS=13.2u
+ PD=7.2u
* device instance $2372 m0 *1 231.2,151.5 PMOS
XM$2372 VDD \$I4369 \$I4368 VDD PMOS L=1u W=3.4u AS=6.46p AD=10.88p PS=7.2u
+ PD=13.2u
* device instance $2373 m0 *1 221.8,171.9 NMOS
XM$2373 BL9 WL5 \$I4369 VSS NMOS L=1u W=3.4u AS=9.52p AD=6.12p PS=12.4u PD=7u
* device instance $2374 m0 *1 226.4,171.9 NMOS
XM$2374 \$I4369 \$I4368 VSS VSS NMOS L=1u W=3.4u AS=6.12p AD=6.46p PS=7u PD=7.2u
* device instance $2375 m0 *1 231.2,171.9 NMOS
XM$2375 VSS \$I4369 \$I4368 VSS NMOS L=1u W=3.4u AS=6.46p AD=6.12p PS=7.2u PD=7u
* device instance $2376 m0 *1 235.8,171.9 NMOS
XM$2376 \$I4368 WL5 BLB9 VSS NMOS L=1u W=3.4u AS=6.12p AD=9.52p PS=7u PD=12.4u
* device instance $2377 m0 *1 226.4,329.1 PMOS
XM$2377 \$I4371 \$I4370 VDD VDD PMOS L=1u W=3.4u AS=10.88p AD=6.46p PS=13.2u
+ PD=7.2u
* device instance $2378 m0 *1 231.2,329.1 PMOS
XM$2378 VDD \$I4371 \$I4370 VDD PMOS L=1u W=3.4u AS=6.46p AD=10.88p PS=7.2u
+ PD=13.2u
* device instance $2379 m0 *1 221.8,349.5 NMOS
XM$2379 BL9 WL11 \$I4371 VSS NMOS L=1u W=3.4u AS=9.52p AD=6.12p PS=12.4u PD=7u
* device instance $2380 m0 *1 226.4,349.5 NMOS
XM$2380 \$I4371 \$I4370 VSS VSS NMOS L=1u W=3.4u AS=6.12p AD=6.46p PS=7u PD=7.2u
* device instance $2381 m0 *1 231.2,349.5 NMOS
XM$2381 VSS \$I4371 \$I4370 VSS NMOS L=1u W=3.4u AS=6.46p AD=6.12p PS=7.2u PD=7u
* device instance $2382 m0 *1 235.8,349.5 NMOS
XM$2382 \$I4370 WL11 BLB9 VSS NMOS L=1u W=3.4u AS=6.12p AD=9.52p PS=7u PD=12.4u
* device instance $2383 m0 *1 226.4,388.3 PMOS
XM$2383 \$I4373 \$I4372 VDD VDD PMOS L=1u W=3.4u AS=10.88p AD=6.46p PS=13.2u
+ PD=7.2u
* device instance $2384 m0 *1 231.2,388.3 PMOS
XM$2384 VDD \$I4373 \$I4372 VDD PMOS L=1u W=3.4u AS=6.46p AD=10.88p PS=7.2u
+ PD=13.2u
* device instance $2385 m0 *1 221.8,408.7 NMOS
XM$2385 BL9 WL13 \$I4373 VSS NMOS L=1u W=3.4u AS=9.52p AD=6.12p PS=12.4u PD=7u
* device instance $2386 m0 *1 226.4,408.7 NMOS
XM$2386 \$I4373 \$I4372 VSS VSS NMOS L=1u W=3.4u AS=6.12p AD=6.46p PS=7u PD=7.2u
* device instance $2387 m0 *1 231.2,408.7 NMOS
XM$2387 VSS \$I4373 \$I4372 VSS NMOS L=1u W=3.4u AS=6.46p AD=6.12p PS=7.2u PD=7u
* device instance $2388 m0 *1 235.8,408.7 NMOS
XM$2388 \$I4372 WL13 BLB9 VSS NMOS L=1u W=3.4u AS=6.12p AD=9.52p PS=7u PD=12.4u
* device instance $2389 m0 *1 226.4,269.9 PMOS
XM$2389 \$I4375 \$I4374 VDD VDD PMOS L=1u W=3.4u AS=10.88p AD=6.46p PS=13.2u
+ PD=7.2u
* device instance $2390 m0 *1 231.2,269.9 PMOS
XM$2390 VDD \$I4375 \$I4374 VDD PMOS L=1u W=3.4u AS=6.46p AD=10.88p PS=7.2u
+ PD=13.2u
* device instance $2391 m0 *1 221.8,290.3 NMOS
XM$2391 BL9 WL9 \$I4375 VSS NMOS L=1u W=3.4u AS=9.52p AD=6.12p PS=12.4u PD=7u
* device instance $2392 m0 *1 226.4,290.3 NMOS
XM$2392 \$I4375 \$I4374 VSS VSS NMOS L=1u W=3.4u AS=6.12p AD=6.46p PS=7u PD=7.2u
* device instance $2393 m0 *1 231.2,290.3 NMOS
XM$2393 VSS \$I4375 \$I4374 VSS NMOS L=1u W=3.4u AS=6.46p AD=6.12p PS=7.2u PD=7u
* device instance $2394 m0 *1 235.8,290.3 NMOS
XM$2394 \$I4374 WL9 BLB9 VSS NMOS L=1u W=3.4u AS=6.12p AD=9.52p PS=7u PD=12.4u
* device instance $2395 m0 *1 226.4,210.7 PMOS
XM$2395 \$I4377 \$I4376 VDD VDD PMOS L=1u W=3.4u AS=10.88p AD=6.46p PS=13.2u
+ PD=7.2u
* device instance $2396 m0 *1 231.2,210.7 PMOS
XM$2396 VDD \$I4377 \$I4376 VDD PMOS L=1u W=3.4u AS=6.46p AD=10.88p PS=7.2u
+ PD=13.2u
* device instance $2397 m0 *1 221.8,231.1 NMOS
XM$2397 BL9 WL7 \$I4377 VSS NMOS L=1u W=3.4u AS=9.52p AD=6.12p PS=12.4u PD=7u
* device instance $2398 m0 *1 226.4,231.1 NMOS
XM$2398 \$I4377 \$I4376 VSS VSS NMOS L=1u W=3.4u AS=6.12p AD=6.46p PS=7u PD=7.2u
* device instance $2399 m0 *1 231.2,231.1 NMOS
XM$2399 VSS \$I4377 \$I4376 VSS NMOS L=1u W=3.4u AS=6.46p AD=6.12p PS=7.2u PD=7u
* device instance $2400 m0 *1 235.8,231.1 NMOS
XM$2400 \$I4376 WL7 BLB9 VSS NMOS L=1u W=3.4u AS=6.12p AD=9.52p PS=7u PD=12.4u
* device instance $2401 r0 *1 226.4,440.5 PMOS
XM$2401 \$I4379 \$I4378 VDD VDD PMOS L=1u W=3.4u AS=10.88p AD=6.46p PS=13.2u
+ PD=7.2u
* device instance $2402 r0 *1 231.2,440.5 PMOS
XM$2402 VDD \$I4379 \$I4378 VDD PMOS L=1u W=3.4u AS=6.46p AD=10.88p PS=7.2u
+ PD=13.2u
* device instance $2403 r0 *1 221.8,420.1 NMOS
XM$2403 BL9 WL14 \$I4379 VSS NMOS L=1u W=3.4u AS=9.52p AD=6.12p PS=12.4u PD=7u
* device instance $2404 r0 *1 226.4,420.1 NMOS
XM$2404 \$I4379 \$I4378 VSS VSS NMOS L=1u W=3.4u AS=6.12p AD=6.46p PS=7u PD=7.2u
* device instance $2405 r0 *1 231.2,420.1 NMOS
XM$2405 VSS \$I4379 \$I4378 VSS NMOS L=1u W=3.4u AS=6.46p AD=6.12p PS=7.2u PD=7u
* device instance $2406 r0 *1 235.8,420.1 NMOS
XM$2406 \$I4378 WL14 BLB9 VSS NMOS L=1u W=3.4u AS=6.12p AD=9.52p PS=7u PD=12.4u
* device instance $2407 r0 *1 226.4,381.3 PMOS
XM$2407 \$I4381 \$I4380 VDD VDD PMOS L=1u W=3.4u AS=10.88p AD=6.46p PS=13.2u
+ PD=7.2u
* device instance $2408 r0 *1 231.2,381.3 PMOS
XM$2408 VDD \$I4381 \$I4380 VDD PMOS L=1u W=3.4u AS=6.46p AD=10.88p PS=7.2u
+ PD=13.2u
* device instance $2409 r0 *1 221.8,360.9 NMOS
XM$2409 BL9 WL12 \$I4381 VSS NMOS L=1u W=3.4u AS=9.52p AD=6.12p PS=12.4u PD=7u
* device instance $2410 r0 *1 226.4,360.9 NMOS
XM$2410 \$I4381 \$I4380 VSS VSS NMOS L=1u W=3.4u AS=6.12p AD=6.46p PS=7u PD=7.2u
* device instance $2411 r0 *1 231.2,360.9 NMOS
XM$2411 VSS \$I4381 \$I4380 VSS NMOS L=1u W=3.4u AS=6.46p AD=6.12p PS=7.2u PD=7u
* device instance $2412 r0 *1 235.8,360.9 NMOS
XM$2412 \$I4380 WL12 BLB9 VSS NMOS L=1u W=3.4u AS=6.12p AD=9.52p PS=7u PD=12.4u
* device instance $2413 r0 *1 226.4,85.3 PMOS
XM$2413 \$I4383 \$I4382 VDD VDD PMOS L=1u W=3.4u AS=10.88p AD=6.46p PS=13.2u
+ PD=7.2u
* device instance $2414 r0 *1 231.2,85.3 PMOS
XM$2414 VDD \$I4383 \$I4382 VDD PMOS L=1u W=3.4u AS=6.46p AD=10.88p PS=7.2u
+ PD=13.2u
* device instance $2415 r0 *1 221.8,64.9 NMOS
XM$2415 BL9 WL2 \$I4383 VSS NMOS L=1u W=3.4u AS=9.52p AD=6.12p PS=12.4u PD=7u
* device instance $2416 r0 *1 226.4,64.9 NMOS
XM$2416 \$I4383 \$I4382 VSS VSS NMOS L=1u W=3.4u AS=6.12p AD=6.46p PS=7u PD=7.2u
* device instance $2417 r0 *1 231.2,64.9 NMOS
XM$2417 VSS \$I4383 \$I4382 VSS NMOS L=1u W=3.4u AS=6.46p AD=6.12p PS=7.2u PD=7u
* device instance $2418 r0 *1 235.8,64.9 NMOS
XM$2418 \$I4382 WL2 BLB9 VSS NMOS L=1u W=3.4u AS=6.12p AD=9.52p PS=7u PD=12.4u
* device instance $2419 r0 *1 226.4,322.1 PMOS
XM$2419 \$I4385 \$I4384 VDD VDD PMOS L=1u W=3.4u AS=10.88p AD=6.46p PS=13.2u
+ PD=7.2u
* device instance $2420 r0 *1 231.2,322.1 PMOS
XM$2420 VDD \$I4385 \$I4384 VDD PMOS L=1u W=3.4u AS=6.46p AD=10.88p PS=7.2u
+ PD=13.2u
* device instance $2421 r0 *1 221.8,301.7 NMOS
XM$2421 BL9 WL10 \$I4385 VSS NMOS L=1u W=3.4u AS=9.52p AD=6.12p PS=12.4u PD=7u
* device instance $2422 r0 *1 226.4,301.7 NMOS
XM$2422 \$I4385 \$I4384 VSS VSS NMOS L=1u W=3.4u AS=6.12p AD=6.46p PS=7u PD=7.2u
* device instance $2423 r0 *1 231.2,301.7 NMOS
XM$2423 VSS \$I4385 \$I4384 VSS NMOS L=1u W=3.4u AS=6.46p AD=6.12p PS=7.2u PD=7u
* device instance $2424 r0 *1 235.8,301.7 NMOS
XM$2424 \$I4384 WL10 BLB9 VSS NMOS L=1u W=3.4u AS=6.12p AD=9.52p PS=7u PD=12.4u
* device instance $2425 r0 *1 226.4,262.9 PMOS
XM$2425 \$I4387 \$I4386 VDD VDD PMOS L=1u W=3.4u AS=10.88p AD=6.46p PS=13.2u
+ PD=7.2u
* device instance $2426 r0 *1 231.2,262.9 PMOS
XM$2426 VDD \$I4387 \$I4386 VDD PMOS L=1u W=3.4u AS=6.46p AD=10.88p PS=7.2u
+ PD=13.2u
* device instance $2427 r0 *1 221.8,242.5 NMOS
XM$2427 BL9 WL8 \$I4387 VSS NMOS L=1u W=3.4u AS=9.52p AD=6.12p PS=12.4u PD=7u
* device instance $2428 r0 *1 226.4,242.5 NMOS
XM$2428 \$I4387 \$I4386 VSS VSS NMOS L=1u W=3.4u AS=6.12p AD=6.46p PS=7u PD=7.2u
* device instance $2429 r0 *1 231.2,242.5 NMOS
XM$2429 VSS \$I4387 \$I4386 VSS NMOS L=1u W=3.4u AS=6.46p AD=6.12p PS=7.2u PD=7u
* device instance $2430 r0 *1 235.8,242.5 NMOS
XM$2430 \$I4386 WL8 BLB9 VSS NMOS L=1u W=3.4u AS=6.12p AD=9.52p PS=7u PD=12.4u
* device instance $2431 r0 *1 226.4,144.5 PMOS
XM$2431 \$I4389 \$I4388 VDD VDD PMOS L=1u W=3.4u AS=10.88p AD=6.46p PS=13.2u
+ PD=7.2u
* device instance $2432 r0 *1 231.2,144.5 PMOS
XM$2432 VDD \$I4389 \$I4388 VDD PMOS L=1u W=3.4u AS=6.46p AD=10.88p PS=7.2u
+ PD=13.2u
* device instance $2433 r0 *1 221.8,124.1 NMOS
XM$2433 BL9 WL4 \$I4389 VSS NMOS L=1u W=3.4u AS=9.52p AD=6.12p PS=12.4u PD=7u
* device instance $2434 r0 *1 226.4,124.1 NMOS
XM$2434 \$I4389 \$I4388 VSS VSS NMOS L=1u W=3.4u AS=6.12p AD=6.46p PS=7u PD=7.2u
* device instance $2435 r0 *1 231.2,124.1 NMOS
XM$2435 VSS \$I4389 \$I4388 VSS NMOS L=1u W=3.4u AS=6.46p AD=6.12p PS=7.2u PD=7u
* device instance $2436 r0 *1 235.8,124.1 NMOS
XM$2436 \$I4388 WL4 BLB9 VSS NMOS L=1u W=3.4u AS=6.12p AD=9.52p PS=7u PD=12.4u
* device instance $2437 r0 *1 226.4,203.7 PMOS
XM$2437 \$I4391 \$I4390 VDD VDD PMOS L=1u W=3.4u AS=10.88p AD=6.46p PS=13.2u
+ PD=7.2u
* device instance $2438 r0 *1 231.2,203.7 PMOS
XM$2438 VDD \$I4391 \$I4390 VDD PMOS L=1u W=3.4u AS=6.46p AD=10.88p PS=7.2u
+ PD=13.2u
* device instance $2439 r0 *1 221.8,183.3 NMOS
XM$2439 BL9 WL6 \$I4391 VSS NMOS L=1u W=3.4u AS=9.52p AD=6.12p PS=12.4u PD=7u
* device instance $2440 r0 *1 226.4,183.3 NMOS
XM$2440 \$I4391 \$I4390 VSS VSS NMOS L=1u W=3.4u AS=6.12p AD=6.46p PS=7u PD=7.2u
* device instance $2441 r0 *1 231.2,183.3 NMOS
XM$2441 VSS \$I4391 \$I4390 VSS NMOS L=1u W=3.4u AS=6.46p AD=6.12p PS=7.2u PD=7u
* device instance $2442 r0 *1 235.8,183.3 NMOS
XM$2442 \$I4390 WL6 BLB9 VSS NMOS L=1u W=3.4u AS=6.12p AD=9.52p PS=7u PD=12.4u
* device instance $2443 m0 *1 358.4,33.1 PMOS
XM$2443 \$I4393 \$I4392 VDD VDD PMOS L=1u W=3.4u AS=10.88p AD=6.46p PS=13.2u
+ PD=7.2u
* device instance $2444 m0 *1 363.2,33.1 PMOS
XM$2444 VDD \$I4393 \$I4392 VDD PMOS L=1u W=3.4u AS=6.46p AD=10.88p PS=7.2u
+ PD=13.2u
* device instance $2445 m0 *1 353.8,53.5 NMOS
XM$2445 BL15 WL1 \$I4393 VSS NMOS L=1u W=3.4u AS=9.52p AD=6.12p PS=12.4u PD=7u
* device instance $2446 m0 *1 358.4,53.5 NMOS
XM$2446 \$I4393 \$I4392 VSS VSS NMOS L=1u W=3.4u AS=6.12p AD=6.46p PS=7u PD=7.2u
* device instance $2447 m0 *1 363.2,53.5 NMOS
XM$2447 VSS \$I4393 \$I4392 VSS NMOS L=1u W=3.4u AS=6.46p AD=6.12p PS=7.2u PD=7u
* device instance $2448 m0 *1 367.8,53.5 NMOS
XM$2448 \$I4392 WL1 BLB15 VSS NMOS L=1u W=3.4u AS=6.12p AD=9.52p PS=7u PD=12.4u
* device instance $2449 m0 *1 358.4,151.5 PMOS
XM$2449 \$I4395 \$I4394 VDD VDD PMOS L=1u W=3.4u AS=10.88p AD=6.46p PS=13.2u
+ PD=7.2u
* device instance $2450 m0 *1 363.2,151.5 PMOS
XM$2450 VDD \$I4395 \$I4394 VDD PMOS L=1u W=3.4u AS=6.46p AD=10.88p PS=7.2u
+ PD=13.2u
* device instance $2451 m0 *1 353.8,171.9 NMOS
XM$2451 BL15 WL5 \$I4395 VSS NMOS L=1u W=3.4u AS=9.52p AD=6.12p PS=12.4u PD=7u
* device instance $2452 m0 *1 358.4,171.9 NMOS
XM$2452 \$I4395 \$I4394 VSS VSS NMOS L=1u W=3.4u AS=6.12p AD=6.46p PS=7u PD=7.2u
* device instance $2453 m0 *1 363.2,171.9 NMOS
XM$2453 VSS \$I4395 \$I4394 VSS NMOS L=1u W=3.4u AS=6.46p AD=6.12p PS=7.2u PD=7u
* device instance $2454 m0 *1 367.8,171.9 NMOS
XM$2454 \$I4394 WL5 BLB15 VSS NMOS L=1u W=3.4u AS=6.12p AD=9.52p PS=7u PD=12.4u
* device instance $2455 m0 *1 358.4,329.1 PMOS
XM$2455 \$I4397 \$I4396 VDD VDD PMOS L=1u W=3.4u AS=10.88p AD=6.46p PS=13.2u
+ PD=7.2u
* device instance $2456 m0 *1 363.2,329.1 PMOS
XM$2456 VDD \$I4397 \$I4396 VDD PMOS L=1u W=3.4u AS=6.46p AD=10.88p PS=7.2u
+ PD=13.2u
* device instance $2457 m0 *1 353.8,349.5 NMOS
XM$2457 BL15 WL11 \$I4397 VSS NMOS L=1u W=3.4u AS=9.52p AD=6.12p PS=12.4u PD=7u
* device instance $2458 m0 *1 358.4,349.5 NMOS
XM$2458 \$I4397 \$I4396 VSS VSS NMOS L=1u W=3.4u AS=6.12p AD=6.46p PS=7u PD=7.2u
* device instance $2459 m0 *1 363.2,349.5 NMOS
XM$2459 VSS \$I4397 \$I4396 VSS NMOS L=1u W=3.4u AS=6.46p AD=6.12p PS=7.2u PD=7u
* device instance $2460 m0 *1 367.8,349.5 NMOS
XM$2460 \$I4396 WL11 BLB15 VSS NMOS L=1u W=3.4u AS=6.12p AD=9.52p PS=7u PD=12.4u
* device instance $2461 m0 *1 358.4,388.3 PMOS
XM$2461 \$I4399 \$I4398 VDD VDD PMOS L=1u W=3.4u AS=10.88p AD=6.46p PS=13.2u
+ PD=7.2u
* device instance $2462 m0 *1 363.2,388.3 PMOS
XM$2462 VDD \$I4399 \$I4398 VDD PMOS L=1u W=3.4u AS=6.46p AD=10.88p PS=7.2u
+ PD=13.2u
* device instance $2463 m0 *1 353.8,408.7 NMOS
XM$2463 BL15 WL13 \$I4399 VSS NMOS L=1u W=3.4u AS=9.52p AD=6.12p PS=12.4u PD=7u
* device instance $2464 m0 *1 358.4,408.7 NMOS
XM$2464 \$I4399 \$I4398 VSS VSS NMOS L=1u W=3.4u AS=6.12p AD=6.46p PS=7u PD=7.2u
* device instance $2465 m0 *1 363.2,408.7 NMOS
XM$2465 VSS \$I4399 \$I4398 VSS NMOS L=1u W=3.4u AS=6.46p AD=6.12p PS=7.2u PD=7u
* device instance $2466 m0 *1 367.8,408.7 NMOS
XM$2466 \$I4398 WL13 BLB15 VSS NMOS L=1u W=3.4u AS=6.12p AD=9.52p PS=7u PD=12.4u
* device instance $2467 m0 *1 358.4,210.7 PMOS
XM$2467 \$I4401 \$I4400 VDD VDD PMOS L=1u W=3.4u AS=10.88p AD=6.46p PS=13.2u
+ PD=7.2u
* device instance $2468 m0 *1 363.2,210.7 PMOS
XM$2468 VDD \$I4401 \$I4400 VDD PMOS L=1u W=3.4u AS=6.46p AD=10.88p PS=7.2u
+ PD=13.2u
* device instance $2469 m0 *1 353.8,231.1 NMOS
XM$2469 BL15 WL7 \$I4401 VSS NMOS L=1u W=3.4u AS=9.52p AD=6.12p PS=12.4u PD=7u
* device instance $2470 m0 *1 358.4,231.1 NMOS
XM$2470 \$I4401 \$I4400 VSS VSS NMOS L=1u W=3.4u AS=6.12p AD=6.46p PS=7u PD=7.2u
* device instance $2471 m0 *1 363.2,231.1 NMOS
XM$2471 VSS \$I4401 \$I4400 VSS NMOS L=1u W=3.4u AS=6.46p AD=6.12p PS=7.2u PD=7u
* device instance $2472 m0 *1 367.8,231.1 NMOS
XM$2472 \$I4400 WL7 BLB15 VSS NMOS L=1u W=3.4u AS=6.12p AD=9.52p PS=7u PD=12.4u
* device instance $2473 m0 *1 358.4,269.9 PMOS
XM$2473 \$I4403 \$I4402 VDD VDD PMOS L=1u W=3.4u AS=10.88p AD=6.46p PS=13.2u
+ PD=7.2u
* device instance $2474 m0 *1 363.2,269.9 PMOS
XM$2474 VDD \$I4403 \$I4402 VDD PMOS L=1u W=3.4u AS=6.46p AD=10.88p PS=7.2u
+ PD=13.2u
* device instance $2475 m0 *1 353.8,290.3 NMOS
XM$2475 BL15 WL9 \$I4403 VSS NMOS L=1u W=3.4u AS=9.52p AD=6.12p PS=12.4u PD=7u
* device instance $2476 m0 *1 358.4,290.3 NMOS
XM$2476 \$I4403 \$I4402 VSS VSS NMOS L=1u W=3.4u AS=6.12p AD=6.46p PS=7u PD=7.2u
* device instance $2477 m0 *1 363.2,290.3 NMOS
XM$2477 VSS \$I4403 \$I4402 VSS NMOS L=1u W=3.4u AS=6.46p AD=6.12p PS=7.2u PD=7u
* device instance $2478 m0 *1 367.8,290.3 NMOS
XM$2478 \$I4402 WL9 BLB15 VSS NMOS L=1u W=3.4u AS=6.12p AD=9.52p PS=7u PD=12.4u
* device instance $2479 m0 *1 358.4,92.3 PMOS
XM$2479 \$I4405 \$I4404 VDD VDD PMOS L=1u W=3.4u AS=10.88p AD=6.46p PS=13.2u
+ PD=7.2u
* device instance $2480 m0 *1 363.2,92.3 PMOS
XM$2480 VDD \$I4405 \$I4404 VDD PMOS L=1u W=3.4u AS=6.46p AD=10.88p PS=7.2u
+ PD=13.2u
* device instance $2481 m0 *1 353.8,112.7 NMOS
XM$2481 BL15 WL3 \$I4405 VSS NMOS L=1u W=3.4u AS=9.52p AD=6.12p PS=12.4u PD=7u
* device instance $2482 m0 *1 358.4,112.7 NMOS
XM$2482 \$I4405 \$I4404 VSS VSS NMOS L=1u W=3.4u AS=6.12p AD=6.46p PS=7u PD=7.2u
* device instance $2483 m0 *1 363.2,112.7 NMOS
XM$2483 VSS \$I4405 \$I4404 VSS NMOS L=1u W=3.4u AS=6.46p AD=6.12p PS=7.2u PD=7u
* device instance $2484 m0 *1 367.8,112.7 NMOS
XM$2484 \$I4404 WL3 BLB15 VSS NMOS L=1u W=3.4u AS=6.12p AD=9.52p PS=7u PD=12.4u
* device instance $2485 m0 *1 358.4,447.5 PMOS
XM$2485 \$I4407 \$I4406 VDD VDD PMOS L=1u W=3.4u AS=10.88p AD=6.46p PS=13.2u
+ PD=7.2u
* device instance $2486 m0 *1 363.2,447.5 PMOS
XM$2486 VDD \$I4407 \$I4406 VDD PMOS L=1u W=3.4u AS=6.46p AD=10.88p PS=7.2u
+ PD=13.2u
* device instance $2487 m0 *1 353.8,467.9 NMOS
XM$2487 BL15 WL15 \$I4407 VSS NMOS L=1u W=3.4u AS=9.52p AD=6.12p PS=12.4u PD=7u
* device instance $2488 m0 *1 358.4,467.9 NMOS
XM$2488 \$I4407 \$I4406 VSS VSS NMOS L=1u W=3.4u AS=6.12p AD=6.46p PS=7u PD=7.2u
* device instance $2489 m0 *1 363.2,467.9 NMOS
XM$2489 VSS \$I4407 \$I4406 VSS NMOS L=1u W=3.4u AS=6.46p AD=6.12p PS=7.2u PD=7u
* device instance $2490 m0 *1 367.8,467.9 NMOS
XM$2490 \$I4406 WL15 BLB15 VSS NMOS L=1u W=3.4u AS=6.12p AD=9.52p PS=7u PD=12.4u
* device instance $2491 r0 *1 358.4,440.5 PMOS
XM$2491 \$I4409 \$I4408 VDD VDD PMOS L=1u W=3.4u AS=10.88p AD=6.46p PS=13.2u
+ PD=7.2u
* device instance $2492 r0 *1 363.2,440.5 PMOS
XM$2492 VDD \$I4409 \$I4408 VDD PMOS L=1u W=3.4u AS=6.46p AD=10.88p PS=7.2u
+ PD=13.2u
* device instance $2493 r0 *1 353.8,420.1 NMOS
XM$2493 BL15 WL14 \$I4409 VSS NMOS L=1u W=3.4u AS=9.52p AD=6.12p PS=12.4u PD=7u
* device instance $2494 r0 *1 358.4,420.1 NMOS
XM$2494 \$I4409 \$I4408 VSS VSS NMOS L=1u W=3.4u AS=6.12p AD=6.46p PS=7u PD=7.2u
* device instance $2495 r0 *1 363.2,420.1 NMOS
XM$2495 VSS \$I4409 \$I4408 VSS NMOS L=1u W=3.4u AS=6.46p AD=6.12p PS=7.2u PD=7u
* device instance $2496 r0 *1 367.8,420.1 NMOS
XM$2496 \$I4408 WL14 BLB15 VSS NMOS L=1u W=3.4u AS=6.12p AD=9.52p PS=7u PD=12.4u
* device instance $2497 r0 *1 358.4,381.3 PMOS
XM$2497 \$I4411 \$I4410 VDD VDD PMOS L=1u W=3.4u AS=10.88p AD=6.46p PS=13.2u
+ PD=7.2u
* device instance $2498 r0 *1 363.2,381.3 PMOS
XM$2498 VDD \$I4411 \$I4410 VDD PMOS L=1u W=3.4u AS=6.46p AD=10.88p PS=7.2u
+ PD=13.2u
* device instance $2499 r0 *1 353.8,360.9 NMOS
XM$2499 BL15 WL12 \$I4411 VSS NMOS L=1u W=3.4u AS=9.52p AD=6.12p PS=12.4u PD=7u
* device instance $2500 r0 *1 358.4,360.9 NMOS
XM$2500 \$I4411 \$I4410 VSS VSS NMOS L=1u W=3.4u AS=6.12p AD=6.46p PS=7u PD=7.2u
* device instance $2501 r0 *1 363.2,360.9 NMOS
XM$2501 VSS \$I4411 \$I4410 VSS NMOS L=1u W=3.4u AS=6.46p AD=6.12p PS=7.2u PD=7u
* device instance $2502 r0 *1 367.8,360.9 NMOS
XM$2502 \$I4410 WL12 BLB15 VSS NMOS L=1u W=3.4u AS=6.12p AD=9.52p PS=7u PD=12.4u
* device instance $2503 r0 *1 358.4,85.3 PMOS
XM$2503 \$I4413 \$I4412 VDD VDD PMOS L=1u W=3.4u AS=10.88p AD=6.46p PS=13.2u
+ PD=7.2u
* device instance $2504 r0 *1 363.2,85.3 PMOS
XM$2504 VDD \$I4413 \$I4412 VDD PMOS L=1u W=3.4u AS=6.46p AD=10.88p PS=7.2u
+ PD=13.2u
* device instance $2505 r0 *1 353.8,64.9 NMOS
XM$2505 BL15 WL2 \$I4413 VSS NMOS L=1u W=3.4u AS=9.52p AD=6.12p PS=12.4u PD=7u
* device instance $2506 r0 *1 358.4,64.9 NMOS
XM$2506 \$I4413 \$I4412 VSS VSS NMOS L=1u W=3.4u AS=6.12p AD=6.46p PS=7u PD=7.2u
* device instance $2507 r0 *1 363.2,64.9 NMOS
XM$2507 VSS \$I4413 \$I4412 VSS NMOS L=1u W=3.4u AS=6.46p AD=6.12p PS=7.2u PD=7u
* device instance $2508 r0 *1 367.8,64.9 NMOS
XM$2508 \$I4412 WL2 BLB15 VSS NMOS L=1u W=3.4u AS=6.12p AD=9.52p PS=7u PD=12.4u
* device instance $2509 r0 *1 358.4,322.1 PMOS
XM$2509 \$I4415 \$I4414 VDD VDD PMOS L=1u W=3.4u AS=10.88p AD=6.46p PS=13.2u
+ PD=7.2u
* device instance $2510 r0 *1 363.2,322.1 PMOS
XM$2510 VDD \$I4415 \$I4414 VDD PMOS L=1u W=3.4u AS=6.46p AD=10.88p PS=7.2u
+ PD=13.2u
* device instance $2511 r0 *1 353.8,301.7 NMOS
XM$2511 BL15 WL10 \$I4415 VSS NMOS L=1u W=3.4u AS=9.52p AD=6.12p PS=12.4u PD=7u
* device instance $2512 r0 *1 358.4,301.7 NMOS
XM$2512 \$I4415 \$I4414 VSS VSS NMOS L=1u W=3.4u AS=6.12p AD=6.46p PS=7u PD=7.2u
* device instance $2513 r0 *1 363.2,301.7 NMOS
XM$2513 VSS \$I4415 \$I4414 VSS NMOS L=1u W=3.4u AS=6.46p AD=6.12p PS=7.2u PD=7u
* device instance $2514 r0 *1 367.8,301.7 NMOS
XM$2514 \$I4414 WL10 BLB15 VSS NMOS L=1u W=3.4u AS=6.12p AD=9.52p PS=7u PD=12.4u
* device instance $2515 r0 *1 358.4,262.9 PMOS
XM$2515 \$I4417 \$I4416 VDD VDD PMOS L=1u W=3.4u AS=10.88p AD=6.46p PS=13.2u
+ PD=7.2u
* device instance $2516 r0 *1 363.2,262.9 PMOS
XM$2516 VDD \$I4417 \$I4416 VDD PMOS L=1u W=3.4u AS=6.46p AD=10.88p PS=7.2u
+ PD=13.2u
* device instance $2517 r0 *1 353.8,242.5 NMOS
XM$2517 BL15 WL8 \$I4417 VSS NMOS L=1u W=3.4u AS=9.52p AD=6.12p PS=12.4u PD=7u
* device instance $2518 r0 *1 358.4,242.5 NMOS
XM$2518 \$I4417 \$I4416 VSS VSS NMOS L=1u W=3.4u AS=6.12p AD=6.46p PS=7u PD=7.2u
* device instance $2519 r0 *1 363.2,242.5 NMOS
XM$2519 VSS \$I4417 \$I4416 VSS NMOS L=1u W=3.4u AS=6.46p AD=6.12p PS=7.2u PD=7u
* device instance $2520 r0 *1 367.8,242.5 NMOS
XM$2520 \$I4416 WL8 BLB15 VSS NMOS L=1u W=3.4u AS=6.12p AD=9.52p PS=7u PD=12.4u
* device instance $2521 r0 *1 358.4,144.5 PMOS
XM$2521 \$I4419 \$I4418 VDD VDD PMOS L=1u W=3.4u AS=10.88p AD=6.46p PS=13.2u
+ PD=7.2u
* device instance $2522 r0 *1 363.2,144.5 PMOS
XM$2522 VDD \$I4419 \$I4418 VDD PMOS L=1u W=3.4u AS=6.46p AD=10.88p PS=7.2u
+ PD=13.2u
* device instance $2523 r0 *1 353.8,124.1 NMOS
XM$2523 BL15 WL4 \$I4419 VSS NMOS L=1u W=3.4u AS=9.52p AD=6.12p PS=12.4u PD=7u
* device instance $2524 r0 *1 358.4,124.1 NMOS
XM$2524 \$I4419 \$I4418 VSS VSS NMOS L=1u W=3.4u AS=6.12p AD=6.46p PS=7u PD=7.2u
* device instance $2525 r0 *1 363.2,124.1 NMOS
XM$2525 VSS \$I4419 \$I4418 VSS NMOS L=1u W=3.4u AS=6.46p AD=6.12p PS=7.2u PD=7u
* device instance $2526 r0 *1 367.8,124.1 NMOS
XM$2526 \$I4418 WL4 BLB15 VSS NMOS L=1u W=3.4u AS=6.12p AD=9.52p PS=7u PD=12.4u
* device instance $2527 r0 *1 358.4,203.7 PMOS
XM$2527 \$I4421 \$I4420 VDD VDD PMOS L=1u W=3.4u AS=10.88p AD=6.46p PS=13.2u
+ PD=7.2u
* device instance $2528 r0 *1 363.2,203.7 PMOS
XM$2528 VDD \$I4421 \$I4420 VDD PMOS L=1u W=3.4u AS=6.46p AD=10.88p PS=7.2u
+ PD=13.2u
* device instance $2529 r0 *1 353.8,183.3 NMOS
XM$2529 BL15 WL6 \$I4421 VSS NMOS L=1u W=3.4u AS=9.52p AD=6.12p PS=12.4u PD=7u
* device instance $2530 r0 *1 358.4,183.3 NMOS
XM$2530 \$I4421 \$I4420 VSS VSS NMOS L=1u W=3.4u AS=6.12p AD=6.46p PS=7u PD=7.2u
* device instance $2531 r0 *1 363.2,183.3 NMOS
XM$2531 VSS \$I4421 \$I4420 VSS NMOS L=1u W=3.4u AS=6.46p AD=6.12p PS=7.2u PD=7u
* device instance $2532 r0 *1 367.8,183.3 NMOS
XM$2532 \$I4420 WL6 BLB15 VSS NMOS L=1u W=3.4u AS=6.12p AD=9.52p PS=7u PD=12.4u
* device instance $2533 m0 *1 336.4,33.1 PMOS
XM$2533 \$I4423 \$I4422 VDD VDD PMOS L=1u W=3.4u AS=10.88p AD=6.46p PS=13.2u
+ PD=7.2u
* device instance $2534 m0 *1 341.2,33.1 PMOS
XM$2534 VDD \$I4423 \$I4422 VDD PMOS L=1u W=3.4u AS=6.46p AD=10.88p PS=7.2u
+ PD=13.2u
* device instance $2535 m0 *1 331.8,53.5 NMOS
XM$2535 BL14 WL1 \$I4423 VSS NMOS L=1u W=3.4u AS=9.52p AD=6.12p PS=12.4u PD=7u
* device instance $2536 m0 *1 336.4,53.5 NMOS
XM$2536 \$I4423 \$I4422 VSS VSS NMOS L=1u W=3.4u AS=6.12p AD=6.46p PS=7u PD=7.2u
* device instance $2537 m0 *1 341.2,53.5 NMOS
XM$2537 VSS \$I4423 \$I4422 VSS NMOS L=1u W=3.4u AS=6.46p AD=6.12p PS=7.2u PD=7u
* device instance $2538 m0 *1 345.8,53.5 NMOS
XM$2538 \$I4422 WL1 BLB14 VSS NMOS L=1u W=3.4u AS=6.12p AD=9.52p PS=7u PD=12.4u
* device instance $2539 m0 *1 336.4,447.5 PMOS
XM$2539 \$I4425 \$I4424 VDD VDD PMOS L=1u W=3.4u AS=10.88p AD=6.46p PS=13.2u
+ PD=7.2u
* device instance $2540 m0 *1 341.2,447.5 PMOS
XM$2540 VDD \$I4425 \$I4424 VDD PMOS L=1u W=3.4u AS=6.46p AD=10.88p PS=7.2u
+ PD=13.2u
* device instance $2541 m0 *1 331.8,467.9 NMOS
XM$2541 BL14 WL15 \$I4425 VSS NMOS L=1u W=3.4u AS=9.52p AD=6.12p PS=12.4u PD=7u
* device instance $2542 m0 *1 336.4,467.9 NMOS
XM$2542 \$I4425 \$I4424 VSS VSS NMOS L=1u W=3.4u AS=6.12p AD=6.46p PS=7u PD=7.2u
* device instance $2543 m0 *1 341.2,467.9 NMOS
XM$2543 VSS \$I4425 \$I4424 VSS NMOS L=1u W=3.4u AS=6.46p AD=6.12p PS=7.2u PD=7u
* device instance $2544 m0 *1 345.8,467.9 NMOS
XM$2544 \$I4424 WL15 BLB14 VSS NMOS L=1u W=3.4u AS=6.12p AD=9.52p PS=7u PD=12.4u
* device instance $2545 m0 *1 336.4,151.5 PMOS
XM$2545 \$I4427 \$I4426 VDD VDD PMOS L=1u W=3.4u AS=10.88p AD=6.46p PS=13.2u
+ PD=7.2u
* device instance $2546 m0 *1 341.2,151.5 PMOS
XM$2546 VDD \$I4427 \$I4426 VDD PMOS L=1u W=3.4u AS=6.46p AD=10.88p PS=7.2u
+ PD=13.2u
* device instance $2547 m0 *1 331.8,171.9 NMOS
XM$2547 BL14 WL5 \$I4427 VSS NMOS L=1u W=3.4u AS=9.52p AD=6.12p PS=12.4u PD=7u
* device instance $2548 m0 *1 336.4,171.9 NMOS
XM$2548 \$I4427 \$I4426 VSS VSS NMOS L=1u W=3.4u AS=6.12p AD=6.46p PS=7u PD=7.2u
* device instance $2549 m0 *1 341.2,171.9 NMOS
XM$2549 VSS \$I4427 \$I4426 VSS NMOS L=1u W=3.4u AS=6.46p AD=6.12p PS=7.2u PD=7u
* device instance $2550 m0 *1 345.8,171.9 NMOS
XM$2550 \$I4426 WL5 BLB14 VSS NMOS L=1u W=3.4u AS=6.12p AD=9.52p PS=7u PD=12.4u
* device instance $2551 m0 *1 336.4,329.1 PMOS
XM$2551 \$I4429 \$I4428 VDD VDD PMOS L=1u W=3.4u AS=10.88p AD=6.46p PS=13.2u
+ PD=7.2u
* device instance $2552 m0 *1 341.2,329.1 PMOS
XM$2552 VDD \$I4429 \$I4428 VDD PMOS L=1u W=3.4u AS=6.46p AD=10.88p PS=7.2u
+ PD=13.2u
* device instance $2553 m0 *1 331.8,349.5 NMOS
XM$2553 BL14 WL11 \$I4429 VSS NMOS L=1u W=3.4u AS=9.52p AD=6.12p PS=12.4u PD=7u
* device instance $2554 m0 *1 336.4,349.5 NMOS
XM$2554 \$I4429 \$I4428 VSS VSS NMOS L=1u W=3.4u AS=6.12p AD=6.46p PS=7u PD=7.2u
* device instance $2555 m0 *1 341.2,349.5 NMOS
XM$2555 VSS \$I4429 \$I4428 VSS NMOS L=1u W=3.4u AS=6.46p AD=6.12p PS=7.2u PD=7u
* device instance $2556 m0 *1 345.8,349.5 NMOS
XM$2556 \$I4428 WL11 BLB14 VSS NMOS L=1u W=3.4u AS=6.12p AD=9.52p PS=7u PD=12.4u
* device instance $2557 m0 *1 336.4,388.3 PMOS
XM$2557 \$I4431 \$I4430 VDD VDD PMOS L=1u W=3.4u AS=10.88p AD=6.46p PS=13.2u
+ PD=7.2u
* device instance $2558 m0 *1 341.2,388.3 PMOS
XM$2558 VDD \$I4431 \$I4430 VDD PMOS L=1u W=3.4u AS=6.46p AD=10.88p PS=7.2u
+ PD=13.2u
* device instance $2559 m0 *1 331.8,408.7 NMOS
XM$2559 BL14 WL13 \$I4431 VSS NMOS L=1u W=3.4u AS=9.52p AD=6.12p PS=12.4u PD=7u
* device instance $2560 m0 *1 336.4,408.7 NMOS
XM$2560 \$I4431 \$I4430 VSS VSS NMOS L=1u W=3.4u AS=6.12p AD=6.46p PS=7u PD=7.2u
* device instance $2561 m0 *1 341.2,408.7 NMOS
XM$2561 VSS \$I4431 \$I4430 VSS NMOS L=1u W=3.4u AS=6.46p AD=6.12p PS=7.2u PD=7u
* device instance $2562 m0 *1 345.8,408.7 NMOS
XM$2562 \$I4430 WL13 BLB14 VSS NMOS L=1u W=3.4u AS=6.12p AD=9.52p PS=7u PD=12.4u
* device instance $2563 m0 *1 336.4,210.7 PMOS
XM$2563 \$I4433 \$I4432 VDD VDD PMOS L=1u W=3.4u AS=10.88p AD=6.46p PS=13.2u
+ PD=7.2u
* device instance $2564 m0 *1 341.2,210.7 PMOS
XM$2564 VDD \$I4433 \$I4432 VDD PMOS L=1u W=3.4u AS=6.46p AD=10.88p PS=7.2u
+ PD=13.2u
* device instance $2565 m0 *1 331.8,231.1 NMOS
XM$2565 BL14 WL7 \$I4433 VSS NMOS L=1u W=3.4u AS=9.52p AD=6.12p PS=12.4u PD=7u
* device instance $2566 m0 *1 336.4,231.1 NMOS
XM$2566 \$I4433 \$I4432 VSS VSS NMOS L=1u W=3.4u AS=6.12p AD=6.46p PS=7u PD=7.2u
* device instance $2567 m0 *1 341.2,231.1 NMOS
XM$2567 VSS \$I4433 \$I4432 VSS NMOS L=1u W=3.4u AS=6.46p AD=6.12p PS=7.2u PD=7u
* device instance $2568 m0 *1 345.8,231.1 NMOS
XM$2568 \$I4432 WL7 BLB14 VSS NMOS L=1u W=3.4u AS=6.12p AD=9.52p PS=7u PD=12.4u
* device instance $2569 m0 *1 336.4,269.9 PMOS
XM$2569 \$I4435 \$I4434 VDD VDD PMOS L=1u W=3.4u AS=10.88p AD=6.46p PS=13.2u
+ PD=7.2u
* device instance $2570 m0 *1 341.2,269.9 PMOS
XM$2570 VDD \$I4435 \$I4434 VDD PMOS L=1u W=3.4u AS=6.46p AD=10.88p PS=7.2u
+ PD=13.2u
* device instance $2571 m0 *1 331.8,290.3 NMOS
XM$2571 BL14 WL9 \$I4435 VSS NMOS L=1u W=3.4u AS=9.52p AD=6.12p PS=12.4u PD=7u
* device instance $2572 m0 *1 336.4,290.3 NMOS
XM$2572 \$I4435 \$I4434 VSS VSS NMOS L=1u W=3.4u AS=6.12p AD=6.46p PS=7u PD=7.2u
* device instance $2573 m0 *1 341.2,290.3 NMOS
XM$2573 VSS \$I4435 \$I4434 VSS NMOS L=1u W=3.4u AS=6.46p AD=6.12p PS=7.2u PD=7u
* device instance $2574 m0 *1 345.8,290.3 NMOS
XM$2574 \$I4434 WL9 BLB14 VSS NMOS L=1u W=3.4u AS=6.12p AD=9.52p PS=7u PD=12.4u
* device instance $2575 m0 *1 336.4,92.3 PMOS
XM$2575 \$I4437 \$I4436 VDD VDD PMOS L=1u W=3.4u AS=10.88p AD=6.46p PS=13.2u
+ PD=7.2u
* device instance $2576 m0 *1 341.2,92.3 PMOS
XM$2576 VDD \$I4437 \$I4436 VDD PMOS L=1u W=3.4u AS=6.46p AD=10.88p PS=7.2u
+ PD=13.2u
* device instance $2577 m0 *1 331.8,112.7 NMOS
XM$2577 BL14 WL3 \$I4437 VSS NMOS L=1u W=3.4u AS=9.52p AD=6.12p PS=12.4u PD=7u
* device instance $2578 m0 *1 336.4,112.7 NMOS
XM$2578 \$I4437 \$I4436 VSS VSS NMOS L=1u W=3.4u AS=6.12p AD=6.46p PS=7u PD=7.2u
* device instance $2579 m0 *1 341.2,112.7 NMOS
XM$2579 VSS \$I4437 \$I4436 VSS NMOS L=1u W=3.4u AS=6.46p AD=6.12p PS=7.2u PD=7u
* device instance $2580 m0 *1 345.8,112.7 NMOS
XM$2580 \$I4436 WL3 BLB14 VSS NMOS L=1u W=3.4u AS=6.12p AD=9.52p PS=7u PD=12.4u
* device instance $2581 r0 *1 336.4,440.5 PMOS
XM$2581 \$I4439 \$I4438 VDD VDD PMOS L=1u W=3.4u AS=10.88p AD=6.46p PS=13.2u
+ PD=7.2u
* device instance $2582 r0 *1 341.2,440.5 PMOS
XM$2582 VDD \$I4439 \$I4438 VDD PMOS L=1u W=3.4u AS=6.46p AD=10.88p PS=7.2u
+ PD=13.2u
* device instance $2583 r0 *1 331.8,420.1 NMOS
XM$2583 BL14 WL14 \$I4439 VSS NMOS L=1u W=3.4u AS=9.52p AD=6.12p PS=12.4u PD=7u
* device instance $2584 r0 *1 336.4,420.1 NMOS
XM$2584 \$I4439 \$I4438 VSS VSS NMOS L=1u W=3.4u AS=6.12p AD=6.46p PS=7u PD=7.2u
* device instance $2585 r0 *1 341.2,420.1 NMOS
XM$2585 VSS \$I4439 \$I4438 VSS NMOS L=1u W=3.4u AS=6.46p AD=6.12p PS=7.2u PD=7u
* device instance $2586 r0 *1 345.8,420.1 NMOS
XM$2586 \$I4438 WL14 BLB14 VSS NMOS L=1u W=3.4u AS=6.12p AD=9.52p PS=7u PD=12.4u
* device instance $2587 r0 *1 336.4,381.3 PMOS
XM$2587 \$I4441 \$I4440 VDD VDD PMOS L=1u W=3.4u AS=10.88p AD=6.46p PS=13.2u
+ PD=7.2u
* device instance $2588 r0 *1 341.2,381.3 PMOS
XM$2588 VDD \$I4441 \$I4440 VDD PMOS L=1u W=3.4u AS=6.46p AD=10.88p PS=7.2u
+ PD=13.2u
* device instance $2589 r0 *1 331.8,360.9 NMOS
XM$2589 BL14 WL12 \$I4441 VSS NMOS L=1u W=3.4u AS=9.52p AD=6.12p PS=12.4u PD=7u
* device instance $2590 r0 *1 336.4,360.9 NMOS
XM$2590 \$I4441 \$I4440 VSS VSS NMOS L=1u W=3.4u AS=6.12p AD=6.46p PS=7u PD=7.2u
* device instance $2591 r0 *1 341.2,360.9 NMOS
XM$2591 VSS \$I4441 \$I4440 VSS NMOS L=1u W=3.4u AS=6.46p AD=6.12p PS=7.2u PD=7u
* device instance $2592 r0 *1 345.8,360.9 NMOS
XM$2592 \$I4440 WL12 BLB14 VSS NMOS L=1u W=3.4u AS=6.12p AD=9.52p PS=7u PD=12.4u
* device instance $2593 r0 *1 336.4,85.3 PMOS
XM$2593 \$I4443 \$I4442 VDD VDD PMOS L=1u W=3.4u AS=10.88p AD=6.46p PS=13.2u
+ PD=7.2u
* device instance $2594 r0 *1 341.2,85.3 PMOS
XM$2594 VDD \$I4443 \$I4442 VDD PMOS L=1u W=3.4u AS=6.46p AD=10.88p PS=7.2u
+ PD=13.2u
* device instance $2595 r0 *1 331.8,64.9 NMOS
XM$2595 BL14 WL2 \$I4443 VSS NMOS L=1u W=3.4u AS=9.52p AD=6.12p PS=12.4u PD=7u
* device instance $2596 r0 *1 336.4,64.9 NMOS
XM$2596 \$I4443 \$I4442 VSS VSS NMOS L=1u W=3.4u AS=6.12p AD=6.46p PS=7u PD=7.2u
* device instance $2597 r0 *1 341.2,64.9 NMOS
XM$2597 VSS \$I4443 \$I4442 VSS NMOS L=1u W=3.4u AS=6.46p AD=6.12p PS=7.2u PD=7u
* device instance $2598 r0 *1 345.8,64.9 NMOS
XM$2598 \$I4442 WL2 BLB14 VSS NMOS L=1u W=3.4u AS=6.12p AD=9.52p PS=7u PD=12.4u
* device instance $2599 r0 *1 336.4,262.9 PMOS
XM$2599 \$I4445 \$I4444 VDD VDD PMOS L=1u W=3.4u AS=10.88p AD=6.46p PS=13.2u
+ PD=7.2u
* device instance $2600 r0 *1 341.2,262.9 PMOS
XM$2600 VDD \$I4445 \$I4444 VDD PMOS L=1u W=3.4u AS=6.46p AD=10.88p PS=7.2u
+ PD=13.2u
* device instance $2601 r0 *1 331.8,242.5 NMOS
XM$2601 BL14 WL8 \$I4445 VSS NMOS L=1u W=3.4u AS=9.52p AD=6.12p PS=12.4u PD=7u
* device instance $2602 r0 *1 336.4,242.5 NMOS
XM$2602 \$I4445 \$I4444 VSS VSS NMOS L=1u W=3.4u AS=6.12p AD=6.46p PS=7u PD=7.2u
* device instance $2603 r0 *1 341.2,242.5 NMOS
XM$2603 VSS \$I4445 \$I4444 VSS NMOS L=1u W=3.4u AS=6.46p AD=6.12p PS=7.2u PD=7u
* device instance $2604 r0 *1 345.8,242.5 NMOS
XM$2604 \$I4444 WL8 BLB14 VSS NMOS L=1u W=3.4u AS=6.12p AD=9.52p PS=7u PD=12.4u
* device instance $2605 r0 *1 336.4,322.1 PMOS
XM$2605 \$I4447 \$I4446 VDD VDD PMOS L=1u W=3.4u AS=10.88p AD=6.46p PS=13.2u
+ PD=7.2u
* device instance $2606 r0 *1 341.2,322.1 PMOS
XM$2606 VDD \$I4447 \$I4446 VDD PMOS L=1u W=3.4u AS=6.46p AD=10.88p PS=7.2u
+ PD=13.2u
* device instance $2607 r0 *1 331.8,301.7 NMOS
XM$2607 BL14 WL10 \$I4447 VSS NMOS L=1u W=3.4u AS=9.52p AD=6.12p PS=12.4u PD=7u
* device instance $2608 r0 *1 336.4,301.7 NMOS
XM$2608 \$I4447 \$I4446 VSS VSS NMOS L=1u W=3.4u AS=6.12p AD=6.46p PS=7u PD=7.2u
* device instance $2609 r0 *1 341.2,301.7 NMOS
XM$2609 VSS \$I4447 \$I4446 VSS NMOS L=1u W=3.4u AS=6.46p AD=6.12p PS=7.2u PD=7u
* device instance $2610 r0 *1 345.8,301.7 NMOS
XM$2610 \$I4446 WL10 BLB14 VSS NMOS L=1u W=3.4u AS=6.12p AD=9.52p PS=7u PD=12.4u
* device instance $2611 r0 *1 336.4,144.5 PMOS
XM$2611 \$I4449 \$I4448 VDD VDD PMOS L=1u W=3.4u AS=10.88p AD=6.46p PS=13.2u
+ PD=7.2u
* device instance $2612 r0 *1 341.2,144.5 PMOS
XM$2612 VDD \$I4449 \$I4448 VDD PMOS L=1u W=3.4u AS=6.46p AD=10.88p PS=7.2u
+ PD=13.2u
* device instance $2613 r0 *1 331.8,124.1 NMOS
XM$2613 BL14 WL4 \$I4449 VSS NMOS L=1u W=3.4u AS=9.52p AD=6.12p PS=12.4u PD=7u
* device instance $2614 r0 *1 336.4,124.1 NMOS
XM$2614 \$I4449 \$I4448 VSS VSS NMOS L=1u W=3.4u AS=6.12p AD=6.46p PS=7u PD=7.2u
* device instance $2615 r0 *1 341.2,124.1 NMOS
XM$2615 VSS \$I4449 \$I4448 VSS NMOS L=1u W=3.4u AS=6.46p AD=6.12p PS=7.2u PD=7u
* device instance $2616 r0 *1 345.8,124.1 NMOS
XM$2616 \$I4448 WL4 BLB14 VSS NMOS L=1u W=3.4u AS=6.12p AD=9.52p PS=7u PD=12.4u
* device instance $2617 r0 *1 336.4,203.7 PMOS
XM$2617 \$I4451 \$I4450 VDD VDD PMOS L=1u W=3.4u AS=10.88p AD=6.46p PS=13.2u
+ PD=7.2u
* device instance $2618 r0 *1 341.2,203.7 PMOS
XM$2618 VDD \$I4451 \$I4450 VDD PMOS L=1u W=3.4u AS=6.46p AD=10.88p PS=7.2u
+ PD=13.2u
* device instance $2619 r0 *1 331.8,183.3 NMOS
XM$2619 BL14 WL6 \$I4451 VSS NMOS L=1u W=3.4u AS=9.52p AD=6.12p PS=12.4u PD=7u
* device instance $2620 r0 *1 336.4,183.3 NMOS
XM$2620 \$I4451 \$I4450 VSS VSS NMOS L=1u W=3.4u AS=6.12p AD=6.46p PS=7u PD=7.2u
* device instance $2621 r0 *1 341.2,183.3 NMOS
XM$2621 VSS \$I4451 \$I4450 VSS NMOS L=1u W=3.4u AS=6.46p AD=6.12p PS=7.2u PD=7u
* device instance $2622 r0 *1 345.8,183.3 NMOS
XM$2622 \$I4450 WL6 BLB14 VSS NMOS L=1u W=3.4u AS=6.12p AD=9.52p PS=7u PD=12.4u
* device instance $2623 m0 *1 314.4,33.1 PMOS
XM$2623 \$I4453 \$I4452 VDD VDD PMOS L=1u W=3.4u AS=10.88p AD=6.46p PS=13.2u
+ PD=7.2u
* device instance $2624 m0 *1 319.2,33.1 PMOS
XM$2624 VDD \$I4453 \$I4452 VDD PMOS L=1u W=3.4u AS=6.46p AD=10.88p PS=7.2u
+ PD=13.2u
* device instance $2625 m0 *1 309.8,53.5 NMOS
XM$2625 BL13 WL1 \$I4453 VSS NMOS L=1u W=3.4u AS=9.52p AD=6.12p PS=12.4u PD=7u
* device instance $2626 m0 *1 314.4,53.5 NMOS
XM$2626 \$I4453 \$I4452 VSS VSS NMOS L=1u W=3.4u AS=6.12p AD=6.46p PS=7u PD=7.2u
* device instance $2627 m0 *1 319.2,53.5 NMOS
XM$2627 VSS \$I4453 \$I4452 VSS NMOS L=1u W=3.4u AS=6.46p AD=6.12p PS=7.2u PD=7u
* device instance $2628 m0 *1 323.8,53.5 NMOS
XM$2628 \$I4452 WL1 BLB13 VSS NMOS L=1u W=3.4u AS=6.12p AD=9.52p PS=7u PD=12.4u
* device instance $2629 m0 *1 314.4,447.5 PMOS
XM$2629 \$I4455 \$I4454 VDD VDD PMOS L=1u W=3.4u AS=10.88p AD=6.46p PS=13.2u
+ PD=7.2u
* device instance $2630 m0 *1 319.2,447.5 PMOS
XM$2630 VDD \$I4455 \$I4454 VDD PMOS L=1u W=3.4u AS=6.46p AD=10.88p PS=7.2u
+ PD=13.2u
* device instance $2631 m0 *1 309.8,467.9 NMOS
XM$2631 BL13 WL15 \$I4455 VSS NMOS L=1u W=3.4u AS=9.52p AD=6.12p PS=12.4u PD=7u
* device instance $2632 m0 *1 314.4,467.9 NMOS
XM$2632 \$I4455 \$I4454 VSS VSS NMOS L=1u W=3.4u AS=6.12p AD=6.46p PS=7u PD=7.2u
* device instance $2633 m0 *1 319.2,467.9 NMOS
XM$2633 VSS \$I4455 \$I4454 VSS NMOS L=1u W=3.4u AS=6.46p AD=6.12p PS=7.2u PD=7u
* device instance $2634 m0 *1 323.8,467.9 NMOS
XM$2634 \$I4454 WL15 BLB13 VSS NMOS L=1u W=3.4u AS=6.12p AD=9.52p PS=7u PD=12.4u
* device instance $2635 m0 *1 314.4,151.5 PMOS
XM$2635 \$I4457 \$I4456 VDD VDD PMOS L=1u W=3.4u AS=10.88p AD=6.46p PS=13.2u
+ PD=7.2u
* device instance $2636 m0 *1 319.2,151.5 PMOS
XM$2636 VDD \$I4457 \$I4456 VDD PMOS L=1u W=3.4u AS=6.46p AD=10.88p PS=7.2u
+ PD=13.2u
* device instance $2637 m0 *1 309.8,171.9 NMOS
XM$2637 BL13 WL5 \$I4457 VSS NMOS L=1u W=3.4u AS=9.52p AD=6.12p PS=12.4u PD=7u
* device instance $2638 m0 *1 314.4,171.9 NMOS
XM$2638 \$I4457 \$I4456 VSS VSS NMOS L=1u W=3.4u AS=6.12p AD=6.46p PS=7u PD=7.2u
* device instance $2639 m0 *1 319.2,171.9 NMOS
XM$2639 VSS \$I4457 \$I4456 VSS NMOS L=1u W=3.4u AS=6.46p AD=6.12p PS=7.2u PD=7u
* device instance $2640 m0 *1 323.8,171.9 NMOS
XM$2640 \$I4456 WL5 BLB13 VSS NMOS L=1u W=3.4u AS=6.12p AD=9.52p PS=7u PD=12.4u
* device instance $2641 m0 *1 314.4,329.1 PMOS
XM$2641 \$I4459 \$I4458 VDD VDD PMOS L=1u W=3.4u AS=10.88p AD=6.46p PS=13.2u
+ PD=7.2u
* device instance $2642 m0 *1 319.2,329.1 PMOS
XM$2642 VDD \$I4459 \$I4458 VDD PMOS L=1u W=3.4u AS=6.46p AD=10.88p PS=7.2u
+ PD=13.2u
* device instance $2643 m0 *1 309.8,349.5 NMOS
XM$2643 BL13 WL11 \$I4459 VSS NMOS L=1u W=3.4u AS=9.52p AD=6.12p PS=12.4u PD=7u
* device instance $2644 m0 *1 314.4,349.5 NMOS
XM$2644 \$I4459 \$I4458 VSS VSS NMOS L=1u W=3.4u AS=6.12p AD=6.46p PS=7u PD=7.2u
* device instance $2645 m0 *1 319.2,349.5 NMOS
XM$2645 VSS \$I4459 \$I4458 VSS NMOS L=1u W=3.4u AS=6.46p AD=6.12p PS=7.2u PD=7u
* device instance $2646 m0 *1 323.8,349.5 NMOS
XM$2646 \$I4458 WL11 BLB13 VSS NMOS L=1u W=3.4u AS=6.12p AD=9.52p PS=7u PD=12.4u
* device instance $2647 m0 *1 314.4,388.3 PMOS
XM$2647 \$I4461 \$I4460 VDD VDD PMOS L=1u W=3.4u AS=10.88p AD=6.46p PS=13.2u
+ PD=7.2u
* device instance $2648 m0 *1 319.2,388.3 PMOS
XM$2648 VDD \$I4461 \$I4460 VDD PMOS L=1u W=3.4u AS=6.46p AD=10.88p PS=7.2u
+ PD=13.2u
* device instance $2649 m0 *1 309.8,408.7 NMOS
XM$2649 BL13 WL13 \$I4461 VSS NMOS L=1u W=3.4u AS=9.52p AD=6.12p PS=12.4u PD=7u
* device instance $2650 m0 *1 314.4,408.7 NMOS
XM$2650 \$I4461 \$I4460 VSS VSS NMOS L=1u W=3.4u AS=6.12p AD=6.46p PS=7u PD=7.2u
* device instance $2651 m0 *1 319.2,408.7 NMOS
XM$2651 VSS \$I4461 \$I4460 VSS NMOS L=1u W=3.4u AS=6.46p AD=6.12p PS=7.2u PD=7u
* device instance $2652 m0 *1 323.8,408.7 NMOS
XM$2652 \$I4460 WL13 BLB13 VSS NMOS L=1u W=3.4u AS=6.12p AD=9.52p PS=7u PD=12.4u
* device instance $2653 m0 *1 314.4,269.9 PMOS
XM$2653 \$I4463 \$I4462 VDD VDD PMOS L=1u W=3.4u AS=10.88p AD=6.46p PS=13.2u
+ PD=7.2u
* device instance $2654 m0 *1 319.2,269.9 PMOS
XM$2654 VDD \$I4463 \$I4462 VDD PMOS L=1u W=3.4u AS=6.46p AD=10.88p PS=7.2u
+ PD=13.2u
* device instance $2655 m0 *1 309.8,290.3 NMOS
XM$2655 BL13 WL9 \$I4463 VSS NMOS L=1u W=3.4u AS=9.52p AD=6.12p PS=12.4u PD=7u
* device instance $2656 m0 *1 314.4,290.3 NMOS
XM$2656 \$I4463 \$I4462 VSS VSS NMOS L=1u W=3.4u AS=6.12p AD=6.46p PS=7u PD=7.2u
* device instance $2657 m0 *1 319.2,290.3 NMOS
XM$2657 VSS \$I4463 \$I4462 VSS NMOS L=1u W=3.4u AS=6.46p AD=6.12p PS=7.2u PD=7u
* device instance $2658 m0 *1 323.8,290.3 NMOS
XM$2658 \$I4462 WL9 BLB13 VSS NMOS L=1u W=3.4u AS=6.12p AD=9.52p PS=7u PD=12.4u
* device instance $2659 m0 *1 314.4,210.7 PMOS
XM$2659 \$I4465 \$I4464 VDD VDD PMOS L=1u W=3.4u AS=10.88p AD=6.46p PS=13.2u
+ PD=7.2u
* device instance $2660 m0 *1 319.2,210.7 PMOS
XM$2660 VDD \$I4465 \$I4464 VDD PMOS L=1u W=3.4u AS=6.46p AD=10.88p PS=7.2u
+ PD=13.2u
* device instance $2661 m0 *1 309.8,231.1 NMOS
XM$2661 BL13 WL7 \$I4465 VSS NMOS L=1u W=3.4u AS=9.52p AD=6.12p PS=12.4u PD=7u
* device instance $2662 m0 *1 314.4,231.1 NMOS
XM$2662 \$I4465 \$I4464 VSS VSS NMOS L=1u W=3.4u AS=6.12p AD=6.46p PS=7u PD=7.2u
* device instance $2663 m0 *1 319.2,231.1 NMOS
XM$2663 VSS \$I4465 \$I4464 VSS NMOS L=1u W=3.4u AS=6.46p AD=6.12p PS=7.2u PD=7u
* device instance $2664 m0 *1 323.8,231.1 NMOS
XM$2664 \$I4464 WL7 BLB13 VSS NMOS L=1u W=3.4u AS=6.12p AD=9.52p PS=7u PD=12.4u
* device instance $2665 m0 *1 314.4,92.3 PMOS
XM$2665 \$I4467 \$I4466 VDD VDD PMOS L=1u W=3.4u AS=10.88p AD=6.46p PS=13.2u
+ PD=7.2u
* device instance $2666 m0 *1 319.2,92.3 PMOS
XM$2666 VDD \$I4467 \$I4466 VDD PMOS L=1u W=3.4u AS=6.46p AD=10.88p PS=7.2u
+ PD=13.2u
* device instance $2667 m0 *1 309.8,112.7 NMOS
XM$2667 BL13 WL3 \$I4467 VSS NMOS L=1u W=3.4u AS=9.52p AD=6.12p PS=12.4u PD=7u
* device instance $2668 m0 *1 314.4,112.7 NMOS
XM$2668 \$I4467 \$I4466 VSS VSS NMOS L=1u W=3.4u AS=6.12p AD=6.46p PS=7u PD=7.2u
* device instance $2669 m0 *1 319.2,112.7 NMOS
XM$2669 VSS \$I4467 \$I4466 VSS NMOS L=1u W=3.4u AS=6.46p AD=6.12p PS=7.2u PD=7u
* device instance $2670 m0 *1 323.8,112.7 NMOS
XM$2670 \$I4466 WL3 BLB13 VSS NMOS L=1u W=3.4u AS=6.12p AD=9.52p PS=7u PD=12.4u
* device instance $2671 r0 *1 314.4,440.5 PMOS
XM$2671 \$I4469 \$I4468 VDD VDD PMOS L=1u W=3.4u AS=10.88p AD=6.46p PS=13.2u
+ PD=7.2u
* device instance $2672 r0 *1 319.2,440.5 PMOS
XM$2672 VDD \$I4469 \$I4468 VDD PMOS L=1u W=3.4u AS=6.46p AD=10.88p PS=7.2u
+ PD=13.2u
* device instance $2673 r0 *1 309.8,420.1 NMOS
XM$2673 BL13 WL14 \$I4469 VSS NMOS L=1u W=3.4u AS=9.52p AD=6.12p PS=12.4u PD=7u
* device instance $2674 r0 *1 314.4,420.1 NMOS
XM$2674 \$I4469 \$I4468 VSS VSS NMOS L=1u W=3.4u AS=6.12p AD=6.46p PS=7u PD=7.2u
* device instance $2675 r0 *1 319.2,420.1 NMOS
XM$2675 VSS \$I4469 \$I4468 VSS NMOS L=1u W=3.4u AS=6.46p AD=6.12p PS=7.2u PD=7u
* device instance $2676 r0 *1 323.8,420.1 NMOS
XM$2676 \$I4468 WL14 BLB13 VSS NMOS L=1u W=3.4u AS=6.12p AD=9.52p PS=7u PD=12.4u
* device instance $2677 r0 *1 314.4,381.3 PMOS
XM$2677 \$I4471 \$I4470 VDD VDD PMOS L=1u W=3.4u AS=10.88p AD=6.46p PS=13.2u
+ PD=7.2u
* device instance $2678 r0 *1 319.2,381.3 PMOS
XM$2678 VDD \$I4471 \$I4470 VDD PMOS L=1u W=3.4u AS=6.46p AD=10.88p PS=7.2u
+ PD=13.2u
* device instance $2679 r0 *1 309.8,360.9 NMOS
XM$2679 BL13 WL12 \$I4471 VSS NMOS L=1u W=3.4u AS=9.52p AD=6.12p PS=12.4u PD=7u
* device instance $2680 r0 *1 314.4,360.9 NMOS
XM$2680 \$I4471 \$I4470 VSS VSS NMOS L=1u W=3.4u AS=6.12p AD=6.46p PS=7u PD=7.2u
* device instance $2681 r0 *1 319.2,360.9 NMOS
XM$2681 VSS \$I4471 \$I4470 VSS NMOS L=1u W=3.4u AS=6.46p AD=6.12p PS=7.2u PD=7u
* device instance $2682 r0 *1 323.8,360.9 NMOS
XM$2682 \$I4470 WL12 BLB13 VSS NMOS L=1u W=3.4u AS=6.12p AD=9.52p PS=7u PD=12.4u
* device instance $2683 r0 *1 314.4,85.3 PMOS
XM$2683 \$I4473 \$I4472 VDD VDD PMOS L=1u W=3.4u AS=10.88p AD=6.46p PS=13.2u
+ PD=7.2u
* device instance $2684 r0 *1 319.2,85.3 PMOS
XM$2684 VDD \$I4473 \$I4472 VDD PMOS L=1u W=3.4u AS=6.46p AD=10.88p PS=7.2u
+ PD=13.2u
* device instance $2685 r0 *1 309.8,64.9 NMOS
XM$2685 BL13 WL2 \$I4473 VSS NMOS L=1u W=3.4u AS=9.52p AD=6.12p PS=12.4u PD=7u
* device instance $2686 r0 *1 314.4,64.9 NMOS
XM$2686 \$I4473 \$I4472 VSS VSS NMOS L=1u W=3.4u AS=6.12p AD=6.46p PS=7u PD=7.2u
* device instance $2687 r0 *1 319.2,64.9 NMOS
XM$2687 VSS \$I4473 \$I4472 VSS NMOS L=1u W=3.4u AS=6.46p AD=6.12p PS=7.2u PD=7u
* device instance $2688 r0 *1 323.8,64.9 NMOS
XM$2688 \$I4472 WL2 BLB13 VSS NMOS L=1u W=3.4u AS=6.12p AD=9.52p PS=7u PD=12.4u
* device instance $2689 r0 *1 314.4,322.1 PMOS
XM$2689 \$I4475 \$I4474 VDD VDD PMOS L=1u W=3.4u AS=10.88p AD=6.46p PS=13.2u
+ PD=7.2u
* device instance $2690 r0 *1 319.2,322.1 PMOS
XM$2690 VDD \$I4475 \$I4474 VDD PMOS L=1u W=3.4u AS=6.46p AD=10.88p PS=7.2u
+ PD=13.2u
* device instance $2691 r0 *1 309.8,301.7 NMOS
XM$2691 BL13 WL10 \$I4475 VSS NMOS L=1u W=3.4u AS=9.52p AD=6.12p PS=12.4u PD=7u
* device instance $2692 r0 *1 314.4,301.7 NMOS
XM$2692 \$I4475 \$I4474 VSS VSS NMOS L=1u W=3.4u AS=6.12p AD=6.46p PS=7u PD=7.2u
* device instance $2693 r0 *1 319.2,301.7 NMOS
XM$2693 VSS \$I4475 \$I4474 VSS NMOS L=1u W=3.4u AS=6.46p AD=6.12p PS=7.2u PD=7u
* device instance $2694 r0 *1 323.8,301.7 NMOS
XM$2694 \$I4474 WL10 BLB13 VSS NMOS L=1u W=3.4u AS=6.12p AD=9.52p PS=7u PD=12.4u
* device instance $2695 r0 *1 314.4,262.9 PMOS
XM$2695 \$I4477 \$I4476 VDD VDD PMOS L=1u W=3.4u AS=10.88p AD=6.46p PS=13.2u
+ PD=7.2u
* device instance $2696 r0 *1 319.2,262.9 PMOS
XM$2696 VDD \$I4477 \$I4476 VDD PMOS L=1u W=3.4u AS=6.46p AD=10.88p PS=7.2u
+ PD=13.2u
* device instance $2697 r0 *1 309.8,242.5 NMOS
XM$2697 BL13 WL8 \$I4477 VSS NMOS L=1u W=3.4u AS=9.52p AD=6.12p PS=12.4u PD=7u
* device instance $2698 r0 *1 314.4,242.5 NMOS
XM$2698 \$I4477 \$I4476 VSS VSS NMOS L=1u W=3.4u AS=6.12p AD=6.46p PS=7u PD=7.2u
* device instance $2699 r0 *1 319.2,242.5 NMOS
XM$2699 VSS \$I4477 \$I4476 VSS NMOS L=1u W=3.4u AS=6.46p AD=6.12p PS=7.2u PD=7u
* device instance $2700 r0 *1 323.8,242.5 NMOS
XM$2700 \$I4476 WL8 BLB13 VSS NMOS L=1u W=3.4u AS=6.12p AD=9.52p PS=7u PD=12.4u
* device instance $2701 r0 *1 314.4,144.5 PMOS
XM$2701 \$I4479 \$I4478 VDD VDD PMOS L=1u W=3.4u AS=10.88p AD=6.46p PS=13.2u
+ PD=7.2u
* device instance $2702 r0 *1 319.2,144.5 PMOS
XM$2702 VDD \$I4479 \$I4478 VDD PMOS L=1u W=3.4u AS=6.46p AD=10.88p PS=7.2u
+ PD=13.2u
* device instance $2703 r0 *1 309.8,124.1 NMOS
XM$2703 BL13 WL4 \$I4479 VSS NMOS L=1u W=3.4u AS=9.52p AD=6.12p PS=12.4u PD=7u
* device instance $2704 r0 *1 314.4,124.1 NMOS
XM$2704 \$I4479 \$I4478 VSS VSS NMOS L=1u W=3.4u AS=6.12p AD=6.46p PS=7u PD=7.2u
* device instance $2705 r0 *1 319.2,124.1 NMOS
XM$2705 VSS \$I4479 \$I4478 VSS NMOS L=1u W=3.4u AS=6.46p AD=6.12p PS=7.2u PD=7u
* device instance $2706 r0 *1 323.8,124.1 NMOS
XM$2706 \$I4478 WL4 BLB13 VSS NMOS L=1u W=3.4u AS=6.12p AD=9.52p PS=7u PD=12.4u
* device instance $2707 r0 *1 314.4,203.7 PMOS
XM$2707 \$I4481 \$I4480 VDD VDD PMOS L=1u W=3.4u AS=10.88p AD=6.46p PS=13.2u
+ PD=7.2u
* device instance $2708 r0 *1 319.2,203.7 PMOS
XM$2708 VDD \$I4481 \$I4480 VDD PMOS L=1u W=3.4u AS=6.46p AD=10.88p PS=7.2u
+ PD=13.2u
* device instance $2709 r0 *1 309.8,183.3 NMOS
XM$2709 BL13 WL6 \$I4481 VSS NMOS L=1u W=3.4u AS=9.52p AD=6.12p PS=12.4u PD=7u
* device instance $2710 r0 *1 314.4,183.3 NMOS
XM$2710 \$I4481 \$I4480 VSS VSS NMOS L=1u W=3.4u AS=6.12p AD=6.46p PS=7u PD=7.2u
* device instance $2711 r0 *1 319.2,183.3 NMOS
XM$2711 VSS \$I4481 \$I4480 VSS NMOS L=1u W=3.4u AS=6.46p AD=6.12p PS=7.2u PD=7u
* device instance $2712 r0 *1 323.8,183.3 NMOS
XM$2712 \$I4480 WL6 BLB13 VSS NMOS L=1u W=3.4u AS=6.12p AD=9.52p PS=7u PD=12.4u
* device instance $2713 m0 *1 292.4,92.3 PMOS
XM$2713 \$I4483 \$I4482 VDD VDD PMOS L=1u W=3.4u AS=10.88p AD=6.46p PS=13.2u
+ PD=7.2u
* device instance $2714 m0 *1 297.2,92.3 PMOS
XM$2714 VDD \$I4483 \$I4482 VDD PMOS L=1u W=3.4u AS=6.46p AD=10.88p PS=7.2u
+ PD=13.2u
* device instance $2715 m0 *1 287.8,112.7 NMOS
XM$2715 BL12 WL3 \$I4483 VSS NMOS L=1u W=3.4u AS=9.52p AD=6.12p PS=12.4u PD=7u
* device instance $2716 m0 *1 292.4,112.7 NMOS
XM$2716 \$I4483 \$I4482 VSS VSS NMOS L=1u W=3.4u AS=6.12p AD=6.46p PS=7u PD=7.2u
* device instance $2717 m0 *1 297.2,112.7 NMOS
XM$2717 VSS \$I4483 \$I4482 VSS NMOS L=1u W=3.4u AS=6.46p AD=6.12p PS=7.2u PD=7u
* device instance $2718 m0 *1 301.8,112.7 NMOS
XM$2718 \$I4482 WL3 BLB12 VSS NMOS L=1u W=3.4u AS=6.12p AD=9.52p PS=7u PD=12.4u
* device instance $2719 m0 *1 292.4,33.1 PMOS
XM$2719 \$I4485 \$I4484 VDD VDD PMOS L=1u W=3.4u AS=10.88p AD=6.46p PS=13.2u
+ PD=7.2u
* device instance $2720 m0 *1 297.2,33.1 PMOS
XM$2720 VDD \$I4485 \$I4484 VDD PMOS L=1u W=3.4u AS=6.46p AD=10.88p PS=7.2u
+ PD=13.2u
* device instance $2721 m0 *1 287.8,53.5 NMOS
XM$2721 BL12 WL1 \$I4485 VSS NMOS L=1u W=3.4u AS=9.52p AD=6.12p PS=12.4u PD=7u
* device instance $2722 m0 *1 292.4,53.5 NMOS
XM$2722 \$I4485 \$I4484 VSS VSS NMOS L=1u W=3.4u AS=6.12p AD=6.46p PS=7u PD=7.2u
* device instance $2723 m0 *1 297.2,53.5 NMOS
XM$2723 VSS \$I4485 \$I4484 VSS NMOS L=1u W=3.4u AS=6.46p AD=6.12p PS=7.2u PD=7u
* device instance $2724 m0 *1 301.8,53.5 NMOS
XM$2724 \$I4484 WL1 BLB12 VSS NMOS L=1u W=3.4u AS=6.12p AD=9.52p PS=7u PD=12.4u
* device instance $2725 m0 *1 292.4,447.5 PMOS
XM$2725 \$I4487 \$I4486 VDD VDD PMOS L=1u W=3.4u AS=10.88p AD=6.46p PS=13.2u
+ PD=7.2u
* device instance $2726 m0 *1 297.2,447.5 PMOS
XM$2726 VDD \$I4487 \$I4486 VDD PMOS L=1u W=3.4u AS=6.46p AD=10.88p PS=7.2u
+ PD=13.2u
* device instance $2727 m0 *1 287.8,467.9 NMOS
XM$2727 BL12 WL15 \$I4487 VSS NMOS L=1u W=3.4u AS=9.52p AD=6.12p PS=12.4u PD=7u
* device instance $2728 m0 *1 292.4,467.9 NMOS
XM$2728 \$I4487 \$I4486 VSS VSS NMOS L=1u W=3.4u AS=6.12p AD=6.46p PS=7u PD=7.2u
* device instance $2729 m0 *1 297.2,467.9 NMOS
XM$2729 VSS \$I4487 \$I4486 VSS NMOS L=1u W=3.4u AS=6.46p AD=6.12p PS=7.2u PD=7u
* device instance $2730 m0 *1 301.8,467.9 NMOS
XM$2730 \$I4486 WL15 BLB12 VSS NMOS L=1u W=3.4u AS=6.12p AD=9.52p PS=7u PD=12.4u
* device instance $2731 m0 *1 292.4,151.5 PMOS
XM$2731 \$I4489 \$I4488 VDD VDD PMOS L=1u W=3.4u AS=10.88p AD=6.46p PS=13.2u
+ PD=7.2u
* device instance $2732 m0 *1 297.2,151.5 PMOS
XM$2732 VDD \$I4489 \$I4488 VDD PMOS L=1u W=3.4u AS=6.46p AD=10.88p PS=7.2u
+ PD=13.2u
* device instance $2733 m0 *1 287.8,171.9 NMOS
XM$2733 BL12 WL5 \$I4489 VSS NMOS L=1u W=3.4u AS=9.52p AD=6.12p PS=12.4u PD=7u
* device instance $2734 m0 *1 292.4,171.9 NMOS
XM$2734 \$I4489 \$I4488 VSS VSS NMOS L=1u W=3.4u AS=6.12p AD=6.46p PS=7u PD=7.2u
* device instance $2735 m0 *1 297.2,171.9 NMOS
XM$2735 VSS \$I4489 \$I4488 VSS NMOS L=1u W=3.4u AS=6.46p AD=6.12p PS=7.2u PD=7u
* device instance $2736 m0 *1 301.8,171.9 NMOS
XM$2736 \$I4488 WL5 BLB12 VSS NMOS L=1u W=3.4u AS=6.12p AD=9.52p PS=7u PD=12.4u
* device instance $2737 m0 *1 292.4,329.1 PMOS
XM$2737 \$I4491 \$I4490 VDD VDD PMOS L=1u W=3.4u AS=10.88p AD=6.46p PS=13.2u
+ PD=7.2u
* device instance $2738 m0 *1 297.2,329.1 PMOS
XM$2738 VDD \$I4491 \$I4490 VDD PMOS L=1u W=3.4u AS=6.46p AD=10.88p PS=7.2u
+ PD=13.2u
* device instance $2739 m0 *1 287.8,349.5 NMOS
XM$2739 BL12 WL11 \$I4491 VSS NMOS L=1u W=3.4u AS=9.52p AD=6.12p PS=12.4u PD=7u
* device instance $2740 m0 *1 292.4,349.5 NMOS
XM$2740 \$I4491 \$I4490 VSS VSS NMOS L=1u W=3.4u AS=6.12p AD=6.46p PS=7u PD=7.2u
* device instance $2741 m0 *1 297.2,349.5 NMOS
XM$2741 VSS \$I4491 \$I4490 VSS NMOS L=1u W=3.4u AS=6.46p AD=6.12p PS=7.2u PD=7u
* device instance $2742 m0 *1 301.8,349.5 NMOS
XM$2742 \$I4490 WL11 BLB12 VSS NMOS L=1u W=3.4u AS=6.12p AD=9.52p PS=7u PD=12.4u
* device instance $2743 m0 *1 292.4,388.3 PMOS
XM$2743 \$I4493 \$I4492 VDD VDD PMOS L=1u W=3.4u AS=10.88p AD=6.46p PS=13.2u
+ PD=7.2u
* device instance $2744 m0 *1 297.2,388.3 PMOS
XM$2744 VDD \$I4493 \$I4492 VDD PMOS L=1u W=3.4u AS=6.46p AD=10.88p PS=7.2u
+ PD=13.2u
* device instance $2745 m0 *1 287.8,408.7 NMOS
XM$2745 BL12 WL13 \$I4493 VSS NMOS L=1u W=3.4u AS=9.52p AD=6.12p PS=12.4u PD=7u
* device instance $2746 m0 *1 292.4,408.7 NMOS
XM$2746 \$I4493 \$I4492 VSS VSS NMOS L=1u W=3.4u AS=6.12p AD=6.46p PS=7u PD=7.2u
* device instance $2747 m0 *1 297.2,408.7 NMOS
XM$2747 VSS \$I4493 \$I4492 VSS NMOS L=1u W=3.4u AS=6.46p AD=6.12p PS=7.2u PD=7u
* device instance $2748 m0 *1 301.8,408.7 NMOS
XM$2748 \$I4492 WL13 BLB12 VSS NMOS L=1u W=3.4u AS=6.12p AD=9.52p PS=7u PD=12.4u
* device instance $2749 m0 *1 292.4,269.9 PMOS
XM$2749 \$I4495 \$I4494 VDD VDD PMOS L=1u W=3.4u AS=10.88p AD=6.46p PS=13.2u
+ PD=7.2u
* device instance $2750 m0 *1 297.2,269.9 PMOS
XM$2750 VDD \$I4495 \$I4494 VDD PMOS L=1u W=3.4u AS=6.46p AD=10.88p PS=7.2u
+ PD=13.2u
* device instance $2751 m0 *1 287.8,290.3 NMOS
XM$2751 BL12 WL9 \$I4495 VSS NMOS L=1u W=3.4u AS=9.52p AD=6.12p PS=12.4u PD=7u
* device instance $2752 m0 *1 292.4,290.3 NMOS
XM$2752 \$I4495 \$I4494 VSS VSS NMOS L=1u W=3.4u AS=6.12p AD=6.46p PS=7u PD=7.2u
* device instance $2753 m0 *1 297.2,290.3 NMOS
XM$2753 VSS \$I4495 \$I4494 VSS NMOS L=1u W=3.4u AS=6.46p AD=6.12p PS=7.2u PD=7u
* device instance $2754 m0 *1 301.8,290.3 NMOS
XM$2754 \$I4494 WL9 BLB12 VSS NMOS L=1u W=3.4u AS=6.12p AD=9.52p PS=7u PD=12.4u
* device instance $2755 m0 *1 292.4,210.7 PMOS
XM$2755 \$I4497 \$I4496 VDD VDD PMOS L=1u W=3.4u AS=10.88p AD=6.46p PS=13.2u
+ PD=7.2u
* device instance $2756 m0 *1 297.2,210.7 PMOS
XM$2756 VDD \$I4497 \$I4496 VDD PMOS L=1u W=3.4u AS=6.46p AD=10.88p PS=7.2u
+ PD=13.2u
* device instance $2757 m0 *1 287.8,231.1 NMOS
XM$2757 BL12 WL7 \$I4497 VSS NMOS L=1u W=3.4u AS=9.52p AD=6.12p PS=12.4u PD=7u
* device instance $2758 m0 *1 292.4,231.1 NMOS
XM$2758 \$I4497 \$I4496 VSS VSS NMOS L=1u W=3.4u AS=6.12p AD=6.46p PS=7u PD=7.2u
* device instance $2759 m0 *1 297.2,231.1 NMOS
XM$2759 VSS \$I4497 \$I4496 VSS NMOS L=1u W=3.4u AS=6.46p AD=6.12p PS=7.2u PD=7u
* device instance $2760 m0 *1 301.8,231.1 NMOS
XM$2760 \$I4496 WL7 BLB12 VSS NMOS L=1u W=3.4u AS=6.12p AD=9.52p PS=7u PD=12.4u
* device instance $2761 r0 *1 292.4,440.5 PMOS
XM$2761 \$I4499 \$I4498 VDD VDD PMOS L=1u W=3.4u AS=10.88p AD=6.46p PS=13.2u
+ PD=7.2u
* device instance $2762 r0 *1 297.2,440.5 PMOS
XM$2762 VDD \$I4499 \$I4498 VDD PMOS L=1u W=3.4u AS=6.46p AD=10.88p PS=7.2u
+ PD=13.2u
* device instance $2763 r0 *1 287.8,420.1 NMOS
XM$2763 BL12 WL14 \$I4499 VSS NMOS L=1u W=3.4u AS=9.52p AD=6.12p PS=12.4u PD=7u
* device instance $2764 r0 *1 292.4,420.1 NMOS
XM$2764 \$I4499 \$I4498 VSS VSS NMOS L=1u W=3.4u AS=6.12p AD=6.46p PS=7u PD=7.2u
* device instance $2765 r0 *1 297.2,420.1 NMOS
XM$2765 VSS \$I4499 \$I4498 VSS NMOS L=1u W=3.4u AS=6.46p AD=6.12p PS=7.2u PD=7u
* device instance $2766 r0 *1 301.8,420.1 NMOS
XM$2766 \$I4498 WL14 BLB12 VSS NMOS L=1u W=3.4u AS=6.12p AD=9.52p PS=7u PD=12.4u
* device instance $2767 r0 *1 292.4,381.3 PMOS
XM$2767 \$I4501 \$I4500 VDD VDD PMOS L=1u W=3.4u AS=10.88p AD=6.46p PS=13.2u
+ PD=7.2u
* device instance $2768 r0 *1 297.2,381.3 PMOS
XM$2768 VDD \$I4501 \$I4500 VDD PMOS L=1u W=3.4u AS=6.46p AD=10.88p PS=7.2u
+ PD=13.2u
* device instance $2769 r0 *1 287.8,360.9 NMOS
XM$2769 BL12 WL12 \$I4501 VSS NMOS L=1u W=3.4u AS=9.52p AD=6.12p PS=12.4u PD=7u
* device instance $2770 r0 *1 292.4,360.9 NMOS
XM$2770 \$I4501 \$I4500 VSS VSS NMOS L=1u W=3.4u AS=6.12p AD=6.46p PS=7u PD=7.2u
* device instance $2771 r0 *1 297.2,360.9 NMOS
XM$2771 VSS \$I4501 \$I4500 VSS NMOS L=1u W=3.4u AS=6.46p AD=6.12p PS=7.2u PD=7u
* device instance $2772 r0 *1 301.8,360.9 NMOS
XM$2772 \$I4500 WL12 BLB12 VSS NMOS L=1u W=3.4u AS=6.12p AD=9.52p PS=7u PD=12.4u
* device instance $2773 r0 *1 292.4,85.3 PMOS
XM$2773 \$I4503 \$I4502 VDD VDD PMOS L=1u W=3.4u AS=10.88p AD=6.46p PS=13.2u
+ PD=7.2u
* device instance $2774 r0 *1 297.2,85.3 PMOS
XM$2774 VDD \$I4503 \$I4502 VDD PMOS L=1u W=3.4u AS=6.46p AD=10.88p PS=7.2u
+ PD=13.2u
* device instance $2775 r0 *1 287.8,64.9 NMOS
XM$2775 BL12 WL2 \$I4503 VSS NMOS L=1u W=3.4u AS=9.52p AD=6.12p PS=12.4u PD=7u
* device instance $2776 r0 *1 292.4,64.9 NMOS
XM$2776 \$I4503 \$I4502 VSS VSS NMOS L=1u W=3.4u AS=6.12p AD=6.46p PS=7u PD=7.2u
* device instance $2777 r0 *1 297.2,64.9 NMOS
XM$2777 VSS \$I4503 \$I4502 VSS NMOS L=1u W=3.4u AS=6.46p AD=6.12p PS=7.2u PD=7u
* device instance $2778 r0 *1 301.8,64.9 NMOS
XM$2778 \$I4502 WL2 BLB12 VSS NMOS L=1u W=3.4u AS=6.12p AD=9.52p PS=7u PD=12.4u
* device instance $2779 r0 *1 292.4,322.1 PMOS
XM$2779 \$I4505 \$I4504 VDD VDD PMOS L=1u W=3.4u AS=10.88p AD=6.46p PS=13.2u
+ PD=7.2u
* device instance $2780 r0 *1 297.2,322.1 PMOS
XM$2780 VDD \$I4505 \$I4504 VDD PMOS L=1u W=3.4u AS=6.46p AD=10.88p PS=7.2u
+ PD=13.2u
* device instance $2781 r0 *1 287.8,301.7 NMOS
XM$2781 BL12 WL10 \$I4505 VSS NMOS L=1u W=3.4u AS=9.52p AD=6.12p PS=12.4u PD=7u
* device instance $2782 r0 *1 292.4,301.7 NMOS
XM$2782 \$I4505 \$I4504 VSS VSS NMOS L=1u W=3.4u AS=6.12p AD=6.46p PS=7u PD=7.2u
* device instance $2783 r0 *1 297.2,301.7 NMOS
XM$2783 VSS \$I4505 \$I4504 VSS NMOS L=1u W=3.4u AS=6.46p AD=6.12p PS=7.2u PD=7u
* device instance $2784 r0 *1 301.8,301.7 NMOS
XM$2784 \$I4504 WL10 BLB12 VSS NMOS L=1u W=3.4u AS=6.12p AD=9.52p PS=7u PD=12.4u
* device instance $2785 r0 *1 292.4,262.9 PMOS
XM$2785 \$I4507 \$I4506 VDD VDD PMOS L=1u W=3.4u AS=10.88p AD=6.46p PS=13.2u
+ PD=7.2u
* device instance $2786 r0 *1 297.2,262.9 PMOS
XM$2786 VDD \$I4507 \$I4506 VDD PMOS L=1u W=3.4u AS=6.46p AD=10.88p PS=7.2u
+ PD=13.2u
* device instance $2787 r0 *1 287.8,242.5 NMOS
XM$2787 BL12 WL8 \$I4507 VSS NMOS L=1u W=3.4u AS=9.52p AD=6.12p PS=12.4u PD=7u
* device instance $2788 r0 *1 292.4,242.5 NMOS
XM$2788 \$I4507 \$I4506 VSS VSS NMOS L=1u W=3.4u AS=6.12p AD=6.46p PS=7u PD=7.2u
* device instance $2789 r0 *1 297.2,242.5 NMOS
XM$2789 VSS \$I4507 \$I4506 VSS NMOS L=1u W=3.4u AS=6.46p AD=6.12p PS=7.2u PD=7u
* device instance $2790 r0 *1 301.8,242.5 NMOS
XM$2790 \$I4506 WL8 BLB12 VSS NMOS L=1u W=3.4u AS=6.12p AD=9.52p PS=7u PD=12.4u
* device instance $2791 r0 *1 292.4,144.5 PMOS
XM$2791 \$I4509 \$I4508 VDD VDD PMOS L=1u W=3.4u AS=10.88p AD=6.46p PS=13.2u
+ PD=7.2u
* device instance $2792 r0 *1 297.2,144.5 PMOS
XM$2792 VDD \$I4509 \$I4508 VDD PMOS L=1u W=3.4u AS=6.46p AD=10.88p PS=7.2u
+ PD=13.2u
* device instance $2793 r0 *1 287.8,124.1 NMOS
XM$2793 BL12 WL4 \$I4509 VSS NMOS L=1u W=3.4u AS=9.52p AD=6.12p PS=12.4u PD=7u
* device instance $2794 r0 *1 292.4,124.1 NMOS
XM$2794 \$I4509 \$I4508 VSS VSS NMOS L=1u W=3.4u AS=6.12p AD=6.46p PS=7u PD=7.2u
* device instance $2795 r0 *1 297.2,124.1 NMOS
XM$2795 VSS \$I4509 \$I4508 VSS NMOS L=1u W=3.4u AS=6.46p AD=6.12p PS=7.2u PD=7u
* device instance $2796 r0 *1 301.8,124.1 NMOS
XM$2796 \$I4508 WL4 BLB12 VSS NMOS L=1u W=3.4u AS=6.12p AD=9.52p PS=7u PD=12.4u
* device instance $2797 r0 *1 292.4,203.7 PMOS
XM$2797 \$I4511 \$I4510 VDD VDD PMOS L=1u W=3.4u AS=10.88p AD=6.46p PS=13.2u
+ PD=7.2u
* device instance $2798 r0 *1 297.2,203.7 PMOS
XM$2798 VDD \$I4511 \$I4510 VDD PMOS L=1u W=3.4u AS=6.46p AD=10.88p PS=7.2u
+ PD=13.2u
* device instance $2799 r0 *1 287.8,183.3 NMOS
XM$2799 BL12 WL6 \$I4511 VSS NMOS L=1u W=3.4u AS=9.52p AD=6.12p PS=12.4u PD=7u
* device instance $2800 r0 *1 292.4,183.3 NMOS
XM$2800 \$I4511 \$I4510 VSS VSS NMOS L=1u W=3.4u AS=6.12p AD=6.46p PS=7u PD=7.2u
* device instance $2801 r0 *1 297.2,183.3 NMOS
XM$2801 VSS \$I4511 \$I4510 VSS NMOS L=1u W=3.4u AS=6.46p AD=6.12p PS=7.2u PD=7u
* device instance $2802 r0 *1 301.8,183.3 NMOS
XM$2802 \$I4510 WL6 BLB12 VSS NMOS L=1u W=3.4u AS=6.12p AD=9.52p PS=7u PD=12.4u
* device instance $2803 m0 *1 489.6,329.1 PMOS
XM$2803 \$I4513 \$I4512 VDD VDD PMOS L=1u W=3.4u AS=10.88p AD=6.46p PS=13.2u
+ PD=7.2u
* device instance $2804 m0 *1 494.4,329.1 PMOS
XM$2804 VDD \$I4513 \$I4512 VDD PMOS L=1u W=3.4u AS=6.46p AD=10.88p PS=7.2u
+ PD=13.2u
* device instance $2805 m0 *1 485,349.5 NMOS
XM$2805 BL20 WL11 \$I4513 VSS NMOS L=1u W=3.4u AS=9.52p AD=6.12p PS=12.4u PD=7u
* device instance $2806 m0 *1 489.6,349.5 NMOS
XM$2806 \$I4513 \$I4512 VSS VSS NMOS L=1u W=3.4u AS=6.12p AD=6.46p PS=7u PD=7.2u
* device instance $2807 m0 *1 494.4,349.5 NMOS
XM$2807 VSS \$I4513 \$I4512 VSS NMOS L=1u W=3.4u AS=6.46p AD=6.12p PS=7.2u PD=7u
* device instance $2808 m0 *1 499,349.5 NMOS
XM$2808 \$I4512 WL11 BLB20 VSS NMOS L=1u W=3.4u AS=6.12p AD=9.52p PS=7u PD=12.4u
* device instance $2809 m0 *1 489.6,269.9 PMOS
XM$2809 \$I4515 \$I4514 VDD VDD PMOS L=1u W=3.4u AS=10.88p AD=6.46p PS=13.2u
+ PD=7.2u
* device instance $2810 m0 *1 494.4,269.9 PMOS
XM$2810 VDD \$I4515 \$I4514 VDD PMOS L=1u W=3.4u AS=6.46p AD=10.88p PS=7.2u
+ PD=13.2u
* device instance $2811 m0 *1 485,290.3 NMOS
XM$2811 BL20 WL9 \$I4515 VSS NMOS L=1u W=3.4u AS=9.52p AD=6.12p PS=12.4u PD=7u
* device instance $2812 m0 *1 489.6,290.3 NMOS
XM$2812 \$I4515 \$I4514 VSS VSS NMOS L=1u W=3.4u AS=6.12p AD=6.46p PS=7u PD=7.2u
* device instance $2813 m0 *1 494.4,290.3 NMOS
XM$2813 VSS \$I4515 \$I4514 VSS NMOS L=1u W=3.4u AS=6.46p AD=6.12p PS=7.2u PD=7u
* device instance $2814 m0 *1 499,290.3 NMOS
XM$2814 \$I4514 WL9 BLB20 VSS NMOS L=1u W=3.4u AS=6.12p AD=9.52p PS=7u PD=12.4u
* device instance $2815 m0 *1 489.6,33.1 PMOS
XM$2815 \$I4517 \$I4516 VDD VDD PMOS L=1u W=3.4u AS=10.88p AD=6.46p PS=13.2u
+ PD=7.2u
* device instance $2816 m0 *1 494.4,33.1 PMOS
XM$2816 VDD \$I4517 \$I4516 VDD PMOS L=1u W=3.4u AS=6.46p AD=10.88p PS=7.2u
+ PD=13.2u
* device instance $2817 m0 *1 485,53.5 NMOS
XM$2817 BL20 WL1 \$I4517 VSS NMOS L=1u W=3.4u AS=9.52p AD=6.12p PS=12.4u PD=7u
* device instance $2818 m0 *1 489.6,53.5 NMOS
XM$2818 \$I4517 \$I4516 VSS VSS NMOS L=1u W=3.4u AS=6.12p AD=6.46p PS=7u PD=7.2u
* device instance $2819 m0 *1 494.4,53.5 NMOS
XM$2819 VSS \$I4517 \$I4516 VSS NMOS L=1u W=3.4u AS=6.46p AD=6.12p PS=7.2u PD=7u
* device instance $2820 m0 *1 499,53.5 NMOS
XM$2820 \$I4516 WL1 BLB20 VSS NMOS L=1u W=3.4u AS=6.12p AD=9.52p PS=7u PD=12.4u
* device instance $2821 m0 *1 489.6,92.3 PMOS
XM$2821 \$I4519 \$I4518 VDD VDD PMOS L=1u W=3.4u AS=10.88p AD=6.46p PS=13.2u
+ PD=7.2u
* device instance $2822 m0 *1 494.4,92.3 PMOS
XM$2822 VDD \$I4519 \$I4518 VDD PMOS L=1u W=3.4u AS=6.46p AD=10.88p PS=7.2u
+ PD=13.2u
* device instance $2823 m0 *1 485,112.7 NMOS
XM$2823 BL20 WL3 \$I4519 VSS NMOS L=1u W=3.4u AS=9.52p AD=6.12p PS=12.4u PD=7u
* device instance $2824 m0 *1 489.6,112.7 NMOS
XM$2824 \$I4519 \$I4518 VSS VSS NMOS L=1u W=3.4u AS=6.12p AD=6.46p PS=7u PD=7.2u
* device instance $2825 m0 *1 494.4,112.7 NMOS
XM$2825 VSS \$I4519 \$I4518 VSS NMOS L=1u W=3.4u AS=6.46p AD=6.12p PS=7.2u PD=7u
* device instance $2826 m0 *1 499,112.7 NMOS
XM$2826 \$I4518 WL3 BLB20 VSS NMOS L=1u W=3.4u AS=6.12p AD=9.52p PS=7u PD=12.4u
* device instance $2827 m0 *1 489.6,447.5 PMOS
XM$2827 \$I4521 \$I4520 VDD VDD PMOS L=1u W=3.4u AS=10.88p AD=6.46p PS=13.2u
+ PD=7.2u
* device instance $2828 m0 *1 494.4,447.5 PMOS
XM$2828 VDD \$I4521 \$I4520 VDD PMOS L=1u W=3.4u AS=6.46p AD=10.88p PS=7.2u
+ PD=13.2u
* device instance $2829 m0 *1 485,467.9 NMOS
XM$2829 BL20 WL15 \$I4521 VSS NMOS L=1u W=3.4u AS=9.52p AD=6.12p PS=12.4u PD=7u
* device instance $2830 m0 *1 489.6,467.9 NMOS
XM$2830 \$I4521 \$I4520 VSS VSS NMOS L=1u W=3.4u AS=6.12p AD=6.46p PS=7u PD=7.2u
* device instance $2831 m0 *1 494.4,467.9 NMOS
XM$2831 VSS \$I4521 \$I4520 VSS NMOS L=1u W=3.4u AS=6.46p AD=6.12p PS=7.2u PD=7u
* device instance $2832 m0 *1 499,467.9 NMOS
XM$2832 \$I4520 WL15 BLB20 VSS NMOS L=1u W=3.4u AS=6.12p AD=9.52p PS=7u PD=12.4u
* device instance $2833 m0 *1 489.6,210.7 PMOS
XM$2833 \$I4523 \$I4522 VDD VDD PMOS L=1u W=3.4u AS=10.88p AD=6.46p PS=13.2u
+ PD=7.2u
* device instance $2834 m0 *1 494.4,210.7 PMOS
XM$2834 VDD \$I4523 \$I4522 VDD PMOS L=1u W=3.4u AS=6.46p AD=10.88p PS=7.2u
+ PD=13.2u
* device instance $2835 m0 *1 485,231.1 NMOS
XM$2835 BL20 WL7 \$I4523 VSS NMOS L=1u W=3.4u AS=9.52p AD=6.12p PS=12.4u PD=7u
* device instance $2836 m0 *1 489.6,231.1 NMOS
XM$2836 \$I4523 \$I4522 VSS VSS NMOS L=1u W=3.4u AS=6.12p AD=6.46p PS=7u PD=7.2u
* device instance $2837 m0 *1 494.4,231.1 NMOS
XM$2837 VSS \$I4523 \$I4522 VSS NMOS L=1u W=3.4u AS=6.46p AD=6.12p PS=7.2u PD=7u
* device instance $2838 m0 *1 499,231.1 NMOS
XM$2838 \$I4522 WL7 BLB20 VSS NMOS L=1u W=3.4u AS=6.12p AD=9.52p PS=7u PD=12.4u
* device instance $2839 m0 *1 489.6,388.3 PMOS
XM$2839 \$I4525 \$I4524 VDD VDD PMOS L=1u W=3.4u AS=10.88p AD=6.46p PS=13.2u
+ PD=7.2u
* device instance $2840 m0 *1 494.4,388.3 PMOS
XM$2840 VDD \$I4525 \$I4524 VDD PMOS L=1u W=3.4u AS=6.46p AD=10.88p PS=7.2u
+ PD=13.2u
* device instance $2841 m0 *1 485,408.7 NMOS
XM$2841 BL20 WL13 \$I4525 VSS NMOS L=1u W=3.4u AS=9.52p AD=6.12p PS=12.4u PD=7u
* device instance $2842 m0 *1 489.6,408.7 NMOS
XM$2842 \$I4525 \$I4524 VSS VSS NMOS L=1u W=3.4u AS=6.12p AD=6.46p PS=7u PD=7.2u
* device instance $2843 m0 *1 494.4,408.7 NMOS
XM$2843 VSS \$I4525 \$I4524 VSS NMOS L=1u W=3.4u AS=6.46p AD=6.12p PS=7.2u PD=7u
* device instance $2844 m0 *1 499,408.7 NMOS
XM$2844 \$I4524 WL13 BLB20 VSS NMOS L=1u W=3.4u AS=6.12p AD=9.52p PS=7u PD=12.4u
* device instance $2845 m0 *1 489.6,151.5 PMOS
XM$2845 \$I4527 \$I4526 VDD VDD PMOS L=1u W=3.4u AS=10.88p AD=6.46p PS=13.2u
+ PD=7.2u
* device instance $2846 m0 *1 494.4,151.5 PMOS
XM$2846 VDD \$I4527 \$I4526 VDD PMOS L=1u W=3.4u AS=6.46p AD=10.88p PS=7.2u
+ PD=13.2u
* device instance $2847 m0 *1 485,171.9 NMOS
XM$2847 BL20 WL5 \$I4527 VSS NMOS L=1u W=3.4u AS=9.52p AD=6.12p PS=12.4u PD=7u
* device instance $2848 m0 *1 489.6,171.9 NMOS
XM$2848 \$I4527 \$I4526 VSS VSS NMOS L=1u W=3.4u AS=6.12p AD=6.46p PS=7u PD=7.2u
* device instance $2849 m0 *1 494.4,171.9 NMOS
XM$2849 VSS \$I4527 \$I4526 VSS NMOS L=1u W=3.4u AS=6.46p AD=6.12p PS=7.2u PD=7u
* device instance $2850 m0 *1 499,171.9 NMOS
XM$2850 \$I4526 WL5 BLB20 VSS NMOS L=1u W=3.4u AS=6.12p AD=9.52p PS=7u PD=12.4u
* device instance $2851 r0 *1 489.6,440.5 PMOS
XM$2851 \$I4529 \$I4528 VDD VDD PMOS L=1u W=3.4u AS=10.88p AD=6.46p PS=13.2u
+ PD=7.2u
* device instance $2852 r0 *1 494.4,440.5 PMOS
XM$2852 VDD \$I4529 \$I4528 VDD PMOS L=1u W=3.4u AS=6.46p AD=10.88p PS=7.2u
+ PD=13.2u
* device instance $2853 r0 *1 485,420.1 NMOS
XM$2853 BL20 WL14 \$I4529 VSS NMOS L=1u W=3.4u AS=9.52p AD=6.12p PS=12.4u PD=7u
* device instance $2854 r0 *1 489.6,420.1 NMOS
XM$2854 \$I4529 \$I4528 VSS VSS NMOS L=1u W=3.4u AS=6.12p AD=6.46p PS=7u PD=7.2u
* device instance $2855 r0 *1 494.4,420.1 NMOS
XM$2855 VSS \$I4529 \$I4528 VSS NMOS L=1u W=3.4u AS=6.46p AD=6.12p PS=7.2u PD=7u
* device instance $2856 r0 *1 499,420.1 NMOS
XM$2856 \$I4528 WL14 BLB20 VSS NMOS L=1u W=3.4u AS=6.12p AD=9.52p PS=7u PD=12.4u
* device instance $2857 r0 *1 489.6,322.1 PMOS
XM$2857 \$I4531 \$I4530 VDD VDD PMOS L=1u W=3.4u AS=10.88p AD=6.46p PS=13.2u
+ PD=7.2u
* device instance $2858 r0 *1 494.4,322.1 PMOS
XM$2858 VDD \$I4531 \$I4530 VDD PMOS L=1u W=3.4u AS=6.46p AD=10.88p PS=7.2u
+ PD=13.2u
* device instance $2859 r0 *1 485,301.7 NMOS
XM$2859 BL20 WL10 \$I4531 VSS NMOS L=1u W=3.4u AS=9.52p AD=6.12p PS=12.4u PD=7u
* device instance $2860 r0 *1 489.6,301.7 NMOS
XM$2860 \$I4531 \$I4530 VSS VSS NMOS L=1u W=3.4u AS=6.12p AD=6.46p PS=7u PD=7.2u
* device instance $2861 r0 *1 494.4,301.7 NMOS
XM$2861 VSS \$I4531 \$I4530 VSS NMOS L=1u W=3.4u AS=6.46p AD=6.12p PS=7.2u PD=7u
* device instance $2862 r0 *1 499,301.7 NMOS
XM$2862 \$I4530 WL10 BLB20 VSS NMOS L=1u W=3.4u AS=6.12p AD=9.52p PS=7u PD=12.4u
* device instance $2863 r0 *1 489.6,381.3 PMOS
XM$2863 \$I4533 \$I4532 VDD VDD PMOS L=1u W=3.4u AS=10.88p AD=6.46p PS=13.2u
+ PD=7.2u
* device instance $2864 r0 *1 494.4,381.3 PMOS
XM$2864 VDD \$I4533 \$I4532 VDD PMOS L=1u W=3.4u AS=6.46p AD=10.88p PS=7.2u
+ PD=13.2u
* device instance $2865 r0 *1 485,360.9 NMOS
XM$2865 BL20 WL12 \$I4533 VSS NMOS L=1u W=3.4u AS=9.52p AD=6.12p PS=12.4u PD=7u
* device instance $2866 r0 *1 489.6,360.9 NMOS
XM$2866 \$I4533 \$I4532 VSS VSS NMOS L=1u W=3.4u AS=6.12p AD=6.46p PS=7u PD=7.2u
* device instance $2867 r0 *1 494.4,360.9 NMOS
XM$2867 VSS \$I4533 \$I4532 VSS NMOS L=1u W=3.4u AS=6.46p AD=6.12p PS=7.2u PD=7u
* device instance $2868 r0 *1 499,360.9 NMOS
XM$2868 \$I4532 WL12 BLB20 VSS NMOS L=1u W=3.4u AS=6.12p AD=9.52p PS=7u PD=12.4u
* device instance $2869 r0 *1 489.6,262.9 PMOS
XM$2869 \$I4535 \$I4534 VDD VDD PMOS L=1u W=3.4u AS=10.88p AD=6.46p PS=13.2u
+ PD=7.2u
* device instance $2870 r0 *1 494.4,262.9 PMOS
XM$2870 VDD \$I4535 \$I4534 VDD PMOS L=1u W=3.4u AS=6.46p AD=10.88p PS=7.2u
+ PD=13.2u
* device instance $2871 r0 *1 485,242.5 NMOS
XM$2871 BL20 WL8 \$I4535 VSS NMOS L=1u W=3.4u AS=9.52p AD=6.12p PS=12.4u PD=7u
* device instance $2872 r0 *1 489.6,242.5 NMOS
XM$2872 \$I4535 \$I4534 VSS VSS NMOS L=1u W=3.4u AS=6.12p AD=6.46p PS=7u PD=7.2u
* device instance $2873 r0 *1 494.4,242.5 NMOS
XM$2873 VSS \$I4535 \$I4534 VSS NMOS L=1u W=3.4u AS=6.46p AD=6.12p PS=7.2u PD=7u
* device instance $2874 r0 *1 499,242.5 NMOS
XM$2874 \$I4534 WL8 BLB20 VSS NMOS L=1u W=3.4u AS=6.12p AD=9.52p PS=7u PD=12.4u
* device instance $2875 r0 *1 489.6,203.7 PMOS
XM$2875 \$I4537 \$I4536 VDD VDD PMOS L=1u W=3.4u AS=10.88p AD=6.46p PS=13.2u
+ PD=7.2u
* device instance $2876 r0 *1 494.4,203.7 PMOS
XM$2876 VDD \$I4537 \$I4536 VDD PMOS L=1u W=3.4u AS=6.46p AD=10.88p PS=7.2u
+ PD=13.2u
* device instance $2877 r0 *1 485,183.3 NMOS
XM$2877 BL20 WL6 \$I4537 VSS NMOS L=1u W=3.4u AS=9.52p AD=6.12p PS=12.4u PD=7u
* device instance $2878 r0 *1 489.6,183.3 NMOS
XM$2878 \$I4537 \$I4536 VSS VSS NMOS L=1u W=3.4u AS=6.12p AD=6.46p PS=7u PD=7.2u
* device instance $2879 r0 *1 494.4,183.3 NMOS
XM$2879 VSS \$I4537 \$I4536 VSS NMOS L=1u W=3.4u AS=6.46p AD=6.12p PS=7.2u PD=7u
* device instance $2880 r0 *1 499,183.3 NMOS
XM$2880 \$I4536 WL6 BLB20 VSS NMOS L=1u W=3.4u AS=6.12p AD=9.52p PS=7u PD=12.4u
* device instance $2881 r0 *1 489.6,144.5 PMOS
XM$2881 \$I4539 \$I4538 VDD VDD PMOS L=1u W=3.4u AS=10.88p AD=6.46p PS=13.2u
+ PD=7.2u
* device instance $2882 r0 *1 494.4,144.5 PMOS
XM$2882 VDD \$I4539 \$I4538 VDD PMOS L=1u W=3.4u AS=6.46p AD=10.88p PS=7.2u
+ PD=13.2u
* device instance $2883 r0 *1 485,124.1 NMOS
XM$2883 BL20 WL4 \$I4539 VSS NMOS L=1u W=3.4u AS=9.52p AD=6.12p PS=12.4u PD=7u
* device instance $2884 r0 *1 489.6,124.1 NMOS
XM$2884 \$I4539 \$I4538 VSS VSS NMOS L=1u W=3.4u AS=6.12p AD=6.46p PS=7u PD=7.2u
* device instance $2885 r0 *1 494.4,124.1 NMOS
XM$2885 VSS \$I4539 \$I4538 VSS NMOS L=1u W=3.4u AS=6.46p AD=6.12p PS=7.2u PD=7u
* device instance $2886 r0 *1 499,124.1 NMOS
XM$2886 \$I4538 WL4 BLB20 VSS NMOS L=1u W=3.4u AS=6.12p AD=9.52p PS=7u PD=12.4u
* device instance $2887 r0 *1 489.6,85.3 PMOS
XM$2887 \$I4541 \$I4540 VDD VDD PMOS L=1u W=3.4u AS=10.88p AD=6.46p PS=13.2u
+ PD=7.2u
* device instance $2888 r0 *1 494.4,85.3 PMOS
XM$2888 VDD \$I4541 \$I4540 VDD PMOS L=1u W=3.4u AS=6.46p AD=10.88p PS=7.2u
+ PD=13.2u
* device instance $2889 r0 *1 485,64.9 NMOS
XM$2889 BL20 WL2 \$I4541 VSS NMOS L=1u W=3.4u AS=9.52p AD=6.12p PS=12.4u PD=7u
* device instance $2890 r0 *1 489.6,64.9 NMOS
XM$2890 \$I4541 \$I4540 VSS VSS NMOS L=1u W=3.4u AS=6.12p AD=6.46p PS=7u PD=7.2u
* device instance $2891 r0 *1 494.4,64.9 NMOS
XM$2891 VSS \$I4541 \$I4540 VSS NMOS L=1u W=3.4u AS=6.46p AD=6.12p PS=7.2u PD=7u
* device instance $2892 r0 *1 499,64.9 NMOS
XM$2892 \$I4540 WL2 BLB20 VSS NMOS L=1u W=3.4u AS=6.12p AD=9.52p PS=7u PD=12.4u
* device instance $2893 m0 *1 401.6,329.1 PMOS
XM$2893 \$I4543 \$I4542 VDD VDD PMOS L=1u W=3.4u AS=10.88p AD=6.46p PS=13.2u
+ PD=7.2u
* device instance $2894 m0 *1 406.4,329.1 PMOS
XM$2894 VDD \$I4543 \$I4542 VDD PMOS L=1u W=3.4u AS=6.46p AD=10.88p PS=7.2u
+ PD=13.2u
* device instance $2895 m0 *1 397,349.5 NMOS
XM$2895 BL16 WL11 \$I4543 VSS NMOS L=1u W=3.4u AS=9.52p AD=6.12p PS=12.4u PD=7u
* device instance $2896 m0 *1 401.6,349.5 NMOS
XM$2896 \$I4543 \$I4542 VSS VSS NMOS L=1u W=3.4u AS=6.12p AD=6.46p PS=7u PD=7.2u
* device instance $2897 m0 *1 406.4,349.5 NMOS
XM$2897 VSS \$I4543 \$I4542 VSS NMOS L=1u W=3.4u AS=6.46p AD=6.12p PS=7.2u PD=7u
* device instance $2898 m0 *1 411,349.5 NMOS
XM$2898 \$I4542 WL11 BLB16 VSS NMOS L=1u W=3.4u AS=6.12p AD=9.52p PS=7u PD=12.4u
* device instance $2899 m0 *1 401.6,269.9 PMOS
XM$2899 \$I4545 \$I4544 VDD VDD PMOS L=1u W=3.4u AS=10.88p AD=6.46p PS=13.2u
+ PD=7.2u
* device instance $2900 m0 *1 406.4,269.9 PMOS
XM$2900 VDD \$I4545 \$I4544 VDD PMOS L=1u W=3.4u AS=6.46p AD=10.88p PS=7.2u
+ PD=13.2u
* device instance $2901 m0 *1 397,290.3 NMOS
XM$2901 BL16 WL9 \$I4545 VSS NMOS L=1u W=3.4u AS=9.52p AD=6.12p PS=12.4u PD=7u
* device instance $2902 m0 *1 401.6,290.3 NMOS
XM$2902 \$I4545 \$I4544 VSS VSS NMOS L=1u W=3.4u AS=6.12p AD=6.46p PS=7u PD=7.2u
* device instance $2903 m0 *1 406.4,290.3 NMOS
XM$2903 VSS \$I4545 \$I4544 VSS NMOS L=1u W=3.4u AS=6.46p AD=6.12p PS=7.2u PD=7u
* device instance $2904 m0 *1 411,290.3 NMOS
XM$2904 \$I4544 WL9 BLB16 VSS NMOS L=1u W=3.4u AS=6.12p AD=9.52p PS=7u PD=12.4u
* device instance $2905 m0 *1 401.6,92.3 PMOS
XM$2905 \$I4547 \$I4546 VDD VDD PMOS L=1u W=3.4u AS=10.88p AD=6.46p PS=13.2u
+ PD=7.2u
* device instance $2906 m0 *1 406.4,92.3 PMOS
XM$2906 VDD \$I4547 \$I4546 VDD PMOS L=1u W=3.4u AS=6.46p AD=10.88p PS=7.2u
+ PD=13.2u
* device instance $2907 m0 *1 397,112.7 NMOS
XM$2907 BL16 WL3 \$I4547 VSS NMOS L=1u W=3.4u AS=9.52p AD=6.12p PS=12.4u PD=7u
* device instance $2908 m0 *1 401.6,112.7 NMOS
XM$2908 \$I4547 \$I4546 VSS VSS NMOS L=1u W=3.4u AS=6.12p AD=6.46p PS=7u PD=7.2u
* device instance $2909 m0 *1 406.4,112.7 NMOS
XM$2909 VSS \$I4547 \$I4546 VSS NMOS L=1u W=3.4u AS=6.46p AD=6.12p PS=7.2u PD=7u
* device instance $2910 m0 *1 411,112.7 NMOS
XM$2910 \$I4546 WL3 BLB16 VSS NMOS L=1u W=3.4u AS=6.12p AD=9.52p PS=7u PD=12.4u
* device instance $2911 m0 *1 401.6,33.1 PMOS
XM$2911 \$I4549 \$I4548 VDD VDD PMOS L=1u W=3.4u AS=10.88p AD=6.46p PS=13.2u
+ PD=7.2u
* device instance $2912 m0 *1 406.4,33.1 PMOS
XM$2912 VDD \$I4549 \$I4548 VDD PMOS L=1u W=3.4u AS=6.46p AD=10.88p PS=7.2u
+ PD=13.2u
* device instance $2913 m0 *1 397,53.5 NMOS
XM$2913 BL16 WL1 \$I4549 VSS NMOS L=1u W=3.4u AS=9.52p AD=6.12p PS=12.4u PD=7u
* device instance $2914 m0 *1 401.6,53.5 NMOS
XM$2914 \$I4549 \$I4548 VSS VSS NMOS L=1u W=3.4u AS=6.12p AD=6.46p PS=7u PD=7.2u
* device instance $2915 m0 *1 406.4,53.5 NMOS
XM$2915 VSS \$I4549 \$I4548 VSS NMOS L=1u W=3.4u AS=6.46p AD=6.12p PS=7.2u PD=7u
* device instance $2916 m0 *1 411,53.5 NMOS
XM$2916 \$I4548 WL1 BLB16 VSS NMOS L=1u W=3.4u AS=6.12p AD=9.52p PS=7u PD=12.4u
* device instance $2917 m0 *1 401.6,447.5 PMOS
XM$2917 \$I4551 \$I4550 VDD VDD PMOS L=1u W=3.4u AS=10.88p AD=6.46p PS=13.2u
+ PD=7.2u
* device instance $2918 m0 *1 406.4,447.5 PMOS
XM$2918 VDD \$I4551 \$I4550 VDD PMOS L=1u W=3.4u AS=6.46p AD=10.88p PS=7.2u
+ PD=13.2u
* device instance $2919 m0 *1 397,467.9 NMOS
XM$2919 BL16 WL15 \$I4551 VSS NMOS L=1u W=3.4u AS=9.52p AD=6.12p PS=12.4u PD=7u
* device instance $2920 m0 *1 401.6,467.9 NMOS
XM$2920 \$I4551 \$I4550 VSS VSS NMOS L=1u W=3.4u AS=6.12p AD=6.46p PS=7u PD=7.2u
* device instance $2921 m0 *1 406.4,467.9 NMOS
XM$2921 VSS \$I4551 \$I4550 VSS NMOS L=1u W=3.4u AS=6.46p AD=6.12p PS=7.2u PD=7u
* device instance $2922 m0 *1 411,467.9 NMOS
XM$2922 \$I4550 WL15 BLB16 VSS NMOS L=1u W=3.4u AS=6.12p AD=9.52p PS=7u PD=12.4u
* device instance $2923 m0 *1 401.6,388.3 PMOS
XM$2923 \$I4553 \$I4552 VDD VDD PMOS L=1u W=3.4u AS=10.88p AD=6.46p PS=13.2u
+ PD=7.2u
* device instance $2924 m0 *1 406.4,388.3 PMOS
XM$2924 VDD \$I4553 \$I4552 VDD PMOS L=1u W=3.4u AS=6.46p AD=10.88p PS=7.2u
+ PD=13.2u
* device instance $2925 m0 *1 397,408.7 NMOS
XM$2925 BL16 WL13 \$I4553 VSS NMOS L=1u W=3.4u AS=9.52p AD=6.12p PS=12.4u PD=7u
* device instance $2926 m0 *1 401.6,408.7 NMOS
XM$2926 \$I4553 \$I4552 VSS VSS NMOS L=1u W=3.4u AS=6.12p AD=6.46p PS=7u PD=7.2u
* device instance $2927 m0 *1 406.4,408.7 NMOS
XM$2927 VSS \$I4553 \$I4552 VSS NMOS L=1u W=3.4u AS=6.46p AD=6.12p PS=7.2u PD=7u
* device instance $2928 m0 *1 411,408.7 NMOS
XM$2928 \$I4552 WL13 BLB16 VSS NMOS L=1u W=3.4u AS=6.12p AD=9.52p PS=7u PD=12.4u
* device instance $2929 m0 *1 401.6,210.7 PMOS
XM$2929 \$I4555 \$I4554 VDD VDD PMOS L=1u W=3.4u AS=10.88p AD=6.46p PS=13.2u
+ PD=7.2u
* device instance $2930 m0 *1 406.4,210.7 PMOS
XM$2930 VDD \$I4555 \$I4554 VDD PMOS L=1u W=3.4u AS=6.46p AD=10.88p PS=7.2u
+ PD=13.2u
* device instance $2931 m0 *1 397,231.1 NMOS
XM$2931 BL16 WL7 \$I4555 VSS NMOS L=1u W=3.4u AS=9.52p AD=6.12p PS=12.4u PD=7u
* device instance $2932 m0 *1 401.6,231.1 NMOS
XM$2932 \$I4555 \$I4554 VSS VSS NMOS L=1u W=3.4u AS=6.12p AD=6.46p PS=7u PD=7.2u
* device instance $2933 m0 *1 406.4,231.1 NMOS
XM$2933 VSS \$I4555 \$I4554 VSS NMOS L=1u W=3.4u AS=6.46p AD=6.12p PS=7.2u PD=7u
* device instance $2934 m0 *1 411,231.1 NMOS
XM$2934 \$I4554 WL7 BLB16 VSS NMOS L=1u W=3.4u AS=6.12p AD=9.52p PS=7u PD=12.4u
* device instance $2935 m0 *1 401.6,151.5 PMOS
XM$2935 \$I4557 \$I4556 VDD VDD PMOS L=1u W=3.4u AS=10.88p AD=6.46p PS=13.2u
+ PD=7.2u
* device instance $2936 m0 *1 406.4,151.5 PMOS
XM$2936 VDD \$I4557 \$I4556 VDD PMOS L=1u W=3.4u AS=6.46p AD=10.88p PS=7.2u
+ PD=13.2u
* device instance $2937 m0 *1 397,171.9 NMOS
XM$2937 BL16 WL5 \$I4557 VSS NMOS L=1u W=3.4u AS=9.52p AD=6.12p PS=12.4u PD=7u
* device instance $2938 m0 *1 401.6,171.9 NMOS
XM$2938 \$I4557 \$I4556 VSS VSS NMOS L=1u W=3.4u AS=6.12p AD=6.46p PS=7u PD=7.2u
* device instance $2939 m0 *1 406.4,171.9 NMOS
XM$2939 VSS \$I4557 \$I4556 VSS NMOS L=1u W=3.4u AS=6.46p AD=6.12p PS=7.2u PD=7u
* device instance $2940 m0 *1 411,171.9 NMOS
XM$2940 \$I4556 WL5 BLB16 VSS NMOS L=1u W=3.4u AS=6.12p AD=9.52p PS=7u PD=12.4u
* device instance $2941 r0 *1 401.6,381.3 PMOS
XM$2941 \$I4559 \$I4558 VDD VDD PMOS L=1u W=3.4u AS=10.88p AD=6.46p PS=13.2u
+ PD=7.2u
* device instance $2942 r0 *1 406.4,381.3 PMOS
XM$2942 VDD \$I4559 \$I4558 VDD PMOS L=1u W=3.4u AS=6.46p AD=10.88p PS=7.2u
+ PD=13.2u
* device instance $2943 r0 *1 397,360.9 NMOS
XM$2943 BL16 WL12 \$I4559 VSS NMOS L=1u W=3.4u AS=9.52p AD=6.12p PS=12.4u PD=7u
* device instance $2944 r0 *1 401.6,360.9 NMOS
XM$2944 \$I4559 \$I4558 VSS VSS NMOS L=1u W=3.4u AS=6.12p AD=6.46p PS=7u PD=7.2u
* device instance $2945 r0 *1 406.4,360.9 NMOS
XM$2945 VSS \$I4559 \$I4558 VSS NMOS L=1u W=3.4u AS=6.46p AD=6.12p PS=7.2u PD=7u
* device instance $2946 r0 *1 411,360.9 NMOS
XM$2946 \$I4558 WL12 BLB16 VSS NMOS L=1u W=3.4u AS=6.12p AD=9.52p PS=7u PD=12.4u
* device instance $2947 r0 *1 401.6,262.9 PMOS
XM$2947 \$I4561 \$I4560 VDD VDD PMOS L=1u W=3.4u AS=10.88p AD=6.46p PS=13.2u
+ PD=7.2u
* device instance $2948 r0 *1 406.4,262.9 PMOS
XM$2948 VDD \$I4561 \$I4560 VDD PMOS L=1u W=3.4u AS=6.46p AD=10.88p PS=7.2u
+ PD=13.2u
* device instance $2949 r0 *1 397,242.5 NMOS
XM$2949 BL16 WL8 \$I4561 VSS NMOS L=1u W=3.4u AS=9.52p AD=6.12p PS=12.4u PD=7u
* device instance $2950 r0 *1 401.6,242.5 NMOS
XM$2950 \$I4561 \$I4560 VSS VSS NMOS L=1u W=3.4u AS=6.12p AD=6.46p PS=7u PD=7.2u
* device instance $2951 r0 *1 406.4,242.5 NMOS
XM$2951 VSS \$I4561 \$I4560 VSS NMOS L=1u W=3.4u AS=6.46p AD=6.12p PS=7.2u PD=7u
* device instance $2952 r0 *1 411,242.5 NMOS
XM$2952 \$I4560 WL8 BLB16 VSS NMOS L=1u W=3.4u AS=6.12p AD=9.52p PS=7u PD=12.4u
* device instance $2953 r0 *1 401.6,440.5 PMOS
XM$2953 \$I4563 \$I4562 VDD VDD PMOS L=1u W=3.4u AS=10.88p AD=6.46p PS=13.2u
+ PD=7.2u
* device instance $2954 r0 *1 406.4,440.5 PMOS
XM$2954 VDD \$I4563 \$I4562 VDD PMOS L=1u W=3.4u AS=6.46p AD=10.88p PS=7.2u
+ PD=13.2u
* device instance $2955 r0 *1 397,420.1 NMOS
XM$2955 BL16 WL14 \$I4563 VSS NMOS L=1u W=3.4u AS=9.52p AD=6.12p PS=12.4u PD=7u
* device instance $2956 r0 *1 401.6,420.1 NMOS
XM$2956 \$I4563 \$I4562 VSS VSS NMOS L=1u W=3.4u AS=6.12p AD=6.46p PS=7u PD=7.2u
* device instance $2957 r0 *1 406.4,420.1 NMOS
XM$2957 VSS \$I4563 \$I4562 VSS NMOS L=1u W=3.4u AS=6.46p AD=6.12p PS=7.2u PD=7u
* device instance $2958 r0 *1 411,420.1 NMOS
XM$2958 \$I4562 WL14 BLB16 VSS NMOS L=1u W=3.4u AS=6.12p AD=9.52p PS=7u PD=12.4u
* device instance $2959 r0 *1 401.6,322.1 PMOS
XM$2959 \$I4565 \$I4564 VDD VDD PMOS L=1u W=3.4u AS=10.88p AD=6.46p PS=13.2u
+ PD=7.2u
* device instance $2960 r0 *1 406.4,322.1 PMOS
XM$2960 VDD \$I4565 \$I4564 VDD PMOS L=1u W=3.4u AS=6.46p AD=10.88p PS=7.2u
+ PD=13.2u
* device instance $2961 r0 *1 397,301.7 NMOS
XM$2961 BL16 WL10 \$I4565 VSS NMOS L=1u W=3.4u AS=9.52p AD=6.12p PS=12.4u PD=7u
* device instance $2962 r0 *1 401.6,301.7 NMOS
XM$2962 \$I4565 \$I4564 VSS VSS NMOS L=1u W=3.4u AS=6.12p AD=6.46p PS=7u PD=7.2u
* device instance $2963 r0 *1 406.4,301.7 NMOS
XM$2963 VSS \$I4565 \$I4564 VSS NMOS L=1u W=3.4u AS=6.46p AD=6.12p PS=7.2u PD=7u
* device instance $2964 r0 *1 411,301.7 NMOS
XM$2964 \$I4564 WL10 BLB16 VSS NMOS L=1u W=3.4u AS=6.12p AD=9.52p PS=7u PD=12.4u
* device instance $2965 r0 *1 401.6,203.7 PMOS
XM$2965 \$I4567 \$I4566 VDD VDD PMOS L=1u W=3.4u AS=10.88p AD=6.46p PS=13.2u
+ PD=7.2u
* device instance $2966 r0 *1 406.4,203.7 PMOS
XM$2966 VDD \$I4567 \$I4566 VDD PMOS L=1u W=3.4u AS=6.46p AD=10.88p PS=7.2u
+ PD=13.2u
* device instance $2967 r0 *1 397,183.3 NMOS
XM$2967 BL16 WL6 \$I4567 VSS NMOS L=1u W=3.4u AS=9.52p AD=6.12p PS=12.4u PD=7u
* device instance $2968 r0 *1 401.6,183.3 NMOS
XM$2968 \$I4567 \$I4566 VSS VSS NMOS L=1u W=3.4u AS=6.12p AD=6.46p PS=7u PD=7.2u
* device instance $2969 r0 *1 406.4,183.3 NMOS
XM$2969 VSS \$I4567 \$I4566 VSS NMOS L=1u W=3.4u AS=6.46p AD=6.12p PS=7.2u PD=7u
* device instance $2970 r0 *1 411,183.3 NMOS
XM$2970 \$I4566 WL6 BLB16 VSS NMOS L=1u W=3.4u AS=6.12p AD=9.52p PS=7u PD=12.4u
* device instance $2971 r0 *1 401.6,144.5 PMOS
XM$2971 \$I4569 \$I4568 VDD VDD PMOS L=1u W=3.4u AS=10.88p AD=6.46p PS=13.2u
+ PD=7.2u
* device instance $2972 r0 *1 406.4,144.5 PMOS
XM$2972 VDD \$I4569 \$I4568 VDD PMOS L=1u W=3.4u AS=6.46p AD=10.88p PS=7.2u
+ PD=13.2u
* device instance $2973 r0 *1 397,124.1 NMOS
XM$2973 BL16 WL4 \$I4569 VSS NMOS L=1u W=3.4u AS=9.52p AD=6.12p PS=12.4u PD=7u
* device instance $2974 r0 *1 401.6,124.1 NMOS
XM$2974 \$I4569 \$I4568 VSS VSS NMOS L=1u W=3.4u AS=6.12p AD=6.46p PS=7u PD=7.2u
* device instance $2975 r0 *1 406.4,124.1 NMOS
XM$2975 VSS \$I4569 \$I4568 VSS NMOS L=1u W=3.4u AS=6.46p AD=6.12p PS=7.2u PD=7u
* device instance $2976 r0 *1 411,124.1 NMOS
XM$2976 \$I4568 WL4 BLB16 VSS NMOS L=1u W=3.4u AS=6.12p AD=9.52p PS=7u PD=12.4u
* device instance $2977 r0 *1 401.6,85.3 PMOS
XM$2977 \$I4571 \$I4570 VDD VDD PMOS L=1u W=3.4u AS=10.88p AD=6.46p PS=13.2u
+ PD=7.2u
* device instance $2978 r0 *1 406.4,85.3 PMOS
XM$2978 VDD \$I4571 \$I4570 VDD PMOS L=1u W=3.4u AS=6.46p AD=10.88p PS=7.2u
+ PD=13.2u
* device instance $2979 r0 *1 397,64.9 NMOS
XM$2979 BL16 WL2 \$I4571 VSS NMOS L=1u W=3.4u AS=9.52p AD=6.12p PS=12.4u PD=7u
* device instance $2980 r0 *1 401.6,64.9 NMOS
XM$2980 \$I4571 \$I4570 VSS VSS NMOS L=1u W=3.4u AS=6.12p AD=6.46p PS=7u PD=7.2u
* device instance $2981 r0 *1 406.4,64.9 NMOS
XM$2981 VSS \$I4571 \$I4570 VSS NMOS L=1u W=3.4u AS=6.46p AD=6.12p PS=7.2u PD=7u
* device instance $2982 r0 *1 411,64.9 NMOS
XM$2982 \$I4570 WL2 BLB16 VSS NMOS L=1u W=3.4u AS=6.12p AD=9.52p PS=7u PD=12.4u
* device instance $2983 m0 *1 423.6,329.1 PMOS
XM$2983 \$I4573 \$I4572 VDD VDD PMOS L=1u W=3.4u AS=10.88p AD=6.46p PS=13.2u
+ PD=7.2u
* device instance $2984 m0 *1 428.4,329.1 PMOS
XM$2984 VDD \$I4573 \$I4572 VDD PMOS L=1u W=3.4u AS=6.46p AD=10.88p PS=7.2u
+ PD=13.2u
* device instance $2985 m0 *1 419,349.5 NMOS
XM$2985 BL17 WL11 \$I4573 VSS NMOS L=1u W=3.4u AS=9.52p AD=6.12p PS=12.4u PD=7u
* device instance $2986 m0 *1 423.6,349.5 NMOS
XM$2986 \$I4573 \$I4572 VSS VSS NMOS L=1u W=3.4u AS=6.12p AD=6.46p PS=7u PD=7.2u
* device instance $2987 m0 *1 428.4,349.5 NMOS
XM$2987 VSS \$I4573 \$I4572 VSS NMOS L=1u W=3.4u AS=6.46p AD=6.12p PS=7.2u PD=7u
* device instance $2988 m0 *1 433,349.5 NMOS
XM$2988 \$I4572 WL11 BLB17 VSS NMOS L=1u W=3.4u AS=6.12p AD=9.52p PS=7u PD=12.4u
* device instance $2989 m0 *1 423.6,269.9 PMOS
XM$2989 \$I4575 \$I4574 VDD VDD PMOS L=1u W=3.4u AS=10.88p AD=6.46p PS=13.2u
+ PD=7.2u
* device instance $2990 m0 *1 428.4,269.9 PMOS
XM$2990 VDD \$I4575 \$I4574 VDD PMOS L=1u W=3.4u AS=6.46p AD=10.88p PS=7.2u
+ PD=13.2u
* device instance $2991 m0 *1 419,290.3 NMOS
XM$2991 BL17 WL9 \$I4575 VSS NMOS L=1u W=3.4u AS=9.52p AD=6.12p PS=12.4u PD=7u
* device instance $2992 m0 *1 423.6,290.3 NMOS
XM$2992 \$I4575 \$I4574 VSS VSS NMOS L=1u W=3.4u AS=6.12p AD=6.46p PS=7u PD=7.2u
* device instance $2993 m0 *1 428.4,290.3 NMOS
XM$2993 VSS \$I4575 \$I4574 VSS NMOS L=1u W=3.4u AS=6.46p AD=6.12p PS=7.2u PD=7u
* device instance $2994 m0 *1 433,290.3 NMOS
XM$2994 \$I4574 WL9 BLB17 VSS NMOS L=1u W=3.4u AS=6.12p AD=9.52p PS=7u PD=12.4u
* device instance $2995 m0 *1 423.6,33.1 PMOS
XM$2995 \$I4577 \$I4576 VDD VDD PMOS L=1u W=3.4u AS=10.88p AD=6.46p PS=13.2u
+ PD=7.2u
* device instance $2996 m0 *1 428.4,33.1 PMOS
XM$2996 VDD \$I4577 \$I4576 VDD PMOS L=1u W=3.4u AS=6.46p AD=10.88p PS=7.2u
+ PD=13.2u
* device instance $2997 m0 *1 419,53.5 NMOS
XM$2997 BL17 WL1 \$I4577 VSS NMOS L=1u W=3.4u AS=9.52p AD=6.12p PS=12.4u PD=7u
* device instance $2998 m0 *1 423.6,53.5 NMOS
XM$2998 \$I4577 \$I4576 VSS VSS NMOS L=1u W=3.4u AS=6.12p AD=6.46p PS=7u PD=7.2u
* device instance $2999 m0 *1 428.4,53.5 NMOS
XM$2999 VSS \$I4577 \$I4576 VSS NMOS L=1u W=3.4u AS=6.46p AD=6.12p PS=7.2u PD=7u
* device instance $3000 m0 *1 433,53.5 NMOS
XM$3000 \$I4576 WL1 BLB17 VSS NMOS L=1u W=3.4u AS=6.12p AD=9.52p PS=7u PD=12.4u
* device instance $3001 m0 *1 423.6,92.3 PMOS
XM$3001 \$I4579 \$I4578 VDD VDD PMOS L=1u W=3.4u AS=10.88p AD=6.46p PS=13.2u
+ PD=7.2u
* device instance $3002 m0 *1 428.4,92.3 PMOS
XM$3002 VDD \$I4579 \$I4578 VDD PMOS L=1u W=3.4u AS=6.46p AD=10.88p PS=7.2u
+ PD=13.2u
* device instance $3003 m0 *1 419,112.7 NMOS
XM$3003 BL17 WL3 \$I4579 VSS NMOS L=1u W=3.4u AS=9.52p AD=6.12p PS=12.4u PD=7u
* device instance $3004 m0 *1 423.6,112.7 NMOS
XM$3004 \$I4579 \$I4578 VSS VSS NMOS L=1u W=3.4u AS=6.12p AD=6.46p PS=7u PD=7.2u
* device instance $3005 m0 *1 428.4,112.7 NMOS
XM$3005 VSS \$I4579 \$I4578 VSS NMOS L=1u W=3.4u AS=6.46p AD=6.12p PS=7.2u PD=7u
* device instance $3006 m0 *1 433,112.7 NMOS
XM$3006 \$I4578 WL3 BLB17 VSS NMOS L=1u W=3.4u AS=6.12p AD=9.52p PS=7u PD=12.4u
* device instance $3007 m0 *1 423.6,447.5 PMOS
XM$3007 \$I4581 \$I4580 VDD VDD PMOS L=1u W=3.4u AS=10.88p AD=6.46p PS=13.2u
+ PD=7.2u
* device instance $3008 m0 *1 428.4,447.5 PMOS
XM$3008 VDD \$I4581 \$I4580 VDD PMOS L=1u W=3.4u AS=6.46p AD=10.88p PS=7.2u
+ PD=13.2u
* device instance $3009 m0 *1 419,467.9 NMOS
XM$3009 BL17 WL15 \$I4581 VSS NMOS L=1u W=3.4u AS=9.52p AD=6.12p PS=12.4u PD=7u
* device instance $3010 m0 *1 423.6,467.9 NMOS
XM$3010 \$I4581 \$I4580 VSS VSS NMOS L=1u W=3.4u AS=6.12p AD=6.46p PS=7u PD=7.2u
* device instance $3011 m0 *1 428.4,467.9 NMOS
XM$3011 VSS \$I4581 \$I4580 VSS NMOS L=1u W=3.4u AS=6.46p AD=6.12p PS=7.2u PD=7u
* device instance $3012 m0 *1 433,467.9 NMOS
XM$3012 \$I4580 WL15 BLB17 VSS NMOS L=1u W=3.4u AS=6.12p AD=9.52p PS=7u PD=12.4u
* device instance $3013 m0 *1 423.6,210.7 PMOS
XM$3013 \$I4583 \$I4582 VDD VDD PMOS L=1u W=3.4u AS=10.88p AD=6.46p PS=13.2u
+ PD=7.2u
* device instance $3014 m0 *1 428.4,210.7 PMOS
XM$3014 VDD \$I4583 \$I4582 VDD PMOS L=1u W=3.4u AS=6.46p AD=10.88p PS=7.2u
+ PD=13.2u
* device instance $3015 m0 *1 419,231.1 NMOS
XM$3015 BL17 WL7 \$I4583 VSS NMOS L=1u W=3.4u AS=9.52p AD=6.12p PS=12.4u PD=7u
* device instance $3016 m0 *1 423.6,231.1 NMOS
XM$3016 \$I4583 \$I4582 VSS VSS NMOS L=1u W=3.4u AS=6.12p AD=6.46p PS=7u PD=7.2u
* device instance $3017 m0 *1 428.4,231.1 NMOS
XM$3017 VSS \$I4583 \$I4582 VSS NMOS L=1u W=3.4u AS=6.46p AD=6.12p PS=7.2u PD=7u
* device instance $3018 m0 *1 433,231.1 NMOS
XM$3018 \$I4582 WL7 BLB17 VSS NMOS L=1u W=3.4u AS=6.12p AD=9.52p PS=7u PD=12.4u
* device instance $3019 m0 *1 423.6,388.3 PMOS
XM$3019 \$I4585 \$I4584 VDD VDD PMOS L=1u W=3.4u AS=10.88p AD=6.46p PS=13.2u
+ PD=7.2u
* device instance $3020 m0 *1 428.4,388.3 PMOS
XM$3020 VDD \$I4585 \$I4584 VDD PMOS L=1u W=3.4u AS=6.46p AD=10.88p PS=7.2u
+ PD=13.2u
* device instance $3021 m0 *1 419,408.7 NMOS
XM$3021 BL17 WL13 \$I4585 VSS NMOS L=1u W=3.4u AS=9.52p AD=6.12p PS=12.4u PD=7u
* device instance $3022 m0 *1 423.6,408.7 NMOS
XM$3022 \$I4585 \$I4584 VSS VSS NMOS L=1u W=3.4u AS=6.12p AD=6.46p PS=7u PD=7.2u
* device instance $3023 m0 *1 428.4,408.7 NMOS
XM$3023 VSS \$I4585 \$I4584 VSS NMOS L=1u W=3.4u AS=6.46p AD=6.12p PS=7.2u PD=7u
* device instance $3024 m0 *1 433,408.7 NMOS
XM$3024 \$I4584 WL13 BLB17 VSS NMOS L=1u W=3.4u AS=6.12p AD=9.52p PS=7u PD=12.4u
* device instance $3025 m0 *1 423.6,151.5 PMOS
XM$3025 \$I4587 \$I4586 VDD VDD PMOS L=1u W=3.4u AS=10.88p AD=6.46p PS=13.2u
+ PD=7.2u
* device instance $3026 m0 *1 428.4,151.5 PMOS
XM$3026 VDD \$I4587 \$I4586 VDD PMOS L=1u W=3.4u AS=6.46p AD=10.88p PS=7.2u
+ PD=13.2u
* device instance $3027 m0 *1 419,171.9 NMOS
XM$3027 BL17 WL5 \$I4587 VSS NMOS L=1u W=3.4u AS=9.52p AD=6.12p PS=12.4u PD=7u
* device instance $3028 m0 *1 423.6,171.9 NMOS
XM$3028 \$I4587 \$I4586 VSS VSS NMOS L=1u W=3.4u AS=6.12p AD=6.46p PS=7u PD=7.2u
* device instance $3029 m0 *1 428.4,171.9 NMOS
XM$3029 VSS \$I4587 \$I4586 VSS NMOS L=1u W=3.4u AS=6.46p AD=6.12p PS=7.2u PD=7u
* device instance $3030 m0 *1 433,171.9 NMOS
XM$3030 \$I4586 WL5 BLB17 VSS NMOS L=1u W=3.4u AS=6.12p AD=9.52p PS=7u PD=12.4u
* device instance $3031 r0 *1 423.6,381.3 PMOS
XM$3031 \$I4589 \$I4588 VDD VDD PMOS L=1u W=3.4u AS=10.88p AD=6.46p PS=13.2u
+ PD=7.2u
* device instance $3032 r0 *1 428.4,381.3 PMOS
XM$3032 VDD \$I4589 \$I4588 VDD PMOS L=1u W=3.4u AS=6.46p AD=10.88p PS=7.2u
+ PD=13.2u
* device instance $3033 r0 *1 419,360.9 NMOS
XM$3033 BL17 WL12 \$I4589 VSS NMOS L=1u W=3.4u AS=9.52p AD=6.12p PS=12.4u PD=7u
* device instance $3034 r0 *1 423.6,360.9 NMOS
XM$3034 \$I4589 \$I4588 VSS VSS NMOS L=1u W=3.4u AS=6.12p AD=6.46p PS=7u PD=7.2u
* device instance $3035 r0 *1 428.4,360.9 NMOS
XM$3035 VSS \$I4589 \$I4588 VSS NMOS L=1u W=3.4u AS=6.46p AD=6.12p PS=7.2u PD=7u
* device instance $3036 r0 *1 433,360.9 NMOS
XM$3036 \$I4588 WL12 BLB17 VSS NMOS L=1u W=3.4u AS=6.12p AD=9.52p PS=7u PD=12.4u
* device instance $3037 r0 *1 423.6,262.9 PMOS
XM$3037 \$I4591 \$I4590 VDD VDD PMOS L=1u W=3.4u AS=10.88p AD=6.46p PS=13.2u
+ PD=7.2u
* device instance $3038 r0 *1 428.4,262.9 PMOS
XM$3038 VDD \$I4591 \$I4590 VDD PMOS L=1u W=3.4u AS=6.46p AD=10.88p PS=7.2u
+ PD=13.2u
* device instance $3039 r0 *1 419,242.5 NMOS
XM$3039 BL17 WL8 \$I4591 VSS NMOS L=1u W=3.4u AS=9.52p AD=6.12p PS=12.4u PD=7u
* device instance $3040 r0 *1 423.6,242.5 NMOS
XM$3040 \$I4591 \$I4590 VSS VSS NMOS L=1u W=3.4u AS=6.12p AD=6.46p PS=7u PD=7.2u
* device instance $3041 r0 *1 428.4,242.5 NMOS
XM$3041 VSS \$I4591 \$I4590 VSS NMOS L=1u W=3.4u AS=6.46p AD=6.12p PS=7.2u PD=7u
* device instance $3042 r0 *1 433,242.5 NMOS
XM$3042 \$I4590 WL8 BLB17 VSS NMOS L=1u W=3.4u AS=6.12p AD=9.52p PS=7u PD=12.4u
* device instance $3043 r0 *1 423.6,440.5 PMOS
XM$3043 \$I4593 \$I4592 VDD VDD PMOS L=1u W=3.4u AS=10.88p AD=6.46p PS=13.2u
+ PD=7.2u
* device instance $3044 r0 *1 428.4,440.5 PMOS
XM$3044 VDD \$I4593 \$I4592 VDD PMOS L=1u W=3.4u AS=6.46p AD=10.88p PS=7.2u
+ PD=13.2u
* device instance $3045 r0 *1 419,420.1 NMOS
XM$3045 BL17 WL14 \$I4593 VSS NMOS L=1u W=3.4u AS=9.52p AD=6.12p PS=12.4u PD=7u
* device instance $3046 r0 *1 423.6,420.1 NMOS
XM$3046 \$I4593 \$I4592 VSS VSS NMOS L=1u W=3.4u AS=6.12p AD=6.46p PS=7u PD=7.2u
* device instance $3047 r0 *1 428.4,420.1 NMOS
XM$3047 VSS \$I4593 \$I4592 VSS NMOS L=1u W=3.4u AS=6.46p AD=6.12p PS=7.2u PD=7u
* device instance $3048 r0 *1 433,420.1 NMOS
XM$3048 \$I4592 WL14 BLB17 VSS NMOS L=1u W=3.4u AS=6.12p AD=9.52p PS=7u PD=12.4u
* device instance $3049 r0 *1 423.6,322.1 PMOS
XM$3049 \$I4595 \$I4594 VDD VDD PMOS L=1u W=3.4u AS=10.88p AD=6.46p PS=13.2u
+ PD=7.2u
* device instance $3050 r0 *1 428.4,322.1 PMOS
XM$3050 VDD \$I4595 \$I4594 VDD PMOS L=1u W=3.4u AS=6.46p AD=10.88p PS=7.2u
+ PD=13.2u
* device instance $3051 r0 *1 419,301.7 NMOS
XM$3051 BL17 WL10 \$I4595 VSS NMOS L=1u W=3.4u AS=9.52p AD=6.12p PS=12.4u PD=7u
* device instance $3052 r0 *1 423.6,301.7 NMOS
XM$3052 \$I4595 \$I4594 VSS VSS NMOS L=1u W=3.4u AS=6.12p AD=6.46p PS=7u PD=7.2u
* device instance $3053 r0 *1 428.4,301.7 NMOS
XM$3053 VSS \$I4595 \$I4594 VSS NMOS L=1u W=3.4u AS=6.46p AD=6.12p PS=7.2u PD=7u
* device instance $3054 r0 *1 433,301.7 NMOS
XM$3054 \$I4594 WL10 BLB17 VSS NMOS L=1u W=3.4u AS=6.12p AD=9.52p PS=7u PD=12.4u
* device instance $3055 r0 *1 423.6,203.7 PMOS
XM$3055 \$I4597 \$I4596 VDD VDD PMOS L=1u W=3.4u AS=10.88p AD=6.46p PS=13.2u
+ PD=7.2u
* device instance $3056 r0 *1 428.4,203.7 PMOS
XM$3056 VDD \$I4597 \$I4596 VDD PMOS L=1u W=3.4u AS=6.46p AD=10.88p PS=7.2u
+ PD=13.2u
* device instance $3057 r0 *1 419,183.3 NMOS
XM$3057 BL17 WL6 \$I4597 VSS NMOS L=1u W=3.4u AS=9.52p AD=6.12p PS=12.4u PD=7u
* device instance $3058 r0 *1 423.6,183.3 NMOS
XM$3058 \$I4597 \$I4596 VSS VSS NMOS L=1u W=3.4u AS=6.12p AD=6.46p PS=7u PD=7.2u
* device instance $3059 r0 *1 428.4,183.3 NMOS
XM$3059 VSS \$I4597 \$I4596 VSS NMOS L=1u W=3.4u AS=6.46p AD=6.12p PS=7.2u PD=7u
* device instance $3060 r0 *1 433,183.3 NMOS
XM$3060 \$I4596 WL6 BLB17 VSS NMOS L=1u W=3.4u AS=6.12p AD=9.52p PS=7u PD=12.4u
* device instance $3061 r0 *1 423.6,144.5 PMOS
XM$3061 \$I4599 \$I4598 VDD VDD PMOS L=1u W=3.4u AS=10.88p AD=6.46p PS=13.2u
+ PD=7.2u
* device instance $3062 r0 *1 428.4,144.5 PMOS
XM$3062 VDD \$I4599 \$I4598 VDD PMOS L=1u W=3.4u AS=6.46p AD=10.88p PS=7.2u
+ PD=13.2u
* device instance $3063 r0 *1 419,124.1 NMOS
XM$3063 BL17 WL4 \$I4599 VSS NMOS L=1u W=3.4u AS=9.52p AD=6.12p PS=12.4u PD=7u
* device instance $3064 r0 *1 423.6,124.1 NMOS
XM$3064 \$I4599 \$I4598 VSS VSS NMOS L=1u W=3.4u AS=6.12p AD=6.46p PS=7u PD=7.2u
* device instance $3065 r0 *1 428.4,124.1 NMOS
XM$3065 VSS \$I4599 \$I4598 VSS NMOS L=1u W=3.4u AS=6.46p AD=6.12p PS=7.2u PD=7u
* device instance $3066 r0 *1 433,124.1 NMOS
XM$3066 \$I4598 WL4 BLB17 VSS NMOS L=1u W=3.4u AS=6.12p AD=9.52p PS=7u PD=12.4u
* device instance $3067 r0 *1 423.6,85.3 PMOS
XM$3067 \$I4601 \$I4600 VDD VDD PMOS L=1u W=3.4u AS=10.88p AD=6.46p PS=13.2u
+ PD=7.2u
* device instance $3068 r0 *1 428.4,85.3 PMOS
XM$3068 VDD \$I4601 \$I4600 VDD PMOS L=1u W=3.4u AS=6.46p AD=10.88p PS=7.2u
+ PD=13.2u
* device instance $3069 r0 *1 419,64.9 NMOS
XM$3069 BL17 WL2 \$I4601 VSS NMOS L=1u W=3.4u AS=9.52p AD=6.12p PS=12.4u PD=7u
* device instance $3070 r0 *1 423.6,64.9 NMOS
XM$3070 \$I4601 \$I4600 VSS VSS NMOS L=1u W=3.4u AS=6.12p AD=6.46p PS=7u PD=7.2u
* device instance $3071 r0 *1 428.4,64.9 NMOS
XM$3071 VSS \$I4601 \$I4600 VSS NMOS L=1u W=3.4u AS=6.46p AD=6.12p PS=7.2u PD=7u
* device instance $3072 r0 *1 433,64.9 NMOS
XM$3072 \$I4600 WL2 BLB17 VSS NMOS L=1u W=3.4u AS=6.12p AD=9.52p PS=7u PD=12.4u
.ENDS compact_strap8_16x32

.subckt sense_amp_7t BL BLB SAE SOUT SOUTB VDD VSS
*.ipin BL
*.ipin BLB
*.opin SOUT
*.opin SOUTB
*.iopin VSS
*.iopin VDD
*.ipin SAE
XXP_ISO_L SOUT SAE BL VDD PMOS w=3.4u l=1u nrd=0 nrs=0
XXP_ISO_R SOUTB SAE BLB VDD PMOS w=3.4u l=1u nrd=0 nrs=0
XXP_L SOUT SOUTB VDD VDD PMOS w=3.4u l=1u nrd=0 nrs=0
XXN_L SOUT SOUTB net1 VSS NMOS w=3.4u l=1u nrd=0 nrs=0
XXP_R SOUTB SOUT VDD VDD PMOS w=3.4u l=1u nrd=0 nrs=0
XXN_R SOUTB SOUT net1 VSS NMOS w=3.4u l=1u nrd=0 nrs=0
XXN_TAIL net1 SAE VSS VSS NMOS w=3.4u l=1u nrd=0 nrs=0
.ends
.subckt write_control DIN WRITE_EN PD_Y PD_YB VDD VSS
*.ipin DIN
*.ipin WRITE_EN
*.opin PD_Y
*.opin PD_YB
*.iopin VDD
*.iopin VSS
xdin_inv VDD DIN DIN_B VSS INV_X1
xdec0 VDD PD_Y_B DIN_B WRITE_EN VSS NAND2
xdrv0 VDD PD_Y_B PD_Y VSS INV_X1
xdec1 VDD PD_YB_B DIN WRITE_EN VSS NAND2
xdrv1 VDD PD_YB_B PD_YB VSS INV_X1
.ends
.subckt INV_X1 VDD A Y GND
*.ipin A
*.opin Y
*.iopin GND
*.iopin VDD
XM7 Y A VDD VDD PMOS w=10.2u l=1u nrd=0 nrs=0
XM2 Y A GND GND NMOS w=3.4u l=1u nrd=0 nrs=0
.ends
.subckt NAND2 VDD Y A B GND
*.ipin B
*.ipin A
*.opin Y
*.iopin GND
*.iopin VDD
XM7 Y A VDD VDD PMOS w=10.2u l=1u nrd=0 nrs=0
XM1 Y B VDD VDD PMOS w=10.2u l=1u nrd=0 nrs=0
XM2 Y B net1 GND NMOS w=3.4u l=1u nrd=0 nrs=0
XM3 net1 A GND GND NMOS w=3.4u l=1u nrd=0 nrs=0
.ends
.subckt AND2_X1 VDD Y A B GND
*.opin Y
*.ipin A
*.ipin B
*.iopin VDD
*.iopin GND
XM7 net1 B VDD VDD PMOS w=10.2u l=1u nrd=0 nrs=0
XM1 net1 A VDD VDD PMOS w=10.2u l=1u nrd=0 nrs=0
XM2 Y net1 VDD VDD PMOS w=10.2u l=1u nrd=0 nrs=0
XM3 Y net1 GND GND NMOS w=3.4u l=1u nrd=0 nrs=0
XM4 net1 A net2 GND NMOS w=3.4u l=1u nrd=0 nrs=0
XM5 net2 B GND GND NMOS w=3.4u l=1u nrd=0 nrs=0
.ends
.subckt DFFR VDD QB D Q RST GND CK
*.iopin VDD
*.iopin GND
*.ipin CK
*.ipin D
*.opin Q
*.opin QB
*.ipin RST
XM2 net2 D VDD VDD PMOS w=10.2u l=1u nrd=0 nrs=0
XM1 net3 CLK net2 VDD PMOS w=10.2u l=1u nrd=0 nrs=0
XM11 net5 net8 VDD VDD PMOS w=10.2u l=1u nrd=0 nrs=0
XM12 net3 CKB net5 VDD PMOS w=10.2u l=1u nrd=0 nrs=0
XM15 net7 net3 VDD VDD PMOS w=10.2u l=1u nrd=0 nrs=0
XM16 net8 RST net7 VDD PMOS w=10.2u l=1u nrd=0 nrs=0
XM18 net9 net8 VDD VDD PMOS w=10.2u l=1u nrd=0 nrs=0
XM19 net10 CKB net9 VDD PMOS w=10.2u l=1u nrd=0 nrs=0
XM23 net12 net14 VDD VDD PMOS w=10.2u l=1u nrd=0 nrs=0
XM24 net10 CLK net12 VDD PMOS w=10.2u l=1u nrd=0 nrs=0
XM27 net15 net10 VDD VDD PMOS w=10.2u l=1u nrd=0 nrs=0
XM28 net14 RST net15 VDD PMOS w=10.2u l=1u nrd=0 nrs=0
XM31 QB net14 VDD VDD PMOS w=10.2u l=1u nrd=0 nrs=0
XM33 Q QB VDD VDD PMOS w=10.2u l=1u nrd=0 nrs=0
XM35 QB net14 GND GND NMOS w=3.4u l=1u nrd=0 nrs=0
XM32 Q QB GND GND NMOS w=3.4u l=1u nrd=0 nrs=0
XM29 net14 RST GND GND NMOS w=3.4u l=1u nrd=0 nrs=0
XM30 net14 net10 GND GND NMOS w=3.4u l=1u nrd=0 nrs=0
XM25 net10 CKB net13 GND NMOS w=3.4u l=1u nrd=0 nrs=0
XM26 net13 net14 GND GND NMOS w=3.4u l=1u nrd=0 nrs=0
XM20 net10 CLK net11 GND NMOS w=3.4u l=1u nrd=0 nrs=0
XM21 net11 net8 GND GND NMOS w=3.4u l=1u nrd=0 nrs=0
XM17 net8 net3 GND GND NMOS w=3.4u l=1u nrd=0 nrs=0
XM22 net8 RST GND GND NMOS w=3.4u l=1u nrd=0 nrs=0
XM13 net3 CLK net6 GND NMOS w=3.4u l=1u nrd=0 nrs=0
XM14 net6 net8 GND GND NMOS w=3.4u l=1u nrd=0 nrs=0
XM7 net3 CKB net4 GND NMOS w=3.4u l=1u nrd=0 nrs=0
XM8 net4 D GND GND NMOS w=3.4u l=1u nrd=0 nrs=0
XM3 net1 CK VDD VDD PMOS w=10.2u l=1u nrd=0 nrs=0
XM4 CLK net1 VDD VDD PMOS w=10.2u l=1u nrd=0 nrs=0
XM5 CKB CLK VDD VDD PMOS w=10.2u l=1u nrd=0 nrs=0
XM34 net1 CK GND GND NMOS w=3.4u l=1u nrd=0 nrs=0
XM6 CLK net1 GND GND NMOS w=3.4u l=1u nrd=0 nrs=0
XM9 CKB CLK GND GND NMOS w=3.4u l=1u nrd=0 nrs=0
.ends
.subckt XOR2 VDD Y A B GND
*.iopin VDD
*.iopin GND
*.ipin A
*.ipin B
*.opin Y
XM10 net1 A VDD VDD PMOS w=10.2u l=1u nrd=0 nrs=0
XM1 net2 B net1 VDD PMOS w=10.2u l=1u nrd=0 nrs=0
XM8 net3 B VDD VDD PMOS w=10.2u l=1u nrd=0 nrs=0
XM2 net3 A VDD VDD PMOS w=10.2u l=1u nrd=0 nrs=0
XM9 Y net2 net3 VDD PMOS w=10.2u l=1u nrd=0 nrs=0
XM3 net2 A GND GND NMOS w=3.4u l=1u nrd=0 nrs=0
XM4 net2 B GND GND NMOS w=3.4u l=1u nrd=0 nrs=0
XM5 Y net2 GND GND NMOS w=3.4u l=1u nrd=0 nrs=0
XM7 net4 B GND GND NMOS w=3.4u l=1u nrd=0 nrs=0
XM6 Y A net4 GND NMOS w=3.4u l=1u nrd=0 nrs=0
.ends
.subckt AND3_X1 C VDD Y A B GND
*.opin Y
*.ipin A
*.ipin B
*.iopin VDD
*.iopin GND
*.ipin C
XM4 net1 C VDD VDD PMOS w=10.2u l=1u nrd=0 nrs=0
XM2 net1 B VDD VDD PMOS w=10.2u l=1u nrd=0 nrs=0
XM3 Y net1 VDD VDD PMOS w=10.2u l=1u nrd=0 nrs=0
XM1 VDD A net1 VDD PMOS w=10.2u l=1u nrd=0 nrs=0
XM8 Y net1 GND GND NMOS w=3.4u l=1u nrd=0 nrs=0
XM5 net1 A net3 GND NMOS w=3.4u l=1u nrd=0 nrs=0
XM6 net3 B net2 GND NMOS w=3.4u l=1u nrd=0 nrs=0
XM7 net2 C GND GND NMOS w=3.4u l=1u nrd=0 nrs=0
.ends
.subckt OR2 VDD Y A B GND
*.ipin A
*.ipin B
*.opin Y
*.iopin VDD
*.iopin GND
XM7 net2 B VDD VDD PMOS w=10.2u l=1u nrd=0 nrs=0
XM2 net1 A net2 VDD PMOS w=10.2u l=1u nrd=0 nrs=0
XM4 Y net1 VDD VDD PMOS w=10.2u l=1u nrd=0 nrs=0
XM1 net1 B GND GND NMOS w=3.4u l=1u nrd=0 nrs=0
XM3 net1 A GND GND NMOS w=3.4u l=1u nrd=0 nrs=0
XM5 Y net1 GND GND NMOS w=3.4u l=1u nrd=0 nrs=0
.ends
.subckt AND4_X1 D C VDD Y A B GND
*.opin Y
*.ipin A
*.ipin B
*.iopin VDD
*.iopin GND
*.ipin C
*.ipin D
XM7 net1 A net4 GND NMOS w=3.4u l=1u nrd=0 nrs=0
XM5 net3 C net2 GND NMOS w=3.4u l=1u nrd=0 nrs=0
XM8 Y net1 GND GND NMOS w=3.4u l=1u nrd=0 nrs=0
XM10 net2 D GND GND NMOS w=3.4u l=1u nrd=0 nrs=0
XM6 net4 B net3 GND NMOS w=3.4u l=1u nrd=0 nrs=0
XM11 net1 A VDD VDD PMOS w=10.2u l=1u nrd=0 nrs=0
XM1 net1 D VDD VDD PMOS w=10.2u l=1u nrd=0 nrs=0
XM3 net1 C VDD VDD PMOS w=10.2u l=1u nrd=0 nrs=0
XM4 Y net1 VDD VDD PMOS w=10.2u l=1u nrd=0 nrs=0
XM2 net1 B VDD VDD PMOS w=10.2u l=1u nrd=0 nrs=0
.ends
.subckt OR4 A B C D VDD Y GND
*.ipin B
*.ipin A
*.opin Y
*.iopin VDD
*.iopin GND
*.ipin C
*.ipin D
XM10 net1 B VDD VDD PMOS w=10.2u l=1u nrd=0 nrs=0
XM2 net2 A net1 VDD PMOS w=10.2u l=1u nrd=0 nrs=0
XM3 net4 C net2 VDD PMOS w=10.2u l=1u nrd=0 nrs=0
XM7 Y net3 VDD VDD PMOS w=10.2u l=1u nrd=0 nrs=0
XM9 net4 D net3 VDD PMOS w=10.2u l=1u nrd=0 nrs=0
XM11 net3 A GND GND NMOS w=3.4u l=1u nrd=0 nrs=0
XM1 net3 B GND GND NMOS w=3.4u l=1u nrd=0 nrs=0
XM4 net3 C GND GND NMOS w=3.4u l=1u nrd=0 nrs=0
XM5 net3 D GND GND NMOS w=3.4u l=1u nrd=0 nrs=0
XM6 Y net3 GND GND NMOS w=3.4u l=1u nrd=0 nrs=0
.ends
.subckt OR3 C VDD Y A B GND
*.ipin A
*.ipin B
*.opin Y
*.iopin VDD
*.iopin GND
*.ipin C
XM8 net1 B VDD VDD PMOS w=10.2u l=1u nrd=0 nrs=0
XM2 net2 A net1 VDD PMOS w=10.2u l=1u nrd=0 nrs=0
XM3 net3 C net2 VDD PMOS w=10.2u l=1u nrd=0 nrs=0
XM7 Y net3 VDD VDD PMOS w=10.2u l=1u nrd=0 nrs=0
XM9 Y net3 GND GND NMOS w=3.4u l=1u nrd=0 nrs=0
XM1 net3 C GND GND NMOS w=3.4u l=1u nrd=0 nrs=0
XM4 net3 A GND GND NMOS w=3.4u l=1u nrd=0 nrs=0
XM5 net3 B GND GND NMOS w=3.4u l=1u nrd=0 nrs=0
.ends
.subckt MUX2 A B S VDD Y GND
*.ipin B
*.ipin S
*.opin Y
*.iopin VDD
*.iopin GND
*.ipin A
XM13 net1 S VDD VDD PMOS w=6.8u l=1u nrd=0 nrs=0
XM9 net2 B VDD VDD PMOS w=6.8u l=1u nrd=0 nrs=0
XM8 net4 net1 net2 VDD PMOS w=6.8u l=1u nrd=0 nrs=0
XM10 Y net4 VDD VDD PMOS w=5.1u l=1u nrd=0 nrs=0 m=2
XM2 net4 S net3 VDD PMOS w=6.8u l=1u nrd=0 nrs=0
XM12 net1 S GND GND NMOS w=3.4u l=1u nrd=0 nrs=0
XM3 net2 B GND GND NMOS w=3.4u l=1u nrd=0 nrs=0
XM1 Y net4 GND GND NMOS w=3.4u l=1u nrd=0 nrs=0
XM5 net3 A GND GND NMOS w=3.4u l=1u nrd=0 nrs=0
XM6 net4 S net2 GND NMOS w=3.4u l=1u nrd=0 nrs=0 m=2
XM4 net4 net1 net3 GND NMOS w=3.4u l=1u nrd=0 nrs=0 m=2
XM7 net3 A VDD VDD PMOS w=6.8u l=1u nrd=0 nrs=0
.ends
