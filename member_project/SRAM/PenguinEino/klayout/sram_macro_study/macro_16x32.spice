.subckt serial_macro_16x32 CLK RESET SDI WE SDO VDD VSS
Xg1 C3B C2B VDD logic1 C0B C1B VSS AND4_X1
Xg2 VDD logic2 logic1 C4 VSS AND2_X1
Xg3 VDD logic3 logic2 C4B VSS OR2
Xg4 VDD logic4 C0B logic3 VSS AND2_X1
Xff_C0 VDD C0B logic4 C0 RESET VSS CLK DFFR
Xg6 VDD toggle1 C1 C0 VSS XOR2
Xg7 VDD logic7 toggle1 logic3 VSS AND2_X1
Xff_C1 VDD C1B logic7 C1 RESET VSS CLK DFFR
Xg9 VDD logic9 C0 C1 VSS AND2_X1
Xg10 VDD toggle2 C2 logic9 VSS XOR2
Xg11 VDD logic11 toggle2 logic3 VSS AND2_X1
Xff_C2 VDD C2B logic11 C2 RESET VSS CLK DFFR
Xg13 C2 VDD logic13 C0 C1 VSS AND3_X1
Xg14 VDD toggle3 C3 logic13 VSS XOR2
Xg15 VDD logic15 toggle3 logic3 VSS AND2_X1
Xff_C3 VDD C3B logic15 C3 RESET VSS CLK DFFR
Xg17 C3 C2 VDD logic17 C0 C1 VSS AND4_X1
Xg18 VDD toggle4 C4 logic17 VSS XOR2
Xg19 VDD logic19 toggle4 logic3 VSS AND2_X1
Xff_C4 VDD C4B logic19 C4 RESET VSS CLK DFFR
Xg21 C4B C3 VDD logic21 C1B C2B VSS AND4_X1
Xg22 VDD logic22 C3B C4B VSS AND2_X1
Xg23 VDD logic23 logic21 logic22 VSS OR2
Xg24 C3 C2B VDD logic24 C0B C1 VSS AND4_X1
Xg25 VDD logic25 logic24 C4B VSS AND2_X1
Xg26 C3 C2B VDD logic26 C0 C1 VSS AND4_X1
Xg27 VDD logic27 logic26 C4B VSS AND2_X1
Xg28 C3 C2 VDD logic28 C0B C1B VSS AND4_X1
Xg29 VDD logic29 logic28 C4B VSS AND2_X1
Xg30 C3 C2 VDD logic30 C0 C1B VSS AND4_X1
Xg31 VDD logic31 logic30 C4B VSS AND2_X1
Xg32 C3 C2 VDD logic32 C0B C1 VSS AND4_X1
Xg33 VDD logic33 logic32 C4B VSS AND2_X1
Xg34 C3 C2 VDD logic34 C0 C1 VSS AND4_X1
Xg35 VDD logic35 logic34 C4B VSS AND2_X1
Xg36 C3B C2B VDD logic36 C0B C1B VSS AND4_X1
Xg37 VDD logic37 logic36 C4 VSS AND2_X1
Xg38 C3B C2B VDD logic38 C0 C1B VSS AND4_X1
Xg39 VDD logic39 logic38 C4 VSS AND2_X1
Xff_PC_ON VDD PREB logic25 PC_ON RESET VSS CLK DFFR
Xg41 VDD logic41 logic31 logic33 VSS OR2
Xff_WL_EN VDD WL_ENB logic41 WL_EN RESET VSS CLK DFFR
Xg43 logic29 logic31 logic33 logic35 VDD logic43 VSS OR4
Xg44 VDD logic44 logic43 W VSS AND2_X1
Xff_WRITE_EN VDD WRITE_ENB logic44 WRITE_EN RESET VSS CLK DFFR
Xg46 VDD WE WE_B VSS INV_X1
Xg47 VDD logic47 WE_B logic25 VSS AND2_X1
Xg48 logic31 VDD logic48 logic27 logic29 VSS OR3
Xg49 VDD logic49 logic48 WB VSS AND2_X1
Xg50 VDD logic50 logic47 logic49 VSS OR2
Xff_TRACK VDD SAE logic50 TRACK RESET VSS CLK DFFR
Xg52 SR0 SDI logic23 VDD SR0_next VSS MUX2
Xff_SR0 VDD SR0B SR0_next SR0 RESET VSS CLK DFFR
Xg54 SR1 SR0 logic23 VDD SR1_next VSS MUX2
Xff_SR1 VDD SR1B SR1_next SR1 RESET VSS CLK DFFR
Xg56 SR2 SR1 logic23 VDD SR2_next VSS MUX2
Xff_SR2 VDD SR2B SR2_next SR2 RESET VSS CLK DFFR
Xg58 SR3 SR2 logic23 VDD SR3_next VSS MUX2
Xff_SR3 VDD SR3B SR3_next SR3 RESET VSS CLK DFFR
Xg60 SR4 SR3 logic23 VDD SR4_next VSS MUX2
Xff_SR4 VDD SR4B SR4_next SR4 RESET VSS CLK DFFR
Xg62 SR5 SR4 logic23 VDD SR5_next VSS MUX2
Xff_SR5 VDD SR5B SR5_next SR5 RESET VSS CLK DFFR
Xg64 SR6 SR5 logic23 VDD SR6_next VSS MUX2
Xff_SR6 VDD SR6B SR6_next SR6 RESET VSS CLK DFFR
Xg66 SR7 SR6 logic23 VDD SR7_next VSS MUX2
Xff_SR7 VDD SR7B SR7_next SR7 RESET VSS CLK DFFR
Xg68 SR8 SR7 logic23 VDD SR8_next VSS MUX2
Xff_SR8 VDD SR8B SR8_next SR8 RESET VSS CLK DFFR
Xg70 SR9 SR8 logic23 VDD SR9_next VSS MUX2
Xff_SR9 VDD SR9B SR9_next SR9 RESET VSS CLK DFFR
Xg72 DIN SR0 logic25 VDD DIN_next VSS MUX2
Xff_DIN VDD DINB DIN_next DIN RESET VSS CLK DFFR
Xg74 CA0 SR1 logic25 VDD CA0_next VSS MUX2
Xff_CA0 VDD CA0B CA0_next CA0 RESET VSS CLK DFFR
Xg76 CA1 SR2 logic25 VDD CA1_next VSS MUX2
Xff_CA1 VDD CA1B CA1_next CA1 RESET VSS CLK DFFR
Xg78 CA2 SR3 logic25 VDD CA2_next VSS MUX2
Xff_CA2 VDD CA2B CA2_next CA2 RESET VSS CLK DFFR
Xg80 CA3 SR4 logic25 VDD CA3_next VSS MUX2
Xff_CA3 VDD CA3B CA3_next CA3 RESET VSS CLK DFFR
Xg82 CA4 SR5 logic25 VDD CA4_next VSS MUX2
Xff_CA4 VDD CA4B CA4_next CA4 RESET VSS CLK DFFR
Xg84 RA0 SR6 logic25 VDD RA0_next VSS MUX2
Xff_RA0 VDD RA0B RA0_next RA0 RESET VSS CLK DFFR
Xg86 RA1 SR7 logic25 VDD RA1_next VSS MUX2
Xff_RA1 VDD RA1B RA1_next RA1 RESET VSS CLK DFFR
Xg88 RA2 SR8 logic25 VDD RA2_next VSS MUX2
Xff_RA2 VDD RA2B RA2_next RA2 RESET VSS CLK DFFR
Xg90 RA3 SR9 logic25 VDD RA3_next VSS MUX2
Xff_RA3 VDD RA3B RA3_next RA3 RESET VSS CLK DFFR
Xg92 W WE logic25 VDD W_next VSS MUX2
Xff_W VDD WB W_next W RESET VSS CLK DFFR
Xg94 VDD logic94 logic37 WB VSS AND2_X1
Xg95 SDO SOUT logic94 VDD SDO_next VSS MUX2
Xff_SDO VDD SDOB SDO_next SDO RESET VSS CLK DFFR
Xg97 VDD logic97 RA0B RA1B VSS AND2_X1
Xg98 VDD logic98 RA0 RA1B VSS AND2_X1
Xg99 VDD logic99 RA0B RA1 VSS AND2_X1
Xg100 VDD logic100 RA0 RA1 VSS AND2_X1
Xg101 VDD logic101 RA2B RA3B VSS AND2_X1
Xg102 VDD logic102 RA2 RA3B VSS AND2_X1
Xg103 VDD logic103 RA2B RA3 VSS AND2_X1
Xg104 VDD logic104 RA2 RA3 VSS AND2_X1
Xg105 WL_EN VDD WL0 logic97 logic101 VSS AND3_X1
Xg106 WL_EN VDD WL1 logic98 logic101 VSS AND3_X1
Xg107 WL_EN VDD WL2 logic99 logic101 VSS AND3_X1
Xg108 WL_EN VDD WL3 logic100 logic101 VSS AND3_X1
Xg109 WL_EN VDD WL4 logic97 logic102 VSS AND3_X1
Xg110 WL_EN VDD WL5 logic98 logic102 VSS AND3_X1
Xg111 WL_EN VDD WL6 logic99 logic102 VSS AND3_X1
Xg112 WL_EN VDD WL7 logic100 logic102 VSS AND3_X1
Xg113 WL_EN VDD WL8 logic97 logic103 VSS AND3_X1
Xg114 WL_EN VDD WL9 logic98 logic103 VSS AND3_X1
Xg115 WL_EN VDD WL10 logic99 logic103 VSS AND3_X1
Xg116 WL_EN VDD WL11 logic100 logic103 VSS AND3_X1
Xg117 WL_EN VDD WL12 logic97 logic104 VSS AND3_X1
Xg118 WL_EN VDD WL13 logic98 logic104 VSS AND3_X1
Xg119 WL_EN VDD WL14 logic99 logic104 VSS AND3_X1
Xg120 WL_EN VDD WL15 logic100 logic104 VSS AND3_X1
Xg121 VDD logic121 CA0B CA1B VSS AND2_X1
Xg122 VDD logic122 CA0 CA1B VSS AND2_X1
Xg123 VDD logic123 CA0B CA1 VSS AND2_X1
Xg124 VDD logic124 CA0 CA1 VSS AND2_X1
Xg125 CA4B VDD logic125 CA2B CA3B VSS AND3_X1
Xg126 CA4B VDD logic126 CA2 CA3B VSS AND3_X1
Xg127 CA4B VDD logic127 CA2B CA3 VSS AND3_X1
Xg128 CA4B VDD logic128 CA2 CA3 VSS AND3_X1
Xg129 CA4 VDD logic129 CA2B CA3B VSS AND3_X1
Xg130 CA4 VDD logic130 CA2 CA3B VSS AND3_X1
Xg131 CA4 VDD logic131 CA2B CA3 VSS AND3_X1
Xg132 CA4 VDD logic132 CA2 CA3 VSS AND3_X1
Xg133 VDD COL0 logic121 logic125 VSS AND2_X1
Xg134 VDD COL1 logic122 logic125 VSS AND2_X1
Xg135 VDD COL2 logic123 logic125 VSS AND2_X1
Xg136 VDD COL3 logic124 logic125 VSS AND2_X1
Xg137 VDD COL4 logic121 logic126 VSS AND2_X1
Xg138 VDD COL5 logic122 logic126 VSS AND2_X1
Xg139 VDD COL6 logic123 logic126 VSS AND2_X1
Xg140 VDD COL7 logic124 logic126 VSS AND2_X1
Xg141 VDD COL8 logic121 logic127 VSS AND2_X1
Xg142 VDD COL9 logic122 logic127 VSS AND2_X1
Xg143 VDD COL10 logic123 logic127 VSS AND2_X1
Xg144 VDD COL11 logic124 logic127 VSS AND2_X1
Xg145 VDD COL12 logic121 logic128 VSS AND2_X1
Xg146 VDD COL13 logic122 logic128 VSS AND2_X1
Xg147 VDD COL14 logic123 logic128 VSS AND2_X1
Xg148 VDD COL15 logic124 logic128 VSS AND2_X1
Xg149 VDD COL16 logic121 logic129 VSS AND2_X1
Xg150 VDD COL17 logic122 logic129 VSS AND2_X1
Xg151 VDD COL18 logic123 logic129 VSS AND2_X1
Xg152 VDD COL19 logic124 logic129 VSS AND2_X1
Xg153 VDD COL20 logic121 logic130 VSS AND2_X1
Xg154 VDD COL21 logic122 logic130 VSS AND2_X1
Xg155 VDD COL22 logic123 logic130 VSS AND2_X1
Xg156 VDD COL23 logic124 logic130 VSS AND2_X1
Xg157 VDD COL24 logic121 logic131 VSS AND2_X1
Xg158 VDD COL25 logic122 logic131 VSS AND2_X1
Xg159 VDD COL26 logic123 logic131 VSS AND2_X1
Xg160 VDD COL27 logic124 logic131 VSS AND2_X1
Xg161 VDD COL28 logic121 logic132 VSS AND2_X1
Xg162 VDD COL29 logic122 logic132 VSS AND2_X1
Xg163 VDD COL30 logic123 logic132 VSS AND2_X1
Xg164 VDD COL31 logic124 logic132 VSS AND2_X1
Xg165 DIN WRITE_EN PD_Y PD_YB VDD VSS write_control
Xmemory BL0 BL1 BL10 BL11 BL12 BL13 BL14 BL15 BL16 BL17 BL18 BL19 BL2 BL20 BL21 BL22 BL23 BL24 BL25 BL26 BL27 BL28 BL29 BL3 BL30 BL31 BL4 BL5 BL6 BL7 BL8 BL9 BLB0 BLB1 BLB10 BLB11 BLB12 BLB13 BLB14 BLB15 BLB16 BLB17 BLB18 BLB19 BLB2 BLB20 BLB21 BLB22 BLB23 BLB24 BLB25 BLB26 BLB27 BLB28 BLB29 BLB3 BLB30 BLB31 BLB4 BLB5 BLB6 BLB7 BLB8 BLB9 VDD VSS WL0 WL1 WL10 WL11 WL12 WL13 WL14 WL15 WL2 WL3 WL4 WL5 WL6 WL7 WL8 WL9 wlstrap16_16x32
XP_BL0 BL0 PREB VDD VDD PMOS W=10.2u L=1u
XM_BL0 BL0 COL0 Y VSS NMOS W=3.4u L=1u
XP_BLB0 BLB0 PREB VDD VDD PMOS W=10.2u L=1u
XM_BLB0 BLB0 COL0 YB VSS NMOS W=3.4u L=1u
XP_BL1 BL1 PREB VDD VDD PMOS W=10.2u L=1u
XM_BL1 BL1 COL1 Y VSS NMOS W=3.4u L=1u
XP_BLB1 BLB1 PREB VDD VDD PMOS W=10.2u L=1u
XM_BLB1 BLB1 COL1 YB VSS NMOS W=3.4u L=1u
XP_BL2 BL2 PREB VDD VDD PMOS W=10.2u L=1u
XM_BL2 BL2 COL2 Y VSS NMOS W=3.4u L=1u
XP_BLB2 BLB2 PREB VDD VDD PMOS W=10.2u L=1u
XM_BLB2 BLB2 COL2 YB VSS NMOS W=3.4u L=1u
XP_BL3 BL3 PREB VDD VDD PMOS W=10.2u L=1u
XM_BL3 BL3 COL3 Y VSS NMOS W=3.4u L=1u
XP_BLB3 BLB3 PREB VDD VDD PMOS W=10.2u L=1u
XM_BLB3 BLB3 COL3 YB VSS NMOS W=3.4u L=1u
XP_BL4 BL4 PREB VDD VDD PMOS W=10.2u L=1u
XM_BL4 BL4 COL4 Y VSS NMOS W=3.4u L=1u
XP_BLB4 BLB4 PREB VDD VDD PMOS W=10.2u L=1u
XM_BLB4 BLB4 COL4 YB VSS NMOS W=3.4u L=1u
XP_BL5 BL5 PREB VDD VDD PMOS W=10.2u L=1u
XM_BL5 BL5 COL5 Y VSS NMOS W=3.4u L=1u
XP_BLB5 BLB5 PREB VDD VDD PMOS W=10.2u L=1u
XM_BLB5 BLB5 COL5 YB VSS NMOS W=3.4u L=1u
XP_BL6 BL6 PREB VDD VDD PMOS W=10.2u L=1u
XM_BL6 BL6 COL6 Y VSS NMOS W=3.4u L=1u
XP_BLB6 BLB6 PREB VDD VDD PMOS W=10.2u L=1u
XM_BLB6 BLB6 COL6 YB VSS NMOS W=3.4u L=1u
XP_BL7 BL7 PREB VDD VDD PMOS W=10.2u L=1u
XM_BL7 BL7 COL7 Y VSS NMOS W=3.4u L=1u
XP_BLB7 BLB7 PREB VDD VDD PMOS W=10.2u L=1u
XM_BLB7 BLB7 COL7 YB VSS NMOS W=3.4u L=1u
XP_BL8 BL8 PREB VDD VDD PMOS W=10.2u L=1u
XM_BL8 BL8 COL8 Y VSS NMOS W=3.4u L=1u
XP_BLB8 BLB8 PREB VDD VDD PMOS W=10.2u L=1u
XM_BLB8 BLB8 COL8 YB VSS NMOS W=3.4u L=1u
XP_BL9 BL9 PREB VDD VDD PMOS W=10.2u L=1u
XM_BL9 BL9 COL9 Y VSS NMOS W=3.4u L=1u
XP_BLB9 BLB9 PREB VDD VDD PMOS W=10.2u L=1u
XM_BLB9 BLB9 COL9 YB VSS NMOS W=3.4u L=1u
XP_BL10 BL10 PREB VDD VDD PMOS W=10.2u L=1u
XM_BL10 BL10 COL10 Y VSS NMOS W=3.4u L=1u
XP_BLB10 BLB10 PREB VDD VDD PMOS W=10.2u L=1u
XM_BLB10 BLB10 COL10 YB VSS NMOS W=3.4u L=1u
XP_BL11 BL11 PREB VDD VDD PMOS W=10.2u L=1u
XM_BL11 BL11 COL11 Y VSS NMOS W=3.4u L=1u
XP_BLB11 BLB11 PREB VDD VDD PMOS W=10.2u L=1u
XM_BLB11 BLB11 COL11 YB VSS NMOS W=3.4u L=1u
XP_BL12 BL12 PREB VDD VDD PMOS W=10.2u L=1u
XM_BL12 BL12 COL12 Y VSS NMOS W=3.4u L=1u
XP_BLB12 BLB12 PREB VDD VDD PMOS W=10.2u L=1u
XM_BLB12 BLB12 COL12 YB VSS NMOS W=3.4u L=1u
XP_BL13 BL13 PREB VDD VDD PMOS W=10.2u L=1u
XM_BL13 BL13 COL13 Y VSS NMOS W=3.4u L=1u
XP_BLB13 BLB13 PREB VDD VDD PMOS W=10.2u L=1u
XM_BLB13 BLB13 COL13 YB VSS NMOS W=3.4u L=1u
XP_BL14 BL14 PREB VDD VDD PMOS W=10.2u L=1u
XM_BL14 BL14 COL14 Y VSS NMOS W=3.4u L=1u
XP_BLB14 BLB14 PREB VDD VDD PMOS W=10.2u L=1u
XM_BLB14 BLB14 COL14 YB VSS NMOS W=3.4u L=1u
XP_BL15 BL15 PREB VDD VDD PMOS W=10.2u L=1u
XM_BL15 BL15 COL15 Y VSS NMOS W=3.4u L=1u
XP_BLB15 BLB15 PREB VDD VDD PMOS W=10.2u L=1u
XM_BLB15 BLB15 COL15 YB VSS NMOS W=3.4u L=1u
XP_BL16 BL16 PREB VDD VDD PMOS W=10.2u L=1u
XM_BL16 BL16 COL16 Y VSS NMOS W=3.4u L=1u
XP_BLB16 BLB16 PREB VDD VDD PMOS W=10.2u L=1u
XM_BLB16 BLB16 COL16 YB VSS NMOS W=3.4u L=1u
XP_BL17 BL17 PREB VDD VDD PMOS W=10.2u L=1u
XM_BL17 BL17 COL17 Y VSS NMOS W=3.4u L=1u
XP_BLB17 BLB17 PREB VDD VDD PMOS W=10.2u L=1u
XM_BLB17 BLB17 COL17 YB VSS NMOS W=3.4u L=1u
XP_BL18 BL18 PREB VDD VDD PMOS W=10.2u L=1u
XM_BL18 BL18 COL18 Y VSS NMOS W=3.4u L=1u
XP_BLB18 BLB18 PREB VDD VDD PMOS W=10.2u L=1u
XM_BLB18 BLB18 COL18 YB VSS NMOS W=3.4u L=1u
XP_BL19 BL19 PREB VDD VDD PMOS W=10.2u L=1u
XM_BL19 BL19 COL19 Y VSS NMOS W=3.4u L=1u
XP_BLB19 BLB19 PREB VDD VDD PMOS W=10.2u L=1u
XM_BLB19 BLB19 COL19 YB VSS NMOS W=3.4u L=1u
XP_BL20 BL20 PREB VDD VDD PMOS W=10.2u L=1u
XM_BL20 BL20 COL20 Y VSS NMOS W=3.4u L=1u
XP_BLB20 BLB20 PREB VDD VDD PMOS W=10.2u L=1u
XM_BLB20 BLB20 COL20 YB VSS NMOS W=3.4u L=1u
XP_BL21 BL21 PREB VDD VDD PMOS W=10.2u L=1u
XM_BL21 BL21 COL21 Y VSS NMOS W=3.4u L=1u
XP_BLB21 BLB21 PREB VDD VDD PMOS W=10.2u L=1u
XM_BLB21 BLB21 COL21 YB VSS NMOS W=3.4u L=1u
XP_BL22 BL22 PREB VDD VDD PMOS W=10.2u L=1u
XM_BL22 BL22 COL22 Y VSS NMOS W=3.4u L=1u
XP_BLB22 BLB22 PREB VDD VDD PMOS W=10.2u L=1u
XM_BLB22 BLB22 COL22 YB VSS NMOS W=3.4u L=1u
XP_BL23 BL23 PREB VDD VDD PMOS W=10.2u L=1u
XM_BL23 BL23 COL23 Y VSS NMOS W=3.4u L=1u
XP_BLB23 BLB23 PREB VDD VDD PMOS W=10.2u L=1u
XM_BLB23 BLB23 COL23 YB VSS NMOS W=3.4u L=1u
XP_BL24 BL24 PREB VDD VDD PMOS W=10.2u L=1u
XM_BL24 BL24 COL24 Y VSS NMOS W=3.4u L=1u
XP_BLB24 BLB24 PREB VDD VDD PMOS W=10.2u L=1u
XM_BLB24 BLB24 COL24 YB VSS NMOS W=3.4u L=1u
XP_BL25 BL25 PREB VDD VDD PMOS W=10.2u L=1u
XM_BL25 BL25 COL25 Y VSS NMOS W=3.4u L=1u
XP_BLB25 BLB25 PREB VDD VDD PMOS W=10.2u L=1u
XM_BLB25 BLB25 COL25 YB VSS NMOS W=3.4u L=1u
XP_BL26 BL26 PREB VDD VDD PMOS W=10.2u L=1u
XM_BL26 BL26 COL26 Y VSS NMOS W=3.4u L=1u
XP_BLB26 BLB26 PREB VDD VDD PMOS W=10.2u L=1u
XM_BLB26 BLB26 COL26 YB VSS NMOS W=3.4u L=1u
XP_BL27 BL27 PREB VDD VDD PMOS W=10.2u L=1u
XM_BL27 BL27 COL27 Y VSS NMOS W=3.4u L=1u
XP_BLB27 BLB27 PREB VDD VDD PMOS W=10.2u L=1u
XM_BLB27 BLB27 COL27 YB VSS NMOS W=3.4u L=1u
XP_BL28 BL28 PREB VDD VDD PMOS W=10.2u L=1u
XM_BL28 BL28 COL28 Y VSS NMOS W=3.4u L=1u
XP_BLB28 BLB28 PREB VDD VDD PMOS W=10.2u L=1u
XM_BLB28 BLB28 COL28 YB VSS NMOS W=3.4u L=1u
XP_BL29 BL29 PREB VDD VDD PMOS W=10.2u L=1u
XM_BL29 BL29 COL29 Y VSS NMOS W=3.4u L=1u
XP_BLB29 BLB29 PREB VDD VDD PMOS W=10.2u L=1u
XM_BLB29 BLB29 COL29 YB VSS NMOS W=3.4u L=1u
XP_BL30 BL30 PREB VDD VDD PMOS W=10.2u L=1u
XM_BL30 BL30 COL30 Y VSS NMOS W=3.4u L=1u
XP_BLB30 BLB30 PREB VDD VDD PMOS W=10.2u L=1u
XM_BLB30 BLB30 COL30 YB VSS NMOS W=3.4u L=1u
XP_BL31 BL31 PREB VDD VDD PMOS W=10.2u L=1u
XM_BL31 BL31 COL31 Y VSS NMOS W=3.4u L=1u
XP_BLB31 BLB31 PREB VDD VDD PMOS W=10.2u L=1u
XM_BLB31 BLB31 COL31 YB VSS NMOS W=3.4u L=1u
XP_Y Y PREB VDD VDD PMOS W=10.2u L=1u
XW_Y Y PD_Y VSS VSS NMOS W=3.4u L=1u
XP_YB YB PREB VDD VDD PMOS W=10.2u L=1u
XW_YB YB PD_YB VSS VSS NMOS W=3.4u L=1u
Xg166 Y YB SAE SOUT SOUTB VDD VSS sense_amp_7t
.ends
* Created by KLayout
*** My special header ***

* cell wlstrap16_16x32
* pin BL0
* pin BL1
* pin BL10
* pin BL11
* pin BL12
* pin BL13
* pin BL14
* pin BL15
* pin BL16
* pin BL17
* pin BL18
* pin BL19
* pin BL2
* pin BL20
* pin BL21
* pin BL22
* pin BL23
* pin BL24
* pin BL25
* pin BL26
* pin BL27
* pin BL28
* pin BL29
* pin BL3
* pin BL30
* pin BL31
* pin BL4
* pin BL5
* pin BL6
* pin BL7
* pin BL8
* pin BL9
* pin BLB0
* pin BLB1
* pin BLB10
* pin BLB11
* pin BLB12
* pin BLB13
* pin BLB14
* pin BLB15
* pin BLB16
* pin BLB17
* pin BLB18
* pin BLB19
* pin BLB2
* pin BLB20
* pin BLB21
* pin BLB22
* pin BLB23
* pin BLB24
* pin BLB25
* pin BLB26
* pin BLB27
* pin BLB28
* pin BLB29
* pin BLB3
* pin BLB30
* pin BLB31
* pin BLB4
* pin BLB5
* pin BLB6
* pin BLB7
* pin BLB8
* pin BLB9
* pin VDD
* pin VSS
* pin WL0
* pin WL1
* pin WL10
* pin WL11
* pin WL12
* pin WL13
* pin WL14
* pin WL15
* pin WL2
* pin WL3
* pin WL4
* pin WL5
* pin WL6
* pin WL7
* pin WL8
* pin WL9
.SUBCKT wlstrap16_16x32 BL0 BL1 BL10 BL11 BL12 BL13 BL14 BL15 BL16 BL17 BL18
+ BL19 BL2 BL20 BL21 BL22 BL23 BL24 BL25 BL26 BL27 BL28 BL29 BL3 BL30 BL31 BL4
+ BL5 BL6 BL7 BL8 BL9 BLB0 BLB1 BLB10 BLB11 BLB12 BLB13 BLB14 BLB15 BLB16 BLB17
+ BLB18 BLB19 BLB2 BLB20 BLB21 BLB22 BLB23 BLB24 BLB25 BLB26 BLB27 BLB28 BLB29
+ BLB3 BLB30 BLB31 BLB4 BLB5 BLB6 BLB7 BLB8 BLB9 VDD VSS WL0 WL1 WL10 WL11 WL12
+ WL13 WL14 WL15 WL2 WL3 WL4 WL5 WL6 WL7 WL8 WL9
* device instance $1 r0 *1 562,26.1 PMOS
XM$1 \$I3578 \$I3579 VDD VDD PMOS L=1u W=3.4u AS=10.88p AD=6.46p PS=13.2u
+ PD=7.2u
* device instance $2 r0 *1 566.8,26.1 PMOS
XM$2 VDD \$I3578 \$I3579 VDD PMOS L=1u W=3.4u AS=6.46p AD=10.88p PS=7.2u
+ PD=13.2u
* device instance $3 r0 *1 557.2,5.7 NMOS
XM$3 BL23 WL0 \$I3578 VSS NMOS L=1u W=3.4u AS=10.88p AD=6.46p PS=13.2u PD=7.2u
* device instance $4 r0 *1 562,5.7 NMOS
XM$4 \$I3578 \$I3579 VSS VSS NMOS L=1u W=3.4u AS=6.46p AD=6.46p PS=7.2u PD=7.2u
* device instance $5 r0 *1 566.8,5.7 NMOS
XM$5 VSS \$I3578 \$I3579 VSS NMOS L=1u W=3.4u AS=6.46p AD=6.46p PS=7.2u PD=7.2u
* device instance $6 r0 *1 571.6,5.7 NMOS
XM$6 \$I3579 WL0 BLB23 VSS NMOS L=1u W=3.4u AS=6.46p AD=10.88p PS=7.2u PD=13.2u
* device instance $7 r0 *1 53.6,26.1 PMOS
XM$7 \$I3580 \$I3581 VDD VDD PMOS L=1u W=3.4u AS=10.88p AD=6.46p PS=13.2u
+ PD=7.2u
* device instance $8 r0 *1 58.4,26.1 PMOS
XM$8 VDD \$I3580 \$I3581 VDD PMOS L=1u W=3.4u AS=6.46p AD=10.88p PS=7.2u
+ PD=13.2u
* device instance $9 r0 *1 48.8,5.7 NMOS
XM$9 BL2 WL0 \$I3580 VSS NMOS L=1u W=3.4u AS=10.88p AD=6.46p PS=13.2u PD=7.2u
* device instance $10 r0 *1 53.6,5.7 NMOS
XM$10 \$I3580 \$I3581 VSS VSS NMOS L=1u W=3.4u AS=6.46p AD=6.46p PS=7.2u PD=7.2u
* device instance $11 r0 *1 58.4,5.7 NMOS
XM$11 VSS \$I3580 \$I3581 VSS NMOS L=1u W=3.4u AS=6.46p AD=6.46p PS=7.2u PD=7.2u
* device instance $12 r0 *1 63.2,5.7 NMOS
XM$12 \$I3581 WL0 BLB2 VSS NMOS L=1u W=3.4u AS=6.46p AD=10.88p PS=7.2u PD=13.2u
* device instance $13 r0 *1 76.8,26.1 PMOS
XM$13 \$I3582 \$I3583 VDD VDD PMOS L=1u W=3.4u AS=10.88p AD=6.46p PS=13.2u
+ PD=7.2u
* device instance $14 r0 *1 81.6,26.1 PMOS
XM$14 VDD \$I3582 \$I3583 VDD PMOS L=1u W=3.4u AS=6.46p AD=10.88p PS=7.2u
+ PD=13.2u
* device instance $15 r0 *1 72,5.7 NMOS
XM$15 BL3 WL0 \$I3582 VSS NMOS L=1u W=3.4u AS=10.88p AD=6.46p PS=13.2u PD=7.2u
* device instance $16 r0 *1 76.8,5.7 NMOS
XM$16 \$I3582 \$I3583 VSS VSS NMOS L=1u W=3.4u AS=6.46p AD=6.46p PS=7.2u PD=7.2u
* device instance $17 r0 *1 81.6,5.7 NMOS
XM$17 VSS \$I3582 \$I3583 VSS NMOS L=1u W=3.4u AS=6.46p AD=6.46p PS=7.2u PD=7.2u
* device instance $18 r0 *1 86.4,5.7 NMOS
XM$18 \$I3583 WL0 BLB3 VSS NMOS L=1u W=3.4u AS=6.46p AD=10.88p PS=7.2u PD=13.2u
* device instance $19 r0 *1 100,26.1 PMOS
XM$19 \$I3584 \$I3585 VDD VDD PMOS L=1u W=3.4u AS=10.88p AD=6.46p PS=13.2u
+ PD=7.2u
* device instance $20 r0 *1 104.8,26.1 PMOS
XM$20 VDD \$I3584 \$I3585 VDD PMOS L=1u W=3.4u AS=6.46p AD=10.88p PS=7.2u
+ PD=13.2u
* device instance $21 r0 *1 95.2,5.7 NMOS
XM$21 BL4 WL0 \$I3584 VSS NMOS L=1u W=3.4u AS=10.88p AD=6.46p PS=13.2u PD=7.2u
* device instance $22 r0 *1 100,5.7 NMOS
XM$22 \$I3584 \$I3585 VSS VSS NMOS L=1u W=3.4u AS=6.46p AD=6.46p PS=7.2u PD=7.2u
* device instance $23 r0 *1 104.8,5.7 NMOS
XM$23 VSS \$I3584 \$I3585 VSS NMOS L=1u W=3.4u AS=6.46p AD=6.46p PS=7.2u PD=7.2u
* device instance $24 r0 *1 109.6,5.7 NMOS
XM$24 \$I3585 WL0 BLB4 VSS NMOS L=1u W=3.4u AS=6.46p AD=10.88p PS=7.2u PD=13.2u
* device instance $25 r0 *1 123.2,26.1 PMOS
XM$25 \$I3586 \$I3587 VDD VDD PMOS L=1u W=3.4u AS=10.88p AD=6.46p PS=13.2u
+ PD=7.2u
* device instance $26 r0 *1 128,26.1 PMOS
XM$26 VDD \$I3586 \$I3587 VDD PMOS L=1u W=3.4u AS=6.46p AD=10.88p PS=7.2u
+ PD=13.2u
* device instance $27 r0 *1 118.4,5.7 NMOS
XM$27 BL5 WL0 \$I3586 VSS NMOS L=1u W=3.4u AS=10.88p AD=6.46p PS=13.2u PD=7.2u
* device instance $28 r0 *1 123.2,5.7 NMOS
XM$28 \$I3586 \$I3587 VSS VSS NMOS L=1u W=3.4u AS=6.46p AD=6.46p PS=7.2u PD=7.2u
* device instance $29 r0 *1 128,5.7 NMOS
XM$29 VSS \$I3586 \$I3587 VSS NMOS L=1u W=3.4u AS=6.46p AD=6.46p PS=7.2u PD=7.2u
* device instance $30 r0 *1 132.8,5.7 NMOS
XM$30 \$I3587 WL0 BLB5 VSS NMOS L=1u W=3.4u AS=6.46p AD=10.88p PS=7.2u PD=13.2u
* device instance $31 r0 *1 146.4,26.1 PMOS
XM$31 \$I3588 \$I3589 VDD VDD PMOS L=1u W=3.4u AS=10.88p AD=6.46p PS=13.2u
+ PD=7.2u
* device instance $32 r0 *1 151.2,26.1 PMOS
XM$32 VDD \$I3588 \$I3589 VDD PMOS L=1u W=3.4u AS=6.46p AD=10.88p PS=7.2u
+ PD=13.2u
* device instance $33 r0 *1 141.6,5.7 NMOS
XM$33 BL6 WL0 \$I3588 VSS NMOS L=1u W=3.4u AS=10.88p AD=6.46p PS=13.2u PD=7.2u
* device instance $34 r0 *1 146.4,5.7 NMOS
XM$34 \$I3588 \$I3589 VSS VSS NMOS L=1u W=3.4u AS=6.46p AD=6.46p PS=7.2u PD=7.2u
* device instance $35 r0 *1 151.2,5.7 NMOS
XM$35 VSS \$I3588 \$I3589 VSS NMOS L=1u W=3.4u AS=6.46p AD=6.46p PS=7.2u PD=7.2u
* device instance $36 r0 *1 156,5.7 NMOS
XM$36 \$I3589 WL0 BLB6 VSS NMOS L=1u W=3.4u AS=6.46p AD=10.88p PS=7.2u PD=13.2u
* device instance $37 r0 *1 169.6,26.1 PMOS
XM$37 \$I3590 \$I3591 VDD VDD PMOS L=1u W=3.4u AS=10.88p AD=6.46p PS=13.2u
+ PD=7.2u
* device instance $38 r0 *1 174.4,26.1 PMOS
XM$38 VDD \$I3590 \$I3591 VDD PMOS L=1u W=3.4u AS=6.46p AD=10.88p PS=7.2u
+ PD=13.2u
* device instance $39 r0 *1 164.8,5.7 NMOS
XM$39 BL7 WL0 \$I3590 VSS NMOS L=1u W=3.4u AS=10.88p AD=6.46p PS=13.2u PD=7.2u
* device instance $40 r0 *1 169.6,5.7 NMOS
XM$40 \$I3590 \$I3591 VSS VSS NMOS L=1u W=3.4u AS=6.46p AD=6.46p PS=7.2u PD=7.2u
* device instance $41 r0 *1 174.4,5.7 NMOS
XM$41 VSS \$I3590 \$I3591 VSS NMOS L=1u W=3.4u AS=6.46p AD=6.46p PS=7.2u PD=7.2u
* device instance $42 r0 *1 179.2,5.7 NMOS
XM$42 \$I3591 WL0 BLB7 VSS NMOS L=1u W=3.4u AS=6.46p AD=10.88p PS=7.2u PD=13.2u
* device instance $43 r0 *1 262.4,26.1 PMOS
XM$43 \$I3592 \$I3593 VDD VDD PMOS L=1u W=3.4u AS=10.88p AD=6.46p PS=13.2u
+ PD=7.2u
* device instance $44 r0 *1 267.2,26.1 PMOS
XM$44 VDD \$I3592 \$I3593 VDD PMOS L=1u W=3.4u AS=6.46p AD=10.88p PS=7.2u
+ PD=13.2u
* device instance $45 r0 *1 257.6,5.7 NMOS
XM$45 BL11 WL0 \$I3592 VSS NMOS L=1u W=3.4u AS=10.88p AD=6.46p PS=13.2u PD=7.2u
* device instance $46 r0 *1 262.4,5.7 NMOS
XM$46 \$I3592 \$I3593 VSS VSS NMOS L=1u W=3.4u AS=6.46p AD=6.46p PS=7.2u PD=7.2u
* device instance $47 r0 *1 267.2,5.7 NMOS
XM$47 VSS \$I3592 \$I3593 VSS NMOS L=1u W=3.4u AS=6.46p AD=6.46p PS=7.2u PD=7.2u
* device instance $48 r0 *1 272,5.7 NMOS
XM$48 \$I3593 WL0 BLB11 VSS NMOS L=1u W=3.4u AS=6.46p AD=10.88p PS=7.2u PD=13.2u
* device instance $49 r0 *1 285.6,26.1 PMOS
XM$49 \$I3594 \$I3595 VDD VDD PMOS L=1u W=3.4u AS=10.88p AD=6.46p PS=13.2u
+ PD=7.2u
* device instance $50 r0 *1 290.4,26.1 PMOS
XM$50 VDD \$I3594 \$I3595 VDD PMOS L=1u W=3.4u AS=6.46p AD=10.88p PS=7.2u
+ PD=13.2u
* device instance $51 r0 *1 280.8,5.7 NMOS
XM$51 BL12 WL0 \$I3594 VSS NMOS L=1u W=3.4u AS=10.88p AD=6.46p PS=13.2u PD=7.2u
* device instance $52 r0 *1 285.6,5.7 NMOS
XM$52 \$I3594 \$I3595 VSS VSS NMOS L=1u W=3.4u AS=6.46p AD=6.46p PS=7.2u PD=7.2u
* device instance $53 r0 *1 290.4,5.7 NMOS
XM$53 VSS \$I3594 \$I3595 VSS NMOS L=1u W=3.4u AS=6.46p AD=6.46p PS=7.2u PD=7.2u
* device instance $54 r0 *1 295.2,5.7 NMOS
XM$54 \$I3595 WL0 BLB12 VSS NMOS L=1u W=3.4u AS=6.46p AD=10.88p PS=7.2u PD=13.2u
* device instance $55 r0 *1 308.8,26.1 PMOS
XM$55 \$I3596 \$I3597 VDD VDD PMOS L=1u W=3.4u AS=10.88p AD=6.46p PS=13.2u
+ PD=7.2u
* device instance $56 r0 *1 313.6,26.1 PMOS
XM$56 VDD \$I3596 \$I3597 VDD PMOS L=1u W=3.4u AS=6.46p AD=10.88p PS=7.2u
+ PD=13.2u
* device instance $57 r0 *1 304,5.7 NMOS
XM$57 BL13 WL0 \$I3596 VSS NMOS L=1u W=3.4u AS=10.88p AD=6.46p PS=13.2u PD=7.2u
* device instance $58 r0 *1 308.8,5.7 NMOS
XM$58 \$I3596 \$I3597 VSS VSS NMOS L=1u W=3.4u AS=6.46p AD=6.46p PS=7.2u PD=7.2u
* device instance $59 r0 *1 313.6,5.7 NMOS
XM$59 VSS \$I3596 \$I3597 VSS NMOS L=1u W=3.4u AS=6.46p AD=6.46p PS=7.2u PD=7.2u
* device instance $60 r0 *1 318.4,5.7 NMOS
XM$60 \$I3597 WL0 BLB13 VSS NMOS L=1u W=3.4u AS=6.46p AD=10.88p PS=7.2u PD=13.2u
* device instance $61 r0 *1 332,26.1 PMOS
XM$61 \$I3598 \$I3599 VDD VDD PMOS L=1u W=3.4u AS=10.88p AD=6.46p PS=13.2u
+ PD=7.2u
* device instance $62 r0 *1 336.8,26.1 PMOS
XM$62 VDD \$I3598 \$I3599 VDD PMOS L=1u W=3.4u AS=6.46p AD=10.88p PS=7.2u
+ PD=13.2u
* device instance $63 r0 *1 327.2,5.7 NMOS
XM$63 BL14 WL0 \$I3598 VSS NMOS L=1u W=3.4u AS=10.88p AD=6.46p PS=13.2u PD=7.2u
* device instance $64 r0 *1 332,5.7 NMOS
XM$64 \$I3598 \$I3599 VSS VSS NMOS L=1u W=3.4u AS=6.46p AD=6.46p PS=7.2u PD=7.2u
* device instance $65 r0 *1 336.8,5.7 NMOS
XM$65 VSS \$I3598 \$I3599 VSS NMOS L=1u W=3.4u AS=6.46p AD=6.46p PS=7.2u PD=7.2u
* device instance $66 r0 *1 341.6,5.7 NMOS
XM$66 \$I3599 WL0 BLB14 VSS NMOS L=1u W=3.4u AS=6.46p AD=10.88p PS=7.2u PD=13.2u
* device instance $67 r0 *1 355.2,26.1 PMOS
XM$67 \$I3600 \$I3601 VDD VDD PMOS L=1u W=3.4u AS=10.88p AD=6.46p PS=13.2u
+ PD=7.2u
* device instance $68 r0 *1 360,26.1 PMOS
XM$68 VDD \$I3600 \$I3601 VDD PMOS L=1u W=3.4u AS=6.46p AD=10.88p PS=7.2u
+ PD=13.2u
* device instance $69 r0 *1 350.4,5.7 NMOS
XM$69 BL15 WL0 \$I3600 VSS NMOS L=1u W=3.4u AS=10.88p AD=6.46p PS=13.2u PD=7.2u
* device instance $70 r0 *1 355.2,5.7 NMOS
XM$70 \$I3600 \$I3601 VSS VSS NMOS L=1u W=3.4u AS=6.46p AD=6.46p PS=7.2u PD=7.2u
* device instance $71 r0 *1 360,5.7 NMOS
XM$71 VSS \$I3600 \$I3601 VSS NMOS L=1u W=3.4u AS=6.46p AD=6.46p PS=7.2u PD=7.2u
* device instance $72 r0 *1 364.8,5.7 NMOS
XM$72 \$I3601 WL0 BLB15 VSS NMOS L=1u W=3.4u AS=6.46p AD=10.88p PS=7.2u PD=13.2u
* device instance $73 r0 *1 216,26.1 PMOS
XM$73 \$I3602 \$I3603 VDD VDD PMOS L=1u W=3.4u AS=10.88p AD=6.46p PS=13.2u
+ PD=7.2u
* device instance $74 r0 *1 220.8,26.1 PMOS
XM$74 VDD \$I3602 \$I3603 VDD PMOS L=1u W=3.4u AS=6.46p AD=10.88p PS=7.2u
+ PD=13.2u
* device instance $75 r0 *1 211.2,5.7 NMOS
XM$75 BL9 WL0 \$I3602 VSS NMOS L=1u W=3.4u AS=10.88p AD=6.46p PS=13.2u PD=7.2u
* device instance $76 r0 *1 216,5.7 NMOS
XM$76 \$I3602 \$I3603 VSS VSS NMOS L=1u W=3.4u AS=6.46p AD=6.46p PS=7.2u PD=7.2u
* device instance $77 r0 *1 220.8,5.7 NMOS
XM$77 VSS \$I3602 \$I3603 VSS NMOS L=1u W=3.4u AS=6.46p AD=6.46p PS=7.2u PD=7.2u
* device instance $78 r0 *1 225.6,5.7 NMOS
XM$78 \$I3603 WL0 BLB9 VSS NMOS L=1u W=3.4u AS=6.46p AD=10.88p PS=7.2u PD=13.2u
* device instance $79 r0 *1 239.2,26.1 PMOS
XM$79 \$I3604 \$I3605 VDD VDD PMOS L=1u W=3.4u AS=10.88p AD=6.46p PS=13.2u
+ PD=7.2u
* device instance $80 r0 *1 244,26.1 PMOS
XM$80 VDD \$I3604 \$I3605 VDD PMOS L=1u W=3.4u AS=6.46p AD=10.88p PS=7.2u
+ PD=13.2u
* device instance $81 r0 *1 234.4,5.7 NMOS
XM$81 BL10 WL0 \$I3604 VSS NMOS L=1u W=3.4u AS=10.88p AD=6.46p PS=13.2u PD=7.2u
* device instance $82 r0 *1 239.2,5.7 NMOS
XM$82 \$I3604 \$I3605 VSS VSS NMOS L=1u W=3.4u AS=6.46p AD=6.46p PS=7.2u PD=7.2u
* device instance $83 r0 *1 244,5.7 NMOS
XM$83 VSS \$I3604 \$I3605 VSS NMOS L=1u W=3.4u AS=6.46p AD=6.46p PS=7.2u PD=7.2u
* device instance $84 r0 *1 248.8,5.7 NMOS
XM$84 \$I3605 WL0 BLB10 VSS NMOS L=1u W=3.4u AS=6.46p AD=10.88p PS=7.2u PD=13.2u
* device instance $85 r0 *1 469.2,26.1 PMOS
XM$85 \$I3606 \$I3607 VDD VDD PMOS L=1u W=3.4u AS=10.88p AD=6.46p PS=13.2u
+ PD=7.2u
* device instance $86 r0 *1 474,26.1 PMOS
XM$86 VDD \$I3606 \$I3607 VDD PMOS L=1u W=3.4u AS=6.46p AD=10.88p PS=7.2u
+ PD=13.2u
* device instance $87 r0 *1 464.4,5.7 NMOS
XM$87 BL19 WL0 \$I3606 VSS NMOS L=1u W=3.4u AS=10.88p AD=6.46p PS=13.2u PD=7.2u
* device instance $88 r0 *1 469.2,5.7 NMOS
XM$88 \$I3606 \$I3607 VSS VSS NMOS L=1u W=3.4u AS=6.46p AD=6.46p PS=7.2u PD=7.2u
* device instance $89 r0 *1 474,5.7 NMOS
XM$89 VSS \$I3606 \$I3607 VSS NMOS L=1u W=3.4u AS=6.46p AD=6.46p PS=7.2u PD=7.2u
* device instance $90 r0 *1 478.8,5.7 NMOS
XM$90 \$I3607 WL0 BLB19 VSS NMOS L=1u W=3.4u AS=6.46p AD=10.88p PS=7.2u PD=13.2u
* device instance $91 r0 *1 492.4,26.1 PMOS
XM$91 \$I3608 \$I3609 VDD VDD PMOS L=1u W=3.4u AS=10.88p AD=6.46p PS=13.2u
+ PD=7.2u
* device instance $92 r0 *1 497.2,26.1 PMOS
XM$92 VDD \$I3608 \$I3609 VDD PMOS L=1u W=3.4u AS=6.46p AD=10.88p PS=7.2u
+ PD=13.2u
* device instance $93 r0 *1 487.6,5.7 NMOS
XM$93 BL20 WL0 \$I3608 VSS NMOS L=1u W=3.4u AS=10.88p AD=6.46p PS=13.2u PD=7.2u
* device instance $94 r0 *1 492.4,5.7 NMOS
XM$94 \$I3608 \$I3609 VSS VSS NMOS L=1u W=3.4u AS=6.46p AD=6.46p PS=7.2u PD=7.2u
* device instance $95 r0 *1 497.2,5.7 NMOS
XM$95 VSS \$I3608 \$I3609 VSS NMOS L=1u W=3.4u AS=6.46p AD=6.46p PS=7.2u PD=7.2u
* device instance $96 r0 *1 502,5.7 NMOS
XM$96 \$I3609 WL0 BLB20 VSS NMOS L=1u W=3.4u AS=6.46p AD=10.88p PS=7.2u PD=13.2u
* device instance $97 r0 *1 585.2,26.1 PMOS
XM$97 \$I3610 \$I3611 VDD VDD PMOS L=1u W=3.4u AS=10.88p AD=6.46p PS=13.2u
+ PD=7.2u
* device instance $98 r0 *1 590,26.1 PMOS
XM$98 VDD \$I3610 \$I3611 VDD PMOS L=1u W=3.4u AS=6.46p AD=10.88p PS=7.2u
+ PD=13.2u
* device instance $99 r0 *1 580.4,5.7 NMOS
XM$99 BL24 WL0 \$I3610 VSS NMOS L=1u W=3.4u AS=10.88p AD=6.46p PS=13.2u PD=7.2u
* device instance $100 r0 *1 585.2,5.7 NMOS
XM$100 \$I3610 \$I3611 VSS VSS NMOS L=1u W=3.4u AS=6.46p AD=6.46p PS=7.2u
+ PD=7.2u
* device instance $101 r0 *1 590,5.7 NMOS
XM$101 VSS \$I3610 \$I3611 VSS NMOS L=1u W=3.4u AS=6.46p AD=6.46p PS=7.2u
+ PD=7.2u
* device instance $102 r0 *1 594.8,5.7 NMOS
XM$102 \$I3611 WL0 BLB24 VSS NMOS L=1u W=3.4u AS=6.46p AD=10.88p PS=7.2u
+ PD=13.2u
* device instance $103 r0 *1 608.4,26.1 PMOS
XM$103 \$I3612 \$I3613 VDD VDD PMOS L=1u W=3.4u AS=10.88p AD=6.46p PS=13.2u
+ PD=7.2u
* device instance $104 r0 *1 613.2,26.1 PMOS
XM$104 VDD \$I3612 \$I3613 VDD PMOS L=1u W=3.4u AS=6.46p AD=10.88p PS=7.2u
+ PD=13.2u
* device instance $105 r0 *1 603.6,5.7 NMOS
XM$105 BL25 WL0 \$I3612 VSS NMOS L=1u W=3.4u AS=10.88p AD=6.46p PS=13.2u PD=7.2u
* device instance $106 r0 *1 608.4,5.7 NMOS
XM$106 \$I3612 \$I3613 VSS VSS NMOS L=1u W=3.4u AS=6.46p AD=6.46p PS=7.2u
+ PD=7.2u
* device instance $107 r0 *1 613.2,5.7 NMOS
XM$107 VSS \$I3612 \$I3613 VSS NMOS L=1u W=3.4u AS=6.46p AD=6.46p PS=7.2u
+ PD=7.2u
* device instance $108 r0 *1 618,5.7 NMOS
XM$108 \$I3613 WL0 BLB25 VSS NMOS L=1u W=3.4u AS=6.46p AD=10.88p PS=7.2u
+ PD=13.2u
* device instance $109 r0 *1 631.6,26.1 PMOS
XM$109 \$I3614 \$I3615 VDD VDD PMOS L=1u W=3.4u AS=10.88p AD=6.46p PS=13.2u
+ PD=7.2u
* device instance $110 r0 *1 636.4,26.1 PMOS
XM$110 VDD \$I3614 \$I3615 VDD PMOS L=1u W=3.4u AS=6.46p AD=10.88p PS=7.2u
+ PD=13.2u
* device instance $111 r0 *1 626.8,5.7 NMOS
XM$111 BL26 WL0 \$I3614 VSS NMOS L=1u W=3.4u AS=10.88p AD=6.46p PS=13.2u PD=7.2u
* device instance $112 r0 *1 631.6,5.7 NMOS
XM$112 \$I3614 \$I3615 VSS VSS NMOS L=1u W=3.4u AS=6.46p AD=6.46p PS=7.2u
+ PD=7.2u
* device instance $113 r0 *1 636.4,5.7 NMOS
XM$113 VSS \$I3614 \$I3615 VSS NMOS L=1u W=3.4u AS=6.46p AD=6.46p PS=7.2u
+ PD=7.2u
* device instance $114 r0 *1 641.2,5.7 NMOS
XM$114 \$I3615 WL0 BLB26 VSS NMOS L=1u W=3.4u AS=6.46p AD=10.88p PS=7.2u
+ PD=13.2u
* device instance $115 r0 *1 654.8,26.1 PMOS
XM$115 \$I3616 \$I3617 VDD VDD PMOS L=1u W=3.4u AS=10.88p AD=6.46p PS=13.2u
+ PD=7.2u
* device instance $116 r0 *1 659.6,26.1 PMOS
XM$116 VDD \$I3616 \$I3617 VDD PMOS L=1u W=3.4u AS=6.46p AD=10.88p PS=7.2u
+ PD=13.2u
* device instance $117 r0 *1 650,5.7 NMOS
XM$117 BL27 WL0 \$I3616 VSS NMOS L=1u W=3.4u AS=10.88p AD=6.46p PS=13.2u PD=7.2u
* device instance $118 r0 *1 654.8,5.7 NMOS
XM$118 \$I3616 \$I3617 VSS VSS NMOS L=1u W=3.4u AS=6.46p AD=6.46p PS=7.2u
+ PD=7.2u
* device instance $119 r0 *1 659.6,5.7 NMOS
XM$119 VSS \$I3616 \$I3617 VSS NMOS L=1u W=3.4u AS=6.46p AD=6.46p PS=7.2u
+ PD=7.2u
* device instance $120 r0 *1 664.4,5.7 NMOS
XM$120 \$I3617 WL0 BLB27 VSS NMOS L=1u W=3.4u AS=6.46p AD=10.88p PS=7.2u
+ PD=13.2u
* device instance $121 r0 *1 678,26.1 PMOS
XM$121 \$I3618 \$I3619 VDD VDD PMOS L=1u W=3.4u AS=10.88p AD=6.46p PS=13.2u
+ PD=7.2u
* device instance $122 r0 *1 682.8,26.1 PMOS
XM$122 VDD \$I3618 \$I3619 VDD PMOS L=1u W=3.4u AS=6.46p AD=10.88p PS=7.2u
+ PD=13.2u
* device instance $123 r0 *1 673.2,5.7 NMOS
XM$123 BL28 WL0 \$I3618 VSS NMOS L=1u W=3.4u AS=10.88p AD=6.46p PS=13.2u PD=7.2u
* device instance $124 r0 *1 678,5.7 NMOS
XM$124 \$I3618 \$I3619 VSS VSS NMOS L=1u W=3.4u AS=6.46p AD=6.46p PS=7.2u
+ PD=7.2u
* device instance $125 r0 *1 682.8,5.7 NMOS
XM$125 VSS \$I3618 \$I3619 VSS NMOS L=1u W=3.4u AS=6.46p AD=6.46p PS=7.2u
+ PD=7.2u
* device instance $126 r0 *1 687.6,5.7 NMOS
XM$126 \$I3619 WL0 BLB28 VSS NMOS L=1u W=3.4u AS=6.46p AD=10.88p PS=7.2u
+ PD=13.2u
* device instance $127 r0 *1 701.2,26.1 PMOS
XM$127 \$I3620 \$I3621 VDD VDD PMOS L=1u W=3.4u AS=10.88p AD=6.46p PS=13.2u
+ PD=7.2u
* device instance $128 r0 *1 706,26.1 PMOS
XM$128 VDD \$I3620 \$I3621 VDD PMOS L=1u W=3.4u AS=6.46p AD=10.88p PS=7.2u
+ PD=13.2u
* device instance $129 r0 *1 696.4,5.7 NMOS
XM$129 BL29 WL0 \$I3620 VSS NMOS L=1u W=3.4u AS=10.88p AD=6.46p PS=13.2u PD=7.2u
* device instance $130 r0 *1 701.2,5.7 NMOS
XM$130 \$I3620 \$I3621 VSS VSS NMOS L=1u W=3.4u AS=6.46p AD=6.46p PS=7.2u
+ PD=7.2u
* device instance $131 r0 *1 706,5.7 NMOS
XM$131 VSS \$I3620 \$I3621 VSS NMOS L=1u W=3.4u AS=6.46p AD=6.46p PS=7.2u
+ PD=7.2u
* device instance $132 r0 *1 710.8,5.7 NMOS
XM$132 \$I3621 WL0 BLB29 VSS NMOS L=1u W=3.4u AS=6.46p AD=10.88p PS=7.2u
+ PD=13.2u
* device instance $133 r0 *1 724.4,26.1 PMOS
XM$133 \$I3622 \$I3623 VDD VDD PMOS L=1u W=3.4u AS=10.88p AD=6.46p PS=13.2u
+ PD=7.2u
* device instance $134 r0 *1 729.2,26.1 PMOS
XM$134 VDD \$I3622 \$I3623 VDD PMOS L=1u W=3.4u AS=6.46p AD=10.88p PS=7.2u
+ PD=13.2u
* device instance $135 r0 *1 719.6,5.7 NMOS
XM$135 BL30 WL0 \$I3622 VSS NMOS L=1u W=3.4u AS=10.88p AD=6.46p PS=13.2u PD=7.2u
* device instance $136 r0 *1 724.4,5.7 NMOS
XM$136 \$I3622 \$I3623 VSS VSS NMOS L=1u W=3.4u AS=6.46p AD=6.46p PS=7.2u
+ PD=7.2u
* device instance $137 r0 *1 729.2,5.7 NMOS
XM$137 VSS \$I3622 \$I3623 VSS NMOS L=1u W=3.4u AS=6.46p AD=6.46p PS=7.2u
+ PD=7.2u
* device instance $138 r0 *1 734,5.7 NMOS
XM$138 \$I3623 WL0 BLB30 VSS NMOS L=1u W=3.4u AS=6.46p AD=10.88p PS=7.2u
+ PD=13.2u
* device instance $139 r0 *1 747.6,26.1 PMOS
XM$139 \$I3624 \$I3625 VDD VDD PMOS L=1u W=3.4u AS=10.88p AD=6.46p PS=13.2u
+ PD=7.2u
* device instance $140 r0 *1 752.4,26.1 PMOS
XM$140 VDD \$I3624 \$I3625 VDD PMOS L=1u W=3.4u AS=6.46p AD=10.88p PS=7.2u
+ PD=13.2u
* device instance $141 r0 *1 742.8,5.7 NMOS
XM$141 BL31 WL0 \$I3624 VSS NMOS L=1u W=3.4u AS=10.88p AD=6.46p PS=13.2u PD=7.2u
* device instance $142 r0 *1 747.6,5.7 NMOS
XM$142 \$I3624 \$I3625 VSS VSS NMOS L=1u W=3.4u AS=6.46p AD=6.46p PS=7.2u
+ PD=7.2u
* device instance $143 r0 *1 752.4,5.7 NMOS
XM$143 VSS \$I3624 \$I3625 VSS NMOS L=1u W=3.4u AS=6.46p AD=6.46p PS=7.2u
+ PD=7.2u
* device instance $144 r0 *1 757.2,5.7 NMOS
XM$144 \$I3625 WL0 BLB31 VSS NMOS L=1u W=3.4u AS=6.46p AD=10.88p PS=7.2u
+ PD=13.2u
* device instance $145 r0 *1 515.6,26.1 PMOS
XM$145 \$I3626 \$I3627 VDD VDD PMOS L=1u W=3.4u AS=10.88p AD=6.46p PS=13.2u
+ PD=7.2u
* device instance $146 r0 *1 520.4,26.1 PMOS
XM$146 VDD \$I3626 \$I3627 VDD PMOS L=1u W=3.4u AS=6.46p AD=10.88p PS=7.2u
+ PD=13.2u
* device instance $147 r0 *1 510.8,5.7 NMOS
XM$147 BL21 WL0 \$I3626 VSS NMOS L=1u W=3.4u AS=10.88p AD=6.46p PS=13.2u PD=7.2u
* device instance $148 r0 *1 515.6,5.7 NMOS
XM$148 \$I3626 \$I3627 VSS VSS NMOS L=1u W=3.4u AS=6.46p AD=6.46p PS=7.2u
+ PD=7.2u
* device instance $149 r0 *1 520.4,5.7 NMOS
XM$149 VSS \$I3626 \$I3627 VSS NMOS L=1u W=3.4u AS=6.46p AD=6.46p PS=7.2u
+ PD=7.2u
* device instance $150 r0 *1 525.2,5.7 NMOS
XM$150 \$I3627 WL0 BLB21 VSS NMOS L=1u W=3.4u AS=6.46p AD=10.88p PS=7.2u
+ PD=13.2u
* device instance $151 r0 *1 538.8,26.1 PMOS
XM$151 \$I3628 \$I3629 VDD VDD PMOS L=1u W=3.4u AS=10.88p AD=6.46p PS=13.2u
+ PD=7.2u
* device instance $152 r0 *1 543.6,26.1 PMOS
XM$152 VDD \$I3628 \$I3629 VDD PMOS L=1u W=3.4u AS=6.46p AD=10.88p PS=7.2u
+ PD=13.2u
* device instance $153 r0 *1 534,5.7 NMOS
XM$153 BL22 WL0 \$I3628 VSS NMOS L=1u W=3.4u AS=10.88p AD=6.46p PS=13.2u PD=7.2u
* device instance $154 r0 *1 538.8,5.7 NMOS
XM$154 \$I3628 \$I3629 VSS VSS NMOS L=1u W=3.4u AS=6.46p AD=6.46p PS=7.2u
+ PD=7.2u
* device instance $155 r0 *1 543.6,5.7 NMOS
XM$155 VSS \$I3628 \$I3629 VSS NMOS L=1u W=3.4u AS=6.46p AD=6.46p PS=7.2u
+ PD=7.2u
* device instance $156 r0 *1 548.4,5.7 NMOS
XM$156 \$I3629 WL0 BLB22 VSS NMOS L=1u W=3.4u AS=6.46p AD=10.88p PS=7.2u
+ PD=13.2u
* device instance $157 r0 *1 399.6,26.1 PMOS
XM$157 \$I3630 \$I3631 VDD VDD PMOS L=1u W=3.4u AS=10.88p AD=6.46p PS=13.2u
+ PD=7.2u
* device instance $158 r0 *1 404.4,26.1 PMOS
XM$158 VDD \$I3630 \$I3631 VDD PMOS L=1u W=3.4u AS=6.46p AD=10.88p PS=7.2u
+ PD=13.2u
* device instance $159 r0 *1 394.8,5.7 NMOS
XM$159 BL16 WL0 \$I3630 VSS NMOS L=1u W=3.4u AS=10.88p AD=6.46p PS=13.2u PD=7.2u
* device instance $160 r0 *1 399.6,5.7 NMOS
XM$160 \$I3630 \$I3631 VSS VSS NMOS L=1u W=3.4u AS=6.46p AD=6.46p PS=7.2u
+ PD=7.2u
* device instance $161 r0 *1 404.4,5.7 NMOS
XM$161 VSS \$I3630 \$I3631 VSS NMOS L=1u W=3.4u AS=6.46p AD=6.46p PS=7.2u
+ PD=7.2u
* device instance $162 r0 *1 409.2,5.7 NMOS
XM$162 \$I3631 WL0 BLB16 VSS NMOS L=1u W=3.4u AS=6.46p AD=10.88p PS=7.2u
+ PD=13.2u
* device instance $163 r0 *1 422.8,26.1 PMOS
XM$163 \$I3632 \$I3633 VDD VDD PMOS L=1u W=3.4u AS=10.88p AD=6.46p PS=13.2u
+ PD=7.2u
* device instance $164 r0 *1 427.6,26.1 PMOS
XM$164 VDD \$I3632 \$I3633 VDD PMOS L=1u W=3.4u AS=6.46p AD=10.88p PS=7.2u
+ PD=13.2u
* device instance $165 r0 *1 418,5.7 NMOS
XM$165 BL17 WL0 \$I3632 VSS NMOS L=1u W=3.4u AS=10.88p AD=6.46p PS=13.2u PD=7.2u
* device instance $166 r0 *1 422.8,5.7 NMOS
XM$166 \$I3632 \$I3633 VSS VSS NMOS L=1u W=3.4u AS=6.46p AD=6.46p PS=7.2u
+ PD=7.2u
* device instance $167 r0 *1 427.6,5.7 NMOS
XM$167 VSS \$I3632 \$I3633 VSS NMOS L=1u W=3.4u AS=6.46p AD=6.46p PS=7.2u
+ PD=7.2u
* device instance $168 r0 *1 432.4,5.7 NMOS
XM$168 \$I3633 WL0 BLB17 VSS NMOS L=1u W=3.4u AS=6.46p AD=10.88p PS=7.2u
+ PD=13.2u
* device instance $169 r0 *1 446,26.1 PMOS
XM$169 \$I3634 \$I3635 VDD VDD PMOS L=1u W=3.4u AS=10.88p AD=6.46p PS=13.2u
+ PD=7.2u
* device instance $170 r0 *1 450.8,26.1 PMOS
XM$170 VDD \$I3634 \$I3635 VDD PMOS L=1u W=3.4u AS=6.46p AD=10.88p PS=7.2u
+ PD=13.2u
* device instance $171 r0 *1 441.2,5.7 NMOS
XM$171 BL18 WL0 \$I3634 VSS NMOS L=1u W=3.4u AS=10.88p AD=6.46p PS=13.2u PD=7.2u
* device instance $172 r0 *1 446,5.7 NMOS
XM$172 \$I3634 \$I3635 VSS VSS NMOS L=1u W=3.4u AS=6.46p AD=6.46p PS=7.2u
+ PD=7.2u
* device instance $173 r0 *1 450.8,5.7 NMOS
XM$173 VSS \$I3634 \$I3635 VSS NMOS L=1u W=3.4u AS=6.46p AD=6.46p PS=7.2u
+ PD=7.2u
* device instance $174 r0 *1 455.6,5.7 NMOS
XM$174 \$I3635 WL0 BLB18 VSS NMOS L=1u W=3.4u AS=6.46p AD=10.88p PS=7.2u
+ PD=13.2u
* device instance $175 r0 *1 7.2,26.1 PMOS
XM$175 \$I3636 \$I3637 VDD VDD PMOS L=1u W=3.4u AS=10.88p AD=6.46p PS=13.2u
+ PD=7.2u
* device instance $176 r0 *1 12,26.1 PMOS
XM$176 VDD \$I3636 \$I3637 VDD PMOS L=1u W=3.4u AS=6.46p AD=10.88p PS=7.2u
+ PD=13.2u
* device instance $177 r0 *1 2.4,5.7 NMOS
XM$177 BL0 WL0 \$I3636 VSS NMOS L=1u W=3.4u AS=10.88p AD=6.46p PS=13.2u PD=7.2u
* device instance $178 r0 *1 7.2,5.7 NMOS
XM$178 \$I3636 \$I3637 VSS VSS NMOS L=1u W=3.4u AS=6.46p AD=6.46p PS=7.2u
+ PD=7.2u
* device instance $179 r0 *1 12,5.7 NMOS
XM$179 VSS \$I3636 \$I3637 VSS NMOS L=1u W=3.4u AS=6.46p AD=6.46p PS=7.2u
+ PD=7.2u
* device instance $180 r0 *1 16.8,5.7 NMOS
XM$180 \$I3637 WL0 BLB0 VSS NMOS L=1u W=3.4u AS=6.46p AD=10.88p PS=7.2u PD=13.2u
* device instance $181 r0 *1 30.4,26.1 PMOS
XM$181 \$I3638 \$I3639 VDD VDD PMOS L=1u W=3.4u AS=10.88p AD=6.46p PS=13.2u
+ PD=7.2u
* device instance $182 r0 *1 35.2,26.1 PMOS
XM$182 VDD \$I3638 \$I3639 VDD PMOS L=1u W=3.4u AS=6.46p AD=10.88p PS=7.2u
+ PD=13.2u
* device instance $183 r0 *1 25.6,5.7 NMOS
XM$183 BL1 WL0 \$I3638 VSS NMOS L=1u W=3.4u AS=10.88p AD=6.46p PS=13.2u PD=7.2u
* device instance $184 r0 *1 30.4,5.7 NMOS
XM$184 \$I3638 \$I3639 VSS VSS NMOS L=1u W=3.4u AS=6.46p AD=6.46p PS=7.2u
+ PD=7.2u
* device instance $185 r0 *1 35.2,5.7 NMOS
XM$185 VSS \$I3638 \$I3639 VSS NMOS L=1u W=3.4u AS=6.46p AD=6.46p PS=7.2u
+ PD=7.2u
* device instance $186 r0 *1 40,5.7 NMOS
XM$186 \$I3639 WL0 BLB1 VSS NMOS L=1u W=3.4u AS=6.46p AD=10.88p PS=7.2u PD=13.2u
* device instance $187 r0 *1 192.8,26.1 PMOS
XM$187 \$I3640 \$I3641 VDD VDD PMOS L=1u W=3.4u AS=10.88p AD=6.46p PS=13.2u
+ PD=7.2u
* device instance $188 r0 *1 197.6,26.1 PMOS
XM$188 VDD \$I3640 \$I3641 VDD PMOS L=1u W=3.4u AS=6.46p AD=10.88p PS=7.2u
+ PD=13.2u
* device instance $189 r0 *1 188,5.7 NMOS
XM$189 BL8 WL0 \$I3640 VSS NMOS L=1u W=3.4u AS=10.88p AD=6.46p PS=13.2u PD=7.2u
* device instance $190 r0 *1 192.8,5.7 NMOS
XM$190 \$I3640 \$I3641 VSS VSS NMOS L=1u W=3.4u AS=6.46p AD=6.46p PS=7.2u
+ PD=7.2u
* device instance $191 r0 *1 197.6,5.7 NMOS
XM$191 VSS \$I3640 \$I3641 VSS NMOS L=1u W=3.4u AS=6.46p AD=6.46p PS=7.2u
+ PD=7.2u
* device instance $192 r0 *1 202.4,5.7 NMOS
XM$192 \$I3641 WL0 BLB8 VSS NMOS L=1u W=3.4u AS=6.46p AD=10.88p PS=7.2u PD=13.2u
* device instance $193 m0 *1 308.8,210.7 PMOS
XM$193 \$I3642 \$I3643 VDD VDD PMOS L=1u W=3.4u AS=10.88p AD=6.46p PS=13.2u
+ PD=7.2u
* device instance $194 m0 *1 313.6,210.7 PMOS
XM$194 VDD \$I3642 \$I3643 VDD PMOS L=1u W=3.4u AS=6.46p AD=10.88p PS=7.2u
+ PD=13.2u
* device instance $195 m0 *1 304,231.1 NMOS
XM$195 BL13 WL7 \$I3642 VSS NMOS L=1u W=3.4u AS=10.88p AD=6.46p PS=13.2u PD=7.2u
* device instance $196 m0 *1 308.8,231.1 NMOS
XM$196 \$I3642 \$I3643 VSS VSS NMOS L=1u W=3.4u AS=6.46p AD=6.46p PS=7.2u
+ PD=7.2u
* device instance $197 m0 *1 313.6,231.1 NMOS
XM$197 VSS \$I3642 \$I3643 VSS NMOS L=1u W=3.4u AS=6.46p AD=6.46p PS=7.2u
+ PD=7.2u
* device instance $198 m0 *1 318.4,231.1 NMOS
XM$198 \$I3643 WL7 BLB13 VSS NMOS L=1u W=3.4u AS=6.46p AD=10.88p PS=7.2u
+ PD=13.2u
* device instance $199 m0 *1 332,210.7 PMOS
XM$199 \$I3644 \$I3645 VDD VDD PMOS L=1u W=3.4u AS=10.88p AD=6.46p PS=13.2u
+ PD=7.2u
* device instance $200 m0 *1 336.8,210.7 PMOS
XM$200 VDD \$I3644 \$I3645 VDD PMOS L=1u W=3.4u AS=6.46p AD=10.88p PS=7.2u
+ PD=13.2u
* device instance $201 m0 *1 327.2,231.1 NMOS
XM$201 BL14 WL7 \$I3644 VSS NMOS L=1u W=3.4u AS=10.88p AD=6.46p PS=13.2u PD=7.2u
* device instance $202 m0 *1 332,231.1 NMOS
XM$202 \$I3644 \$I3645 VSS VSS NMOS L=1u W=3.4u AS=6.46p AD=6.46p PS=7.2u
+ PD=7.2u
* device instance $203 m0 *1 336.8,231.1 NMOS
XM$203 VSS \$I3644 \$I3645 VSS NMOS L=1u W=3.4u AS=6.46p AD=6.46p PS=7.2u
+ PD=7.2u
* device instance $204 m0 *1 341.6,231.1 NMOS
XM$204 \$I3645 WL7 BLB14 VSS NMOS L=1u W=3.4u AS=6.46p AD=10.88p PS=7.2u
+ PD=13.2u
* device instance $205 m0 *1 355.2,210.7 PMOS
XM$205 \$I3646 \$I3647 VDD VDD PMOS L=1u W=3.4u AS=10.88p AD=6.46p PS=13.2u
+ PD=7.2u
* device instance $206 m0 *1 360,210.7 PMOS
XM$206 VDD \$I3646 \$I3647 VDD PMOS L=1u W=3.4u AS=6.46p AD=10.88p PS=7.2u
+ PD=13.2u
* device instance $207 m0 *1 350.4,231.1 NMOS
XM$207 BL15 WL7 \$I3646 VSS NMOS L=1u W=3.4u AS=10.88p AD=6.46p PS=13.2u PD=7.2u
* device instance $208 m0 *1 355.2,231.1 NMOS
XM$208 \$I3646 \$I3647 VSS VSS NMOS L=1u W=3.4u AS=6.46p AD=6.46p PS=7.2u
+ PD=7.2u
* device instance $209 m0 *1 360,231.1 NMOS
XM$209 VSS \$I3646 \$I3647 VSS NMOS L=1u W=3.4u AS=6.46p AD=6.46p PS=7.2u
+ PD=7.2u
* device instance $210 m0 *1 364.8,231.1 NMOS
XM$210 \$I3647 WL7 BLB15 VSS NMOS L=1u W=3.4u AS=6.46p AD=10.88p PS=7.2u
+ PD=13.2u
* device instance $211 m0 *1 631.6,269.9 PMOS
XM$211 \$I3648 \$I3649 VDD VDD PMOS L=1u W=3.4u AS=10.88p AD=6.46p PS=13.2u
+ PD=7.2u
* device instance $212 m0 *1 636.4,269.9 PMOS
XM$212 VDD \$I3648 \$I3649 VDD PMOS L=1u W=3.4u AS=6.46p AD=10.88p PS=7.2u
+ PD=13.2u
* device instance $213 m0 *1 626.8,290.3 NMOS
XM$213 BL26 WL9 \$I3648 VSS NMOS L=1u W=3.4u AS=10.88p AD=6.46p PS=13.2u PD=7.2u
* device instance $214 m0 *1 631.6,290.3 NMOS
XM$214 \$I3648 \$I3649 VSS VSS NMOS L=1u W=3.4u AS=6.46p AD=6.46p PS=7.2u
+ PD=7.2u
* device instance $215 m0 *1 636.4,290.3 NMOS
XM$215 VSS \$I3648 \$I3649 VSS NMOS L=1u W=3.4u AS=6.46p AD=6.46p PS=7.2u
+ PD=7.2u
* device instance $216 m0 *1 641.2,290.3 NMOS
XM$216 \$I3649 WL9 BLB26 VSS NMOS L=1u W=3.4u AS=6.46p AD=10.88p PS=7.2u
+ PD=13.2u
* device instance $217 m0 *1 608.4,269.9 PMOS
XM$217 \$I3650 \$I3651 VDD VDD PMOS L=1u W=3.4u AS=10.88p AD=6.46p PS=13.2u
+ PD=7.2u
* device instance $218 m0 *1 613.2,269.9 PMOS
XM$218 VDD \$I3650 \$I3651 VDD PMOS L=1u W=3.4u AS=6.46p AD=10.88p PS=7.2u
+ PD=13.2u
* device instance $219 m0 *1 603.6,290.3 NMOS
XM$219 BL25 WL9 \$I3650 VSS NMOS L=1u W=3.4u AS=10.88p AD=6.46p PS=13.2u PD=7.2u
* device instance $220 m0 *1 608.4,290.3 NMOS
XM$220 \$I3650 \$I3651 VSS VSS NMOS L=1u W=3.4u AS=6.46p AD=6.46p PS=7.2u
+ PD=7.2u
* device instance $221 m0 *1 613.2,290.3 NMOS
XM$221 VSS \$I3650 \$I3651 VSS NMOS L=1u W=3.4u AS=6.46p AD=6.46p PS=7.2u
+ PD=7.2u
* device instance $222 m0 *1 618,290.3 NMOS
XM$222 \$I3651 WL9 BLB25 VSS NMOS L=1u W=3.4u AS=6.46p AD=10.88p PS=7.2u
+ PD=13.2u
* device instance $223 m0 *1 585.2,269.9 PMOS
XM$223 \$I3652 \$I3653 VDD VDD PMOS L=1u W=3.4u AS=10.88p AD=6.46p PS=13.2u
+ PD=7.2u
* device instance $224 m0 *1 590,269.9 PMOS
XM$224 VDD \$I3652 \$I3653 VDD PMOS L=1u W=3.4u AS=6.46p AD=10.88p PS=7.2u
+ PD=13.2u
* device instance $225 m0 *1 580.4,290.3 NMOS
XM$225 BL24 WL9 \$I3652 VSS NMOS L=1u W=3.4u AS=10.88p AD=6.46p PS=13.2u PD=7.2u
* device instance $226 m0 *1 585.2,290.3 NMOS
XM$226 \$I3652 \$I3653 VSS VSS NMOS L=1u W=3.4u AS=6.46p AD=6.46p PS=7.2u
+ PD=7.2u
* device instance $227 m0 *1 590,290.3 NMOS
XM$227 VSS \$I3652 \$I3653 VSS NMOS L=1u W=3.4u AS=6.46p AD=6.46p PS=7.2u
+ PD=7.2u
* device instance $228 m0 *1 594.8,290.3 NMOS
XM$228 \$I3653 WL9 BLB24 VSS NMOS L=1u W=3.4u AS=6.46p AD=10.88p PS=7.2u
+ PD=13.2u
* device instance $229 m0 *1 7.2,151.5 PMOS
XM$229 \$I3654 \$I3655 VDD VDD PMOS L=1u W=3.4u AS=10.88p AD=6.46p PS=13.2u
+ PD=7.2u
* device instance $230 m0 *1 12,151.5 PMOS
XM$230 VDD \$I3654 \$I3655 VDD PMOS L=1u W=3.4u AS=6.46p AD=10.88p PS=7.2u
+ PD=13.2u
* device instance $231 m0 *1 2.4,171.9 NMOS
XM$231 BL0 WL5 \$I3654 VSS NMOS L=1u W=3.4u AS=10.88p AD=6.46p PS=13.2u PD=7.2u
* device instance $232 m0 *1 7.2,171.9 NMOS
XM$232 \$I3654 \$I3655 VSS VSS NMOS L=1u W=3.4u AS=6.46p AD=6.46p PS=7.2u
+ PD=7.2u
* device instance $233 m0 *1 12,171.9 NMOS
XM$233 VSS \$I3654 \$I3655 VSS NMOS L=1u W=3.4u AS=6.46p AD=6.46p PS=7.2u
+ PD=7.2u
* device instance $234 m0 *1 16.8,171.9 NMOS
XM$234 \$I3655 WL5 BLB0 VSS NMOS L=1u W=3.4u AS=6.46p AD=10.88p PS=7.2u PD=13.2u
* device instance $235 m0 *1 30.4,151.5 PMOS
XM$235 \$I3656 \$I3657 VDD VDD PMOS L=1u W=3.4u AS=10.88p AD=6.46p PS=13.2u
+ PD=7.2u
* device instance $236 m0 *1 35.2,151.5 PMOS
XM$236 VDD \$I3656 \$I3657 VDD PMOS L=1u W=3.4u AS=6.46p AD=10.88p PS=7.2u
+ PD=13.2u
* device instance $237 m0 *1 25.6,171.9 NMOS
XM$237 BL1 WL5 \$I3656 VSS NMOS L=1u W=3.4u AS=10.88p AD=6.46p PS=13.2u PD=7.2u
* device instance $238 m0 *1 30.4,171.9 NMOS
XM$238 \$I3656 \$I3657 VSS VSS NMOS L=1u W=3.4u AS=6.46p AD=6.46p PS=7.2u
+ PD=7.2u
* device instance $239 m0 *1 35.2,171.9 NMOS
XM$239 VSS \$I3656 \$I3657 VSS NMOS L=1u W=3.4u AS=6.46p AD=6.46p PS=7.2u
+ PD=7.2u
* device instance $240 m0 *1 40,171.9 NMOS
XM$240 \$I3657 WL5 BLB1 VSS NMOS L=1u W=3.4u AS=6.46p AD=10.88p PS=7.2u PD=13.2u
* device instance $241 m0 *1 355.2,33.1 PMOS
XM$241 \$I3658 \$I3659 VDD VDD PMOS L=1u W=3.4u AS=10.88p AD=6.46p PS=13.2u
+ PD=7.2u
* device instance $242 m0 *1 360,33.1 PMOS
XM$242 VDD \$I3658 \$I3659 VDD PMOS L=1u W=3.4u AS=6.46p AD=10.88p PS=7.2u
+ PD=13.2u
* device instance $243 m0 *1 350.4,53.5 NMOS
XM$243 BL15 WL1 \$I3658 VSS NMOS L=1u W=3.4u AS=10.88p AD=6.46p PS=13.2u PD=7.2u
* device instance $244 m0 *1 355.2,53.5 NMOS
XM$244 \$I3658 \$I3659 VSS VSS NMOS L=1u W=3.4u AS=6.46p AD=6.46p PS=7.2u
+ PD=7.2u
* device instance $245 m0 *1 360,53.5 NMOS
XM$245 VSS \$I3658 \$I3659 VSS NMOS L=1u W=3.4u AS=6.46p AD=6.46p PS=7.2u
+ PD=7.2u
* device instance $246 m0 *1 364.8,53.5 NMOS
XM$246 \$I3659 WL1 BLB15 VSS NMOS L=1u W=3.4u AS=6.46p AD=10.88p PS=7.2u
+ PD=13.2u
* device instance $247 m0 *1 76.8,151.5 PMOS
XM$247 \$I3660 \$I3661 VDD VDD PMOS L=1u W=3.4u AS=10.88p AD=6.46p PS=13.2u
+ PD=7.2u
* device instance $248 m0 *1 81.6,151.5 PMOS
XM$248 VDD \$I3660 \$I3661 VDD PMOS L=1u W=3.4u AS=6.46p AD=10.88p PS=7.2u
+ PD=13.2u
* device instance $249 m0 *1 72,171.9 NMOS
XM$249 BL3 WL5 \$I3660 VSS NMOS L=1u W=3.4u AS=10.88p AD=6.46p PS=13.2u PD=7.2u
* device instance $250 m0 *1 76.8,171.9 NMOS
XM$250 \$I3660 \$I3661 VSS VSS NMOS L=1u W=3.4u AS=6.46p AD=6.46p PS=7.2u
+ PD=7.2u
* device instance $251 m0 *1 81.6,171.9 NMOS
XM$251 VSS \$I3660 \$I3661 VSS NMOS L=1u W=3.4u AS=6.46p AD=6.46p PS=7.2u
+ PD=7.2u
* device instance $252 m0 *1 86.4,171.9 NMOS
XM$252 \$I3661 WL5 BLB3 VSS NMOS L=1u W=3.4u AS=6.46p AD=10.88p PS=7.2u PD=13.2u
* device instance $253 m0 *1 100,151.5 PMOS
XM$253 \$I3662 \$I3663 VDD VDD PMOS L=1u W=3.4u AS=10.88p AD=6.46p PS=13.2u
+ PD=7.2u
* device instance $254 m0 *1 104.8,151.5 PMOS
XM$254 VDD \$I3662 \$I3663 VDD PMOS L=1u W=3.4u AS=6.46p AD=10.88p PS=7.2u
+ PD=13.2u
* device instance $255 m0 *1 95.2,171.9 NMOS
XM$255 BL4 WL5 \$I3662 VSS NMOS L=1u W=3.4u AS=10.88p AD=6.46p PS=13.2u PD=7.2u
* device instance $256 m0 *1 100,171.9 NMOS
XM$256 \$I3662 \$I3663 VSS VSS NMOS L=1u W=3.4u AS=6.46p AD=6.46p PS=7.2u
+ PD=7.2u
* device instance $257 m0 *1 104.8,171.9 NMOS
XM$257 VSS \$I3662 \$I3663 VSS NMOS L=1u W=3.4u AS=6.46p AD=6.46p PS=7.2u
+ PD=7.2u
* device instance $258 m0 *1 109.6,171.9 NMOS
XM$258 \$I3663 WL5 BLB4 VSS NMOS L=1u W=3.4u AS=6.46p AD=10.88p PS=7.2u PD=13.2u
* device instance $259 m0 *1 123.2,151.5 PMOS
XM$259 \$I3664 \$I3665 VDD VDD PMOS L=1u W=3.4u AS=10.88p AD=6.46p PS=13.2u
+ PD=7.2u
* device instance $260 m0 *1 128,151.5 PMOS
XM$260 VDD \$I3664 \$I3665 VDD PMOS L=1u W=3.4u AS=6.46p AD=10.88p PS=7.2u
+ PD=13.2u
* device instance $261 m0 *1 118.4,171.9 NMOS
XM$261 BL5 WL5 \$I3664 VSS NMOS L=1u W=3.4u AS=10.88p AD=6.46p PS=13.2u PD=7.2u
* device instance $262 m0 *1 123.2,171.9 NMOS
XM$262 \$I3664 \$I3665 VSS VSS NMOS L=1u W=3.4u AS=6.46p AD=6.46p PS=7.2u
+ PD=7.2u
* device instance $263 m0 *1 128,171.9 NMOS
XM$263 VSS \$I3664 \$I3665 VSS NMOS L=1u W=3.4u AS=6.46p AD=6.46p PS=7.2u
+ PD=7.2u
* device instance $264 m0 *1 132.8,171.9 NMOS
XM$264 \$I3665 WL5 BLB5 VSS NMOS L=1u W=3.4u AS=6.46p AD=10.88p PS=7.2u PD=13.2u
* device instance $265 m0 *1 146.4,151.5 PMOS
XM$265 \$I3666 \$I3667 VDD VDD PMOS L=1u W=3.4u AS=10.88p AD=6.46p PS=13.2u
+ PD=7.2u
* device instance $266 m0 *1 151.2,151.5 PMOS
XM$266 VDD \$I3666 \$I3667 VDD PMOS L=1u W=3.4u AS=6.46p AD=10.88p PS=7.2u
+ PD=13.2u
* device instance $267 m0 *1 141.6,171.9 NMOS
XM$267 BL6 WL5 \$I3666 VSS NMOS L=1u W=3.4u AS=10.88p AD=6.46p PS=13.2u PD=7.2u
* device instance $268 m0 *1 146.4,171.9 NMOS
XM$268 \$I3666 \$I3667 VSS VSS NMOS L=1u W=3.4u AS=6.46p AD=6.46p PS=7.2u
+ PD=7.2u
* device instance $269 m0 *1 151.2,171.9 NMOS
XM$269 VSS \$I3666 \$I3667 VSS NMOS L=1u W=3.4u AS=6.46p AD=6.46p PS=7.2u
+ PD=7.2u
* device instance $270 m0 *1 156,171.9 NMOS
XM$270 \$I3667 WL5 BLB6 VSS NMOS L=1u W=3.4u AS=6.46p AD=10.88p PS=7.2u PD=13.2u
* device instance $271 m0 *1 169.6,151.5 PMOS
XM$271 \$I3668 \$I3669 VDD VDD PMOS L=1u W=3.4u AS=10.88p AD=6.46p PS=13.2u
+ PD=7.2u
* device instance $272 m0 *1 174.4,151.5 PMOS
XM$272 VDD \$I3668 \$I3669 VDD PMOS L=1u W=3.4u AS=6.46p AD=10.88p PS=7.2u
+ PD=13.2u
* device instance $273 m0 *1 164.8,171.9 NMOS
XM$273 BL7 WL5 \$I3668 VSS NMOS L=1u W=3.4u AS=10.88p AD=6.46p PS=13.2u PD=7.2u
* device instance $274 m0 *1 169.6,171.9 NMOS
XM$274 \$I3668 \$I3669 VSS VSS NMOS L=1u W=3.4u AS=6.46p AD=6.46p PS=7.2u
+ PD=7.2u
* device instance $275 m0 *1 174.4,171.9 NMOS
XM$275 VSS \$I3668 \$I3669 VSS NMOS L=1u W=3.4u AS=6.46p AD=6.46p PS=7.2u
+ PD=7.2u
* device instance $276 m0 *1 179.2,171.9 NMOS
XM$276 \$I3669 WL5 BLB7 VSS NMOS L=1u W=3.4u AS=6.46p AD=10.88p PS=7.2u PD=13.2u
* device instance $277 m0 *1 7.2,210.7 PMOS
XM$277 \$I3670 \$I3671 VDD VDD PMOS L=1u W=3.4u AS=10.88p AD=6.46p PS=13.2u
+ PD=7.2u
* device instance $278 m0 *1 12,210.7 PMOS
XM$278 VDD \$I3670 \$I3671 VDD PMOS L=1u W=3.4u AS=6.46p AD=10.88p PS=7.2u
+ PD=13.2u
* device instance $279 m0 *1 2.4,231.1 NMOS
XM$279 BL0 WL7 \$I3670 VSS NMOS L=1u W=3.4u AS=10.88p AD=6.46p PS=13.2u PD=7.2u
* device instance $280 m0 *1 7.2,231.1 NMOS
XM$280 \$I3670 \$I3671 VSS VSS NMOS L=1u W=3.4u AS=6.46p AD=6.46p PS=7.2u
+ PD=7.2u
* device instance $281 m0 *1 12,231.1 NMOS
XM$281 VSS \$I3670 \$I3671 VSS NMOS L=1u W=3.4u AS=6.46p AD=6.46p PS=7.2u
+ PD=7.2u
* device instance $282 m0 *1 16.8,231.1 NMOS
XM$282 \$I3671 WL7 BLB0 VSS NMOS L=1u W=3.4u AS=6.46p AD=10.88p PS=7.2u PD=13.2u
* device instance $283 m0 *1 30.4,210.7 PMOS
XM$283 \$I3672 \$I3673 VDD VDD PMOS L=1u W=3.4u AS=10.88p AD=6.46p PS=13.2u
+ PD=7.2u
* device instance $284 m0 *1 35.2,210.7 PMOS
XM$284 VDD \$I3672 \$I3673 VDD PMOS L=1u W=3.4u AS=6.46p AD=10.88p PS=7.2u
+ PD=13.2u
* device instance $285 m0 *1 25.6,231.1 NMOS
XM$285 BL1 WL7 \$I3672 VSS NMOS L=1u W=3.4u AS=10.88p AD=6.46p PS=13.2u PD=7.2u
* device instance $286 m0 *1 30.4,231.1 NMOS
XM$286 \$I3672 \$I3673 VSS VSS NMOS L=1u W=3.4u AS=6.46p AD=6.46p PS=7.2u
+ PD=7.2u
* device instance $287 m0 *1 35.2,231.1 NMOS
XM$287 VSS \$I3672 \$I3673 VSS NMOS L=1u W=3.4u AS=6.46p AD=6.46p PS=7.2u
+ PD=7.2u
* device instance $288 m0 *1 40,231.1 NMOS
XM$288 \$I3673 WL7 BLB1 VSS NMOS L=1u W=3.4u AS=6.46p AD=10.88p PS=7.2u PD=13.2u
* device instance $289 m0 *1 53.6,210.7 PMOS
XM$289 \$I3674 \$I3675 VDD VDD PMOS L=1u W=3.4u AS=10.88p AD=6.46p PS=13.2u
+ PD=7.2u
* device instance $290 m0 *1 58.4,210.7 PMOS
XM$290 VDD \$I3674 \$I3675 VDD PMOS L=1u W=3.4u AS=6.46p AD=10.88p PS=7.2u
+ PD=13.2u
* device instance $291 m0 *1 48.8,231.1 NMOS
XM$291 BL2 WL7 \$I3674 VSS NMOS L=1u W=3.4u AS=10.88p AD=6.46p PS=13.2u PD=7.2u
* device instance $292 m0 *1 53.6,231.1 NMOS
XM$292 \$I3674 \$I3675 VSS VSS NMOS L=1u W=3.4u AS=6.46p AD=6.46p PS=7.2u
+ PD=7.2u
* device instance $293 m0 *1 58.4,231.1 NMOS
XM$293 VSS \$I3674 \$I3675 VSS NMOS L=1u W=3.4u AS=6.46p AD=6.46p PS=7.2u
+ PD=7.2u
* device instance $294 m0 *1 63.2,231.1 NMOS
XM$294 \$I3675 WL7 BLB2 VSS NMOS L=1u W=3.4u AS=6.46p AD=10.88p PS=7.2u PD=13.2u
* device instance $295 m0 *1 53.6,151.5 PMOS
XM$295 \$I3676 \$I3677 VDD VDD PMOS L=1u W=3.4u AS=10.88p AD=6.46p PS=13.2u
+ PD=7.2u
* device instance $296 m0 *1 58.4,151.5 PMOS
XM$296 VDD \$I3676 \$I3677 VDD PMOS L=1u W=3.4u AS=6.46p AD=10.88p PS=7.2u
+ PD=13.2u
* device instance $297 m0 *1 48.8,171.9 NMOS
XM$297 BL2 WL5 \$I3676 VSS NMOS L=1u W=3.4u AS=10.88p AD=6.46p PS=13.2u PD=7.2u
* device instance $298 m0 *1 53.6,171.9 NMOS
XM$298 \$I3676 \$I3677 VSS VSS NMOS L=1u W=3.4u AS=6.46p AD=6.46p PS=7.2u
+ PD=7.2u
* device instance $299 m0 *1 58.4,171.9 NMOS
XM$299 VSS \$I3676 \$I3677 VSS NMOS L=1u W=3.4u AS=6.46p AD=6.46p PS=7.2u
+ PD=7.2u
* device instance $300 m0 *1 63.2,171.9 NMOS
XM$300 \$I3677 WL5 BLB2 VSS NMOS L=1u W=3.4u AS=6.46p AD=10.88p PS=7.2u PD=13.2u
* device instance $301 m0 *1 262.4,151.5 PMOS
XM$301 \$I3678 \$I3679 VDD VDD PMOS L=1u W=3.4u AS=10.88p AD=6.46p PS=13.2u
+ PD=7.2u
* device instance $302 m0 *1 267.2,151.5 PMOS
XM$302 VDD \$I3678 \$I3679 VDD PMOS L=1u W=3.4u AS=6.46p AD=10.88p PS=7.2u
+ PD=13.2u
* device instance $303 m0 *1 257.6,171.9 NMOS
XM$303 BL11 WL5 \$I3678 VSS NMOS L=1u W=3.4u AS=10.88p AD=6.46p PS=13.2u PD=7.2u
* device instance $304 m0 *1 262.4,171.9 NMOS
XM$304 \$I3678 \$I3679 VSS VSS NMOS L=1u W=3.4u AS=6.46p AD=6.46p PS=7.2u
+ PD=7.2u
* device instance $305 m0 *1 267.2,171.9 NMOS
XM$305 VSS \$I3678 \$I3679 VSS NMOS L=1u W=3.4u AS=6.46p AD=6.46p PS=7.2u
+ PD=7.2u
* device instance $306 m0 *1 272,171.9 NMOS
XM$306 \$I3679 WL5 BLB11 VSS NMOS L=1u W=3.4u AS=6.46p AD=10.88p PS=7.2u
+ PD=13.2u
* device instance $307 m0 *1 285.6,151.5 PMOS
XM$307 \$I3680 \$I3681 VDD VDD PMOS L=1u W=3.4u AS=10.88p AD=6.46p PS=13.2u
+ PD=7.2u
* device instance $308 m0 *1 290.4,151.5 PMOS
XM$308 VDD \$I3680 \$I3681 VDD PMOS L=1u W=3.4u AS=6.46p AD=10.88p PS=7.2u
+ PD=13.2u
* device instance $309 m0 *1 280.8,171.9 NMOS
XM$309 BL12 WL5 \$I3680 VSS NMOS L=1u W=3.4u AS=10.88p AD=6.46p PS=13.2u PD=7.2u
* device instance $310 m0 *1 285.6,171.9 NMOS
XM$310 \$I3680 \$I3681 VSS VSS NMOS L=1u W=3.4u AS=6.46p AD=6.46p PS=7.2u
+ PD=7.2u
* device instance $311 m0 *1 290.4,171.9 NMOS
XM$311 VSS \$I3680 \$I3681 VSS NMOS L=1u W=3.4u AS=6.46p AD=6.46p PS=7.2u
+ PD=7.2u
* device instance $312 m0 *1 295.2,171.9 NMOS
XM$312 \$I3681 WL5 BLB12 VSS NMOS L=1u W=3.4u AS=6.46p AD=10.88p PS=7.2u
+ PD=13.2u
* device instance $313 m0 *1 308.8,151.5 PMOS
XM$313 \$I3682 \$I3683 VDD VDD PMOS L=1u W=3.4u AS=10.88p AD=6.46p PS=13.2u
+ PD=7.2u
* device instance $314 m0 *1 313.6,151.5 PMOS
XM$314 VDD \$I3682 \$I3683 VDD PMOS L=1u W=3.4u AS=6.46p AD=10.88p PS=7.2u
+ PD=13.2u
* device instance $315 m0 *1 304,171.9 NMOS
XM$315 BL13 WL5 \$I3682 VSS NMOS L=1u W=3.4u AS=10.88p AD=6.46p PS=13.2u PD=7.2u
* device instance $316 m0 *1 308.8,171.9 NMOS
XM$316 \$I3682 \$I3683 VSS VSS NMOS L=1u W=3.4u AS=6.46p AD=6.46p PS=7.2u
+ PD=7.2u
* device instance $317 m0 *1 313.6,171.9 NMOS
XM$317 VSS \$I3682 \$I3683 VSS NMOS L=1u W=3.4u AS=6.46p AD=6.46p PS=7.2u
+ PD=7.2u
* device instance $318 m0 *1 318.4,171.9 NMOS
XM$318 \$I3683 WL5 BLB13 VSS NMOS L=1u W=3.4u AS=6.46p AD=10.88p PS=7.2u
+ PD=13.2u
* device instance $319 m0 *1 332,151.5 PMOS
XM$319 \$I3684 \$I3685 VDD VDD PMOS L=1u W=3.4u AS=10.88p AD=6.46p PS=13.2u
+ PD=7.2u
* device instance $320 m0 *1 336.8,151.5 PMOS
XM$320 VDD \$I3684 \$I3685 VDD PMOS L=1u W=3.4u AS=6.46p AD=10.88p PS=7.2u
+ PD=13.2u
* device instance $321 m0 *1 327.2,171.9 NMOS
XM$321 BL14 WL5 \$I3684 VSS NMOS L=1u W=3.4u AS=10.88p AD=6.46p PS=13.2u PD=7.2u
* device instance $322 m0 *1 332,171.9 NMOS
XM$322 \$I3684 \$I3685 VSS VSS NMOS L=1u W=3.4u AS=6.46p AD=6.46p PS=7.2u
+ PD=7.2u
* device instance $323 m0 *1 336.8,171.9 NMOS
XM$323 VSS \$I3684 \$I3685 VSS NMOS L=1u W=3.4u AS=6.46p AD=6.46p PS=7.2u
+ PD=7.2u
* device instance $324 m0 *1 341.6,171.9 NMOS
XM$324 \$I3685 WL5 BLB14 VSS NMOS L=1u W=3.4u AS=6.46p AD=10.88p PS=7.2u
+ PD=13.2u
* device instance $325 m0 *1 355.2,151.5 PMOS
XM$325 \$I3686 \$I3687 VDD VDD PMOS L=1u W=3.4u AS=10.88p AD=6.46p PS=13.2u
+ PD=7.2u
* device instance $326 m0 *1 360,151.5 PMOS
XM$326 VDD \$I3686 \$I3687 VDD PMOS L=1u W=3.4u AS=6.46p AD=10.88p PS=7.2u
+ PD=13.2u
* device instance $327 m0 *1 350.4,171.9 NMOS
XM$327 BL15 WL5 \$I3686 VSS NMOS L=1u W=3.4u AS=10.88p AD=6.46p PS=13.2u PD=7.2u
* device instance $328 m0 *1 355.2,171.9 NMOS
XM$328 \$I3686 \$I3687 VSS VSS NMOS L=1u W=3.4u AS=6.46p AD=6.46p PS=7.2u
+ PD=7.2u
* device instance $329 m0 *1 360,171.9 NMOS
XM$329 VSS \$I3686 \$I3687 VSS NMOS L=1u W=3.4u AS=6.46p AD=6.46p PS=7.2u
+ PD=7.2u
* device instance $330 m0 *1 364.8,171.9 NMOS
XM$330 \$I3687 WL5 BLB15 VSS NMOS L=1u W=3.4u AS=6.46p AD=10.88p PS=7.2u
+ PD=13.2u
* device instance $331 m0 *1 654.8,329.1 PMOS
XM$331 \$I3688 \$I3689 VDD VDD PMOS L=1u W=3.4u AS=10.88p AD=6.46p PS=13.2u
+ PD=7.2u
* device instance $332 m0 *1 659.6,329.1 PMOS
XM$332 VDD \$I3688 \$I3689 VDD PMOS L=1u W=3.4u AS=6.46p AD=10.88p PS=7.2u
+ PD=13.2u
* device instance $333 m0 *1 650,349.5 NMOS
XM$333 BL27 WL11 \$I3688 VSS NMOS L=1u W=3.4u AS=10.88p AD=6.46p PS=13.2u
+ PD=7.2u
* device instance $334 m0 *1 654.8,349.5 NMOS
XM$334 \$I3688 \$I3689 VSS VSS NMOS L=1u W=3.4u AS=6.46p AD=6.46p PS=7.2u
+ PD=7.2u
* device instance $335 m0 *1 659.6,349.5 NMOS
XM$335 VSS \$I3688 \$I3689 VSS NMOS L=1u W=3.4u AS=6.46p AD=6.46p PS=7.2u
+ PD=7.2u
* device instance $336 m0 *1 664.4,349.5 NMOS
XM$336 \$I3689 WL11 BLB27 VSS NMOS L=1u W=3.4u AS=6.46p AD=10.88p PS=7.2u
+ PD=13.2u
* device instance $337 m0 *1 631.6,329.1 PMOS
XM$337 \$I3690 \$I3691 VDD VDD PMOS L=1u W=3.4u AS=10.88p AD=6.46p PS=13.2u
+ PD=7.2u
* device instance $338 m0 *1 636.4,329.1 PMOS
XM$338 VDD \$I3690 \$I3691 VDD PMOS L=1u W=3.4u AS=6.46p AD=10.88p PS=7.2u
+ PD=13.2u
* device instance $339 m0 *1 626.8,349.5 NMOS
XM$339 BL26 WL11 \$I3690 VSS NMOS L=1u W=3.4u AS=10.88p AD=6.46p PS=13.2u
+ PD=7.2u
* device instance $340 m0 *1 631.6,349.5 NMOS
XM$340 \$I3690 \$I3691 VSS VSS NMOS L=1u W=3.4u AS=6.46p AD=6.46p PS=7.2u
+ PD=7.2u
* device instance $341 m0 *1 636.4,349.5 NMOS
XM$341 VSS \$I3690 \$I3691 VSS NMOS L=1u W=3.4u AS=6.46p AD=6.46p PS=7.2u
+ PD=7.2u
* device instance $342 m0 *1 641.2,349.5 NMOS
XM$342 \$I3691 WL11 BLB26 VSS NMOS L=1u W=3.4u AS=6.46p AD=10.88p PS=7.2u
+ PD=13.2u
* device instance $343 m0 *1 608.4,329.1 PMOS
XM$343 \$I3692 \$I3693 VDD VDD PMOS L=1u W=3.4u AS=10.88p AD=6.46p PS=13.2u
+ PD=7.2u
* device instance $344 m0 *1 613.2,329.1 PMOS
XM$344 VDD \$I3692 \$I3693 VDD PMOS L=1u W=3.4u AS=6.46p AD=10.88p PS=7.2u
+ PD=13.2u
* device instance $345 m0 *1 603.6,349.5 NMOS
XM$345 BL25 WL11 \$I3692 VSS NMOS L=1u W=3.4u AS=10.88p AD=6.46p PS=13.2u
+ PD=7.2u
* device instance $346 m0 *1 608.4,349.5 NMOS
XM$346 \$I3692 \$I3693 VSS VSS NMOS L=1u W=3.4u AS=6.46p AD=6.46p PS=7.2u
+ PD=7.2u
* device instance $347 m0 *1 613.2,349.5 NMOS
XM$347 VSS \$I3692 \$I3693 VSS NMOS L=1u W=3.4u AS=6.46p AD=6.46p PS=7.2u
+ PD=7.2u
* device instance $348 m0 *1 618,349.5 NMOS
XM$348 \$I3693 WL11 BLB25 VSS NMOS L=1u W=3.4u AS=6.46p AD=10.88p PS=7.2u
+ PD=13.2u
* device instance $349 m0 *1 285.6,210.7 PMOS
XM$349 \$I3694 \$I3695 VDD VDD PMOS L=1u W=3.4u AS=10.88p AD=6.46p PS=13.2u
+ PD=7.2u
* device instance $350 m0 *1 290.4,210.7 PMOS
XM$350 VDD \$I3694 \$I3695 VDD PMOS L=1u W=3.4u AS=6.46p AD=10.88p PS=7.2u
+ PD=13.2u
* device instance $351 m0 *1 280.8,231.1 NMOS
XM$351 BL12 WL7 \$I3694 VSS NMOS L=1u W=3.4u AS=10.88p AD=6.46p PS=13.2u PD=7.2u
* device instance $352 m0 *1 285.6,231.1 NMOS
XM$352 \$I3694 \$I3695 VSS VSS NMOS L=1u W=3.4u AS=6.46p AD=6.46p PS=7.2u
+ PD=7.2u
* device instance $353 m0 *1 290.4,231.1 NMOS
XM$353 VSS \$I3694 \$I3695 VSS NMOS L=1u W=3.4u AS=6.46p AD=6.46p PS=7.2u
+ PD=7.2u
* device instance $354 m0 *1 295.2,231.1 NMOS
XM$354 \$I3695 WL7 BLB12 VSS NMOS L=1u W=3.4u AS=6.46p AD=10.88p PS=7.2u
+ PD=13.2u
* device instance $355 m0 *1 747.6,269.9 PMOS
XM$355 \$I3696 \$I3697 VDD VDD PMOS L=1u W=3.4u AS=10.88p AD=6.46p PS=13.2u
+ PD=7.2u
* device instance $356 m0 *1 752.4,269.9 PMOS
XM$356 VDD \$I3696 \$I3697 VDD PMOS L=1u W=3.4u AS=6.46p AD=10.88p PS=7.2u
+ PD=13.2u
* device instance $357 m0 *1 742.8,290.3 NMOS
XM$357 BL31 WL9 \$I3696 VSS NMOS L=1u W=3.4u AS=10.88p AD=6.46p PS=13.2u PD=7.2u
* device instance $358 m0 *1 747.6,290.3 NMOS
XM$358 \$I3696 \$I3697 VSS VSS NMOS L=1u W=3.4u AS=6.46p AD=6.46p PS=7.2u
+ PD=7.2u
* device instance $359 m0 *1 752.4,290.3 NMOS
XM$359 VSS \$I3696 \$I3697 VSS NMOS L=1u W=3.4u AS=6.46p AD=6.46p PS=7.2u
+ PD=7.2u
* device instance $360 m0 *1 757.2,290.3 NMOS
XM$360 \$I3697 WL9 BLB31 VSS NMOS L=1u W=3.4u AS=6.46p AD=10.88p PS=7.2u
+ PD=13.2u
* device instance $361 m0 *1 724.4,269.9 PMOS
XM$361 \$I3698 \$I3699 VDD VDD PMOS L=1u W=3.4u AS=10.88p AD=6.46p PS=13.2u
+ PD=7.2u
* device instance $362 m0 *1 729.2,269.9 PMOS
XM$362 VDD \$I3698 \$I3699 VDD PMOS L=1u W=3.4u AS=6.46p AD=10.88p PS=7.2u
+ PD=13.2u
* device instance $363 m0 *1 719.6,290.3 NMOS
XM$363 BL30 WL9 \$I3698 VSS NMOS L=1u W=3.4u AS=10.88p AD=6.46p PS=13.2u PD=7.2u
* device instance $364 m0 *1 724.4,290.3 NMOS
XM$364 \$I3698 \$I3699 VSS VSS NMOS L=1u W=3.4u AS=6.46p AD=6.46p PS=7.2u
+ PD=7.2u
* device instance $365 m0 *1 729.2,290.3 NMOS
XM$365 VSS \$I3698 \$I3699 VSS NMOS L=1u W=3.4u AS=6.46p AD=6.46p PS=7.2u
+ PD=7.2u
* device instance $366 m0 *1 734,290.3 NMOS
XM$366 \$I3699 WL9 BLB30 VSS NMOS L=1u W=3.4u AS=6.46p AD=10.88p PS=7.2u
+ PD=13.2u
* device instance $367 m0 *1 701.2,269.9 PMOS
XM$367 \$I3700 \$I3701 VDD VDD PMOS L=1u W=3.4u AS=10.88p AD=6.46p PS=13.2u
+ PD=7.2u
* device instance $368 m0 *1 706,269.9 PMOS
XM$368 VDD \$I3700 \$I3701 VDD PMOS L=1u W=3.4u AS=6.46p AD=10.88p PS=7.2u
+ PD=13.2u
* device instance $369 m0 *1 696.4,290.3 NMOS
XM$369 BL29 WL9 \$I3700 VSS NMOS L=1u W=3.4u AS=10.88p AD=6.46p PS=13.2u PD=7.2u
* device instance $370 m0 *1 701.2,290.3 NMOS
XM$370 \$I3700 \$I3701 VSS VSS NMOS L=1u W=3.4u AS=6.46p AD=6.46p PS=7.2u
+ PD=7.2u
* device instance $371 m0 *1 706,290.3 NMOS
XM$371 VSS \$I3700 \$I3701 VSS NMOS L=1u W=3.4u AS=6.46p AD=6.46p PS=7.2u
+ PD=7.2u
* device instance $372 m0 *1 710.8,290.3 NMOS
XM$372 \$I3701 WL9 BLB29 VSS NMOS L=1u W=3.4u AS=6.46p AD=10.88p PS=7.2u
+ PD=13.2u
* device instance $373 m0 *1 678,269.9 PMOS
XM$373 \$I3702 \$I3703 VDD VDD PMOS L=1u W=3.4u AS=10.88p AD=6.46p PS=13.2u
+ PD=7.2u
* device instance $374 m0 *1 682.8,269.9 PMOS
XM$374 VDD \$I3702 \$I3703 VDD PMOS L=1u W=3.4u AS=6.46p AD=10.88p PS=7.2u
+ PD=13.2u
* device instance $375 m0 *1 673.2,290.3 NMOS
XM$375 BL28 WL9 \$I3702 VSS NMOS L=1u W=3.4u AS=10.88p AD=6.46p PS=13.2u PD=7.2u
* device instance $376 m0 *1 678,290.3 NMOS
XM$376 \$I3702 \$I3703 VSS VSS NMOS L=1u W=3.4u AS=6.46p AD=6.46p PS=7.2u
+ PD=7.2u
* device instance $377 m0 *1 682.8,290.3 NMOS
XM$377 VSS \$I3702 \$I3703 VSS NMOS L=1u W=3.4u AS=6.46p AD=6.46p PS=7.2u
+ PD=7.2u
* device instance $378 m0 *1 687.6,290.3 NMOS
XM$378 \$I3703 WL9 BLB28 VSS NMOS L=1u W=3.4u AS=6.46p AD=10.88p PS=7.2u
+ PD=13.2u
* device instance $379 m0 *1 654.8,269.9 PMOS
XM$379 \$I3704 \$I3705 VDD VDD PMOS L=1u W=3.4u AS=10.88p AD=6.46p PS=13.2u
+ PD=7.2u
* device instance $380 m0 *1 659.6,269.9 PMOS
XM$380 VDD \$I3704 \$I3705 VDD PMOS L=1u W=3.4u AS=6.46p AD=10.88p PS=7.2u
+ PD=13.2u
* device instance $381 m0 *1 650,290.3 NMOS
XM$381 BL27 WL9 \$I3704 VSS NMOS L=1u W=3.4u AS=10.88p AD=6.46p PS=13.2u PD=7.2u
* device instance $382 m0 *1 654.8,290.3 NMOS
XM$382 \$I3704 \$I3705 VSS VSS NMOS L=1u W=3.4u AS=6.46p AD=6.46p PS=7.2u
+ PD=7.2u
* device instance $383 m0 *1 659.6,290.3 NMOS
XM$383 VSS \$I3704 \$I3705 VSS NMOS L=1u W=3.4u AS=6.46p AD=6.46p PS=7.2u
+ PD=7.2u
* device instance $384 m0 *1 664.4,290.3 NMOS
XM$384 \$I3705 WL9 BLB27 VSS NMOS L=1u W=3.4u AS=6.46p AD=10.88p PS=7.2u
+ PD=13.2u
* device instance $385 m0 *1 216,210.7 PMOS
XM$385 \$I3706 \$I3707 VDD VDD PMOS L=1u W=3.4u AS=10.88p AD=6.46p PS=13.2u
+ PD=7.2u
* device instance $386 m0 *1 220.8,210.7 PMOS
XM$386 VDD \$I3706 \$I3707 VDD PMOS L=1u W=3.4u AS=6.46p AD=10.88p PS=7.2u
+ PD=13.2u
* device instance $387 m0 *1 211.2,231.1 NMOS
XM$387 BL9 WL7 \$I3706 VSS NMOS L=1u W=3.4u AS=10.88p AD=6.46p PS=13.2u PD=7.2u
* device instance $388 m0 *1 216,231.1 NMOS
XM$388 \$I3706 \$I3707 VSS VSS NMOS L=1u W=3.4u AS=6.46p AD=6.46p PS=7.2u
+ PD=7.2u
* device instance $389 m0 *1 220.8,231.1 NMOS
XM$389 VSS \$I3706 \$I3707 VSS NMOS L=1u W=3.4u AS=6.46p AD=6.46p PS=7.2u
+ PD=7.2u
* device instance $390 m0 *1 225.6,231.1 NMOS
XM$390 \$I3707 WL7 BLB9 VSS NMOS L=1u W=3.4u AS=6.46p AD=10.88p PS=7.2u PD=13.2u
* device instance $391 m0 *1 239.2,210.7 PMOS
XM$391 \$I3708 \$I3709 VDD VDD PMOS L=1u W=3.4u AS=10.88p AD=6.46p PS=13.2u
+ PD=7.2u
* device instance $392 m0 *1 244,210.7 PMOS
XM$392 VDD \$I3708 \$I3709 VDD PMOS L=1u W=3.4u AS=6.46p AD=10.88p PS=7.2u
+ PD=13.2u
* device instance $393 m0 *1 234.4,231.1 NMOS
XM$393 BL10 WL7 \$I3708 VSS NMOS L=1u W=3.4u AS=10.88p AD=6.46p PS=13.2u PD=7.2u
* device instance $394 m0 *1 239.2,231.1 NMOS
XM$394 \$I3708 \$I3709 VSS VSS NMOS L=1u W=3.4u AS=6.46p AD=6.46p PS=7.2u
+ PD=7.2u
* device instance $395 m0 *1 244,231.1 NMOS
XM$395 VSS \$I3708 \$I3709 VSS NMOS L=1u W=3.4u AS=6.46p AD=6.46p PS=7.2u
+ PD=7.2u
* device instance $396 m0 *1 248.8,231.1 NMOS
XM$396 \$I3709 WL7 BLB10 VSS NMOS L=1u W=3.4u AS=6.46p AD=10.88p PS=7.2u
+ PD=13.2u
* device instance $397 m0 *1 262.4,210.7 PMOS
XM$397 \$I3710 \$I3711 VDD VDD PMOS L=1u W=3.4u AS=10.88p AD=6.46p PS=13.2u
+ PD=7.2u
* device instance $398 m0 *1 267.2,210.7 PMOS
XM$398 VDD \$I3710 \$I3711 VDD PMOS L=1u W=3.4u AS=6.46p AD=10.88p PS=7.2u
+ PD=13.2u
* device instance $399 m0 *1 257.6,231.1 NMOS
XM$399 BL11 WL7 \$I3710 VSS NMOS L=1u W=3.4u AS=10.88p AD=6.46p PS=13.2u PD=7.2u
* device instance $400 m0 *1 262.4,231.1 NMOS
XM$400 \$I3710 \$I3711 VSS VSS NMOS L=1u W=3.4u AS=6.46p AD=6.46p PS=7.2u
+ PD=7.2u
* device instance $401 m0 *1 267.2,231.1 NMOS
XM$401 VSS \$I3710 \$I3711 VSS NMOS L=1u W=3.4u AS=6.46p AD=6.46p PS=7.2u
+ PD=7.2u
* device instance $402 m0 *1 272,231.1 NMOS
XM$402 \$I3711 WL7 BLB11 VSS NMOS L=1u W=3.4u AS=6.46p AD=10.88p PS=7.2u
+ PD=13.2u
* device instance $403 m0 *1 585.2,329.1 PMOS
XM$403 \$I3712 \$I3713 VDD VDD PMOS L=1u W=3.4u AS=10.88p AD=6.46p PS=13.2u
+ PD=7.2u
* device instance $404 m0 *1 590,329.1 PMOS
XM$404 VDD \$I3712 \$I3713 VDD PMOS L=1u W=3.4u AS=6.46p AD=10.88p PS=7.2u
+ PD=13.2u
* device instance $405 m0 *1 580.4,349.5 NMOS
XM$405 BL24 WL11 \$I3712 VSS NMOS L=1u W=3.4u AS=10.88p AD=6.46p PS=13.2u
+ PD=7.2u
* device instance $406 m0 *1 585.2,349.5 NMOS
XM$406 \$I3712 \$I3713 VSS VSS NMOS L=1u W=3.4u AS=6.46p AD=6.46p PS=7.2u
+ PD=7.2u
* device instance $407 m0 *1 590,349.5 NMOS
XM$407 VSS \$I3712 \$I3713 VSS NMOS L=1u W=3.4u AS=6.46p AD=6.46p PS=7.2u
+ PD=7.2u
* device instance $408 m0 *1 594.8,349.5 NMOS
XM$408 \$I3713 WL11 BLB24 VSS NMOS L=1u W=3.4u AS=6.46p AD=10.88p PS=7.2u
+ PD=13.2u
* device instance $409 m0 *1 169.6,388.3 PMOS
XM$409 \$I3714 \$I3715 VDD VDD PMOS L=1u W=3.4u AS=10.88p AD=6.46p PS=13.2u
+ PD=7.2u
* device instance $410 m0 *1 174.4,388.3 PMOS
XM$410 VDD \$I3714 \$I3715 VDD PMOS L=1u W=3.4u AS=6.46p AD=10.88p PS=7.2u
+ PD=13.2u
* device instance $411 m0 *1 164.8,408.7 NMOS
XM$411 BL7 WL13 \$I3714 VSS NMOS L=1u W=3.4u AS=10.88p AD=6.46p PS=13.2u PD=7.2u
* device instance $412 m0 *1 169.6,408.7 NMOS
XM$412 \$I3714 \$I3715 VSS VSS NMOS L=1u W=3.4u AS=6.46p AD=6.46p PS=7.2u
+ PD=7.2u
* device instance $413 m0 *1 174.4,408.7 NMOS
XM$413 VSS \$I3714 \$I3715 VSS NMOS L=1u W=3.4u AS=6.46p AD=6.46p PS=7.2u
+ PD=7.2u
* device instance $414 m0 *1 179.2,408.7 NMOS
XM$414 \$I3715 WL13 BLB7 VSS NMOS L=1u W=3.4u AS=6.46p AD=10.88p PS=7.2u
+ PD=13.2u
* device instance $415 m0 *1 7.2,92.3 PMOS
XM$415 \$I3716 \$I3717 VDD VDD PMOS L=1u W=3.4u AS=10.88p AD=6.46p PS=13.2u
+ PD=7.2u
* device instance $416 m0 *1 12,92.3 PMOS
XM$416 VDD \$I3716 \$I3717 VDD PMOS L=1u W=3.4u AS=6.46p AD=10.88p PS=7.2u
+ PD=13.2u
* device instance $417 m0 *1 2.4,112.7 NMOS
XM$417 BL0 WL3 \$I3716 VSS NMOS L=1u W=3.4u AS=10.88p AD=6.46p PS=13.2u PD=7.2u
* device instance $418 m0 *1 7.2,112.7 NMOS
XM$418 \$I3716 \$I3717 VSS VSS NMOS L=1u W=3.4u AS=6.46p AD=6.46p PS=7.2u
+ PD=7.2u
* device instance $419 m0 *1 12,112.7 NMOS
XM$419 VSS \$I3716 \$I3717 VSS NMOS L=1u W=3.4u AS=6.46p AD=6.46p PS=7.2u
+ PD=7.2u
* device instance $420 m0 *1 16.8,112.7 NMOS
XM$420 \$I3717 WL3 BLB0 VSS NMOS L=1u W=3.4u AS=6.46p AD=10.88p PS=7.2u PD=13.2u
* device instance $421 m0 *1 30.4,92.3 PMOS
XM$421 \$I3718 \$I3719 VDD VDD PMOS L=1u W=3.4u AS=10.88p AD=6.46p PS=13.2u
+ PD=7.2u
* device instance $422 m0 *1 35.2,92.3 PMOS
XM$422 VDD \$I3718 \$I3719 VDD PMOS L=1u W=3.4u AS=6.46p AD=10.88p PS=7.2u
+ PD=13.2u
* device instance $423 m0 *1 25.6,112.7 NMOS
XM$423 BL1 WL3 \$I3718 VSS NMOS L=1u W=3.4u AS=10.88p AD=6.46p PS=13.2u PD=7.2u
* device instance $424 m0 *1 30.4,112.7 NMOS
XM$424 \$I3718 \$I3719 VSS VSS NMOS L=1u W=3.4u AS=6.46p AD=6.46p PS=7.2u
+ PD=7.2u
* device instance $425 m0 *1 35.2,112.7 NMOS
XM$425 VSS \$I3718 \$I3719 VSS NMOS L=1u W=3.4u AS=6.46p AD=6.46p PS=7.2u
+ PD=7.2u
* device instance $426 m0 *1 40,112.7 NMOS
XM$426 \$I3719 WL3 BLB1 VSS NMOS L=1u W=3.4u AS=6.46p AD=10.88p PS=7.2u PD=13.2u
* device instance $427 m0 *1 53.6,92.3 PMOS
XM$427 \$I3720 \$I3721 VDD VDD PMOS L=1u W=3.4u AS=10.88p AD=6.46p PS=13.2u
+ PD=7.2u
* device instance $428 m0 *1 58.4,92.3 PMOS
XM$428 VDD \$I3720 \$I3721 VDD PMOS L=1u W=3.4u AS=6.46p AD=10.88p PS=7.2u
+ PD=13.2u
* device instance $429 m0 *1 48.8,112.7 NMOS
XM$429 BL2 WL3 \$I3720 VSS NMOS L=1u W=3.4u AS=10.88p AD=6.46p PS=13.2u PD=7.2u
* device instance $430 m0 *1 53.6,112.7 NMOS
XM$430 \$I3720 \$I3721 VSS VSS NMOS L=1u W=3.4u AS=6.46p AD=6.46p PS=7.2u
+ PD=7.2u
* device instance $431 m0 *1 58.4,112.7 NMOS
XM$431 VSS \$I3720 \$I3721 VSS NMOS L=1u W=3.4u AS=6.46p AD=6.46p PS=7.2u
+ PD=7.2u
* device instance $432 m0 *1 63.2,112.7 NMOS
XM$432 \$I3721 WL3 BLB2 VSS NMOS L=1u W=3.4u AS=6.46p AD=10.88p PS=7.2u PD=13.2u
* device instance $433 m0 *1 76.8,92.3 PMOS
XM$433 \$I3722 \$I3723 VDD VDD PMOS L=1u W=3.4u AS=10.88p AD=6.46p PS=13.2u
+ PD=7.2u
* device instance $434 m0 *1 81.6,92.3 PMOS
XM$434 VDD \$I3722 \$I3723 VDD PMOS L=1u W=3.4u AS=6.46p AD=10.88p PS=7.2u
+ PD=13.2u
* device instance $435 m0 *1 72,112.7 NMOS
XM$435 BL3 WL3 \$I3722 VSS NMOS L=1u W=3.4u AS=10.88p AD=6.46p PS=13.2u PD=7.2u
* device instance $436 m0 *1 76.8,112.7 NMOS
XM$436 \$I3722 \$I3723 VSS VSS NMOS L=1u W=3.4u AS=6.46p AD=6.46p PS=7.2u
+ PD=7.2u
* device instance $437 m0 *1 81.6,112.7 NMOS
XM$437 VSS \$I3722 \$I3723 VSS NMOS L=1u W=3.4u AS=6.46p AD=6.46p PS=7.2u
+ PD=7.2u
* device instance $438 m0 *1 86.4,112.7 NMOS
XM$438 \$I3723 WL3 BLB3 VSS NMOS L=1u W=3.4u AS=6.46p AD=10.88p PS=7.2u PD=13.2u
* device instance $439 m0 *1 100,92.3 PMOS
XM$439 \$I3724 \$I3725 VDD VDD PMOS L=1u W=3.4u AS=10.88p AD=6.46p PS=13.2u
+ PD=7.2u
* device instance $440 m0 *1 104.8,92.3 PMOS
XM$440 VDD \$I3724 \$I3725 VDD PMOS L=1u W=3.4u AS=6.46p AD=10.88p PS=7.2u
+ PD=13.2u
* device instance $441 m0 *1 95.2,112.7 NMOS
XM$441 BL4 WL3 \$I3724 VSS NMOS L=1u W=3.4u AS=10.88p AD=6.46p PS=13.2u PD=7.2u
* device instance $442 m0 *1 100,112.7 NMOS
XM$442 \$I3724 \$I3725 VSS VSS NMOS L=1u W=3.4u AS=6.46p AD=6.46p PS=7.2u
+ PD=7.2u
* device instance $443 m0 *1 104.8,112.7 NMOS
XM$443 VSS \$I3724 \$I3725 VSS NMOS L=1u W=3.4u AS=6.46p AD=6.46p PS=7.2u
+ PD=7.2u
* device instance $444 m0 *1 109.6,112.7 NMOS
XM$444 \$I3725 WL3 BLB4 VSS NMOS L=1u W=3.4u AS=6.46p AD=10.88p PS=7.2u PD=13.2u
* device instance $445 m0 *1 123.2,92.3 PMOS
XM$445 \$I3726 \$I3727 VDD VDD PMOS L=1u W=3.4u AS=10.88p AD=6.46p PS=13.2u
+ PD=7.2u
* device instance $446 m0 *1 128,92.3 PMOS
XM$446 VDD \$I3726 \$I3727 VDD PMOS L=1u W=3.4u AS=6.46p AD=10.88p PS=7.2u
+ PD=13.2u
* device instance $447 m0 *1 118.4,112.7 NMOS
XM$447 BL5 WL3 \$I3726 VSS NMOS L=1u W=3.4u AS=10.88p AD=6.46p PS=13.2u PD=7.2u
* device instance $448 m0 *1 123.2,112.7 NMOS
XM$448 \$I3726 \$I3727 VSS VSS NMOS L=1u W=3.4u AS=6.46p AD=6.46p PS=7.2u
+ PD=7.2u
* device instance $449 m0 *1 128,112.7 NMOS
XM$449 VSS \$I3726 \$I3727 VSS NMOS L=1u W=3.4u AS=6.46p AD=6.46p PS=7.2u
+ PD=7.2u
* device instance $450 m0 *1 132.8,112.7 NMOS
XM$450 \$I3727 WL3 BLB5 VSS NMOS L=1u W=3.4u AS=6.46p AD=10.88p PS=7.2u PD=13.2u
* device instance $451 m0 *1 146.4,92.3 PMOS
XM$451 \$I3728 \$I3729 VDD VDD PMOS L=1u W=3.4u AS=10.88p AD=6.46p PS=13.2u
+ PD=7.2u
* device instance $452 m0 *1 151.2,92.3 PMOS
XM$452 VDD \$I3728 \$I3729 VDD PMOS L=1u W=3.4u AS=6.46p AD=10.88p PS=7.2u
+ PD=13.2u
* device instance $453 m0 *1 141.6,112.7 NMOS
XM$453 BL6 WL3 \$I3728 VSS NMOS L=1u W=3.4u AS=10.88p AD=6.46p PS=13.2u PD=7.2u
* device instance $454 m0 *1 146.4,112.7 NMOS
XM$454 \$I3728 \$I3729 VSS VSS NMOS L=1u W=3.4u AS=6.46p AD=6.46p PS=7.2u
+ PD=7.2u
* device instance $455 m0 *1 151.2,112.7 NMOS
XM$455 VSS \$I3728 \$I3729 VSS NMOS L=1u W=3.4u AS=6.46p AD=6.46p PS=7.2u
+ PD=7.2u
* device instance $456 m0 *1 156,112.7 NMOS
XM$456 \$I3729 WL3 BLB6 VSS NMOS L=1u W=3.4u AS=6.46p AD=10.88p PS=7.2u PD=13.2u
* device instance $457 m0 *1 76.8,210.7 PMOS
XM$457 \$I3730 \$I3731 VDD VDD PMOS L=1u W=3.4u AS=10.88p AD=6.46p PS=13.2u
+ PD=7.2u
* device instance $458 m0 *1 81.6,210.7 PMOS
XM$458 VDD \$I3730 \$I3731 VDD PMOS L=1u W=3.4u AS=6.46p AD=10.88p PS=7.2u
+ PD=13.2u
* device instance $459 m0 *1 72,231.1 NMOS
XM$459 BL3 WL7 \$I3730 VSS NMOS L=1u W=3.4u AS=10.88p AD=6.46p PS=13.2u PD=7.2u
* device instance $460 m0 *1 76.8,231.1 NMOS
XM$460 \$I3730 \$I3731 VSS VSS NMOS L=1u W=3.4u AS=6.46p AD=6.46p PS=7.2u
+ PD=7.2u
* device instance $461 m0 *1 81.6,231.1 NMOS
XM$461 VSS \$I3730 \$I3731 VSS NMOS L=1u W=3.4u AS=6.46p AD=6.46p PS=7.2u
+ PD=7.2u
* device instance $462 m0 *1 86.4,231.1 NMOS
XM$462 \$I3731 WL7 BLB3 VSS NMOS L=1u W=3.4u AS=6.46p AD=10.88p PS=7.2u PD=13.2u
* device instance $463 m0 *1 469.2,329.1 PMOS
XM$463 \$I3732 \$I3733 VDD VDD PMOS L=1u W=3.4u AS=10.88p AD=6.46p PS=13.2u
+ PD=7.2u
* device instance $464 m0 *1 474,329.1 PMOS
XM$464 VDD \$I3732 \$I3733 VDD PMOS L=1u W=3.4u AS=6.46p AD=10.88p PS=7.2u
+ PD=13.2u
* device instance $465 m0 *1 464.4,349.5 NMOS
XM$465 BL19 WL11 \$I3732 VSS NMOS L=1u W=3.4u AS=10.88p AD=6.46p PS=13.2u
+ PD=7.2u
* device instance $466 m0 *1 469.2,349.5 NMOS
XM$466 \$I3732 \$I3733 VSS VSS NMOS L=1u W=3.4u AS=6.46p AD=6.46p PS=7.2u
+ PD=7.2u
* device instance $467 m0 *1 474,349.5 NMOS
XM$467 VSS \$I3732 \$I3733 VSS NMOS L=1u W=3.4u AS=6.46p AD=6.46p PS=7.2u
+ PD=7.2u
* device instance $468 m0 *1 478.8,349.5 NMOS
XM$468 \$I3733 WL11 BLB19 VSS NMOS L=1u W=3.4u AS=6.46p AD=10.88p PS=7.2u
+ PD=13.2u
* device instance $469 m0 *1 446,329.1 PMOS
XM$469 \$I3734 \$I3735 VDD VDD PMOS L=1u W=3.4u AS=10.88p AD=6.46p PS=13.2u
+ PD=7.2u
* device instance $470 m0 *1 450.8,329.1 PMOS
XM$470 VDD \$I3734 \$I3735 VDD PMOS L=1u W=3.4u AS=6.46p AD=10.88p PS=7.2u
+ PD=13.2u
* device instance $471 m0 *1 441.2,349.5 NMOS
XM$471 BL18 WL11 \$I3734 VSS NMOS L=1u W=3.4u AS=10.88p AD=6.46p PS=13.2u
+ PD=7.2u
* device instance $472 m0 *1 446,349.5 NMOS
XM$472 \$I3734 \$I3735 VSS VSS NMOS L=1u W=3.4u AS=6.46p AD=6.46p PS=7.2u
+ PD=7.2u
* device instance $473 m0 *1 450.8,349.5 NMOS
XM$473 VSS \$I3734 \$I3735 VSS NMOS L=1u W=3.4u AS=6.46p AD=6.46p PS=7.2u
+ PD=7.2u
* device instance $474 m0 *1 455.6,349.5 NMOS
XM$474 \$I3735 WL11 BLB18 VSS NMOS L=1u W=3.4u AS=6.46p AD=10.88p PS=7.2u
+ PD=13.2u
* device instance $475 m0 *1 422.8,329.1 PMOS
XM$475 \$I3736 \$I3737 VDD VDD PMOS L=1u W=3.4u AS=10.88p AD=6.46p PS=13.2u
+ PD=7.2u
* device instance $476 m0 *1 427.6,329.1 PMOS
XM$476 VDD \$I3736 \$I3737 VDD PMOS L=1u W=3.4u AS=6.46p AD=10.88p PS=7.2u
+ PD=13.2u
* device instance $477 m0 *1 418,349.5 NMOS
XM$477 BL17 WL11 \$I3736 VSS NMOS L=1u W=3.4u AS=10.88p AD=6.46p PS=13.2u
+ PD=7.2u
* device instance $478 m0 *1 422.8,349.5 NMOS
XM$478 \$I3736 \$I3737 VSS VSS NMOS L=1u W=3.4u AS=6.46p AD=6.46p PS=7.2u
+ PD=7.2u
* device instance $479 m0 *1 427.6,349.5 NMOS
XM$479 VSS \$I3736 \$I3737 VSS NMOS L=1u W=3.4u AS=6.46p AD=6.46p PS=7.2u
+ PD=7.2u
* device instance $480 m0 *1 432.4,349.5 NMOS
XM$480 \$I3737 WL11 BLB17 VSS NMOS L=1u W=3.4u AS=6.46p AD=10.88p PS=7.2u
+ PD=13.2u
* device instance $481 m0 *1 399.6,329.1 PMOS
XM$481 \$I3738 \$I3739 VDD VDD PMOS L=1u W=3.4u AS=10.88p AD=6.46p PS=13.2u
+ PD=7.2u
* device instance $482 m0 *1 404.4,329.1 PMOS
XM$482 VDD \$I3738 \$I3739 VDD PMOS L=1u W=3.4u AS=6.46p AD=10.88p PS=7.2u
+ PD=13.2u
* device instance $483 m0 *1 394.8,349.5 NMOS
XM$483 BL16 WL11 \$I3738 VSS NMOS L=1u W=3.4u AS=10.88p AD=6.46p PS=13.2u
+ PD=7.2u
* device instance $484 m0 *1 399.6,349.5 NMOS
XM$484 \$I3738 \$I3739 VSS VSS NMOS L=1u W=3.4u AS=6.46p AD=6.46p PS=7.2u
+ PD=7.2u
* device instance $485 m0 *1 404.4,349.5 NMOS
XM$485 VSS \$I3738 \$I3739 VSS NMOS L=1u W=3.4u AS=6.46p AD=6.46p PS=7.2u
+ PD=7.2u
* device instance $486 m0 *1 409.2,349.5 NMOS
XM$486 \$I3739 WL11 BLB16 VSS NMOS L=1u W=3.4u AS=6.46p AD=10.88p PS=7.2u
+ PD=13.2u
* device instance $487 m0 *1 262.4,33.1 PMOS
XM$487 \$I3740 \$I3741 VDD VDD PMOS L=1u W=3.4u AS=10.88p AD=6.46p PS=13.2u
+ PD=7.2u
* device instance $488 m0 *1 267.2,33.1 PMOS
XM$488 VDD \$I3740 \$I3741 VDD PMOS L=1u W=3.4u AS=6.46p AD=10.88p PS=7.2u
+ PD=13.2u
* device instance $489 m0 *1 257.6,53.5 NMOS
XM$489 BL11 WL1 \$I3740 VSS NMOS L=1u W=3.4u AS=10.88p AD=6.46p PS=13.2u PD=7.2u
* device instance $490 m0 *1 262.4,53.5 NMOS
XM$490 \$I3740 \$I3741 VSS VSS NMOS L=1u W=3.4u AS=6.46p AD=6.46p PS=7.2u
+ PD=7.2u
* device instance $491 m0 *1 267.2,53.5 NMOS
XM$491 VSS \$I3740 \$I3741 VSS NMOS L=1u W=3.4u AS=6.46p AD=6.46p PS=7.2u
+ PD=7.2u
* device instance $492 m0 *1 272,53.5 NMOS
XM$492 \$I3741 WL1 BLB11 VSS NMOS L=1u W=3.4u AS=6.46p AD=10.88p PS=7.2u
+ PD=13.2u
* device instance $493 m0 *1 285.6,33.1 PMOS
XM$493 \$I3742 \$I3743 VDD VDD PMOS L=1u W=3.4u AS=10.88p AD=6.46p PS=13.2u
+ PD=7.2u
* device instance $494 m0 *1 290.4,33.1 PMOS
XM$494 VDD \$I3742 \$I3743 VDD PMOS L=1u W=3.4u AS=6.46p AD=10.88p PS=7.2u
+ PD=13.2u
* device instance $495 m0 *1 280.8,53.5 NMOS
XM$495 BL12 WL1 \$I3742 VSS NMOS L=1u W=3.4u AS=10.88p AD=6.46p PS=13.2u PD=7.2u
* device instance $496 m0 *1 285.6,53.5 NMOS
XM$496 \$I3742 \$I3743 VSS VSS NMOS L=1u W=3.4u AS=6.46p AD=6.46p PS=7.2u
+ PD=7.2u
* device instance $497 m0 *1 290.4,53.5 NMOS
XM$497 VSS \$I3742 \$I3743 VSS NMOS L=1u W=3.4u AS=6.46p AD=6.46p PS=7.2u
+ PD=7.2u
* device instance $498 m0 *1 295.2,53.5 NMOS
XM$498 \$I3743 WL1 BLB12 VSS NMOS L=1u W=3.4u AS=6.46p AD=10.88p PS=7.2u
+ PD=13.2u
* device instance $499 m0 *1 308.8,33.1 PMOS
XM$499 \$I3744 \$I3745 VDD VDD PMOS L=1u W=3.4u AS=10.88p AD=6.46p PS=13.2u
+ PD=7.2u
* device instance $500 m0 *1 313.6,33.1 PMOS
XM$500 VDD \$I3744 \$I3745 VDD PMOS L=1u W=3.4u AS=6.46p AD=10.88p PS=7.2u
+ PD=13.2u
* device instance $501 m0 *1 304,53.5 NMOS
XM$501 BL13 WL1 \$I3744 VSS NMOS L=1u W=3.4u AS=10.88p AD=6.46p PS=13.2u PD=7.2u
* device instance $502 m0 *1 308.8,53.5 NMOS
XM$502 \$I3744 \$I3745 VSS VSS NMOS L=1u W=3.4u AS=6.46p AD=6.46p PS=7.2u
+ PD=7.2u
* device instance $503 m0 *1 313.6,53.5 NMOS
XM$503 VSS \$I3744 \$I3745 VSS NMOS L=1u W=3.4u AS=6.46p AD=6.46p PS=7.2u
+ PD=7.2u
* device instance $504 m0 *1 318.4,53.5 NMOS
XM$504 \$I3745 WL1 BLB13 VSS NMOS L=1u W=3.4u AS=6.46p AD=10.88p PS=7.2u
+ PD=13.2u
* device instance $505 m0 *1 332,33.1 PMOS
XM$505 \$I3746 \$I3747 VDD VDD PMOS L=1u W=3.4u AS=10.88p AD=6.46p PS=13.2u
+ PD=7.2u
* device instance $506 m0 *1 336.8,33.1 PMOS
XM$506 VDD \$I3746 \$I3747 VDD PMOS L=1u W=3.4u AS=6.46p AD=10.88p PS=7.2u
+ PD=13.2u
* device instance $507 m0 *1 327.2,53.5 NMOS
XM$507 BL14 WL1 \$I3746 VSS NMOS L=1u W=3.4u AS=10.88p AD=6.46p PS=13.2u PD=7.2u
* device instance $508 m0 *1 332,53.5 NMOS
XM$508 \$I3746 \$I3747 VSS VSS NMOS L=1u W=3.4u AS=6.46p AD=6.46p PS=7.2u
+ PD=7.2u
* device instance $509 m0 *1 336.8,53.5 NMOS
XM$509 VSS \$I3746 \$I3747 VSS NMOS L=1u W=3.4u AS=6.46p AD=6.46p PS=7.2u
+ PD=7.2u
* device instance $510 m0 *1 341.6,53.5 NMOS
XM$510 \$I3747 WL1 BLB14 VSS NMOS L=1u W=3.4u AS=6.46p AD=10.88p PS=7.2u
+ PD=13.2u
* device instance $511 m0 *1 169.6,92.3 PMOS
XM$511 \$I3748 \$I3749 VDD VDD PMOS L=1u W=3.4u AS=10.88p AD=6.46p PS=13.2u
+ PD=7.2u
* device instance $512 m0 *1 174.4,92.3 PMOS
XM$512 VDD \$I3748 \$I3749 VDD PMOS L=1u W=3.4u AS=6.46p AD=10.88p PS=7.2u
+ PD=13.2u
* device instance $513 m0 *1 164.8,112.7 NMOS
XM$513 BL7 WL3 \$I3748 VSS NMOS L=1u W=3.4u AS=10.88p AD=6.46p PS=13.2u PD=7.2u
* device instance $514 m0 *1 169.6,112.7 NMOS
XM$514 \$I3748 \$I3749 VSS VSS NMOS L=1u W=3.4u AS=6.46p AD=6.46p PS=7.2u
+ PD=7.2u
* device instance $515 m0 *1 174.4,112.7 NMOS
XM$515 VSS \$I3748 \$I3749 VSS NMOS L=1u W=3.4u AS=6.46p AD=6.46p PS=7.2u
+ PD=7.2u
* device instance $516 m0 *1 179.2,112.7 NMOS
XM$516 \$I3749 WL3 BLB7 VSS NMOS L=1u W=3.4u AS=6.46p AD=10.88p PS=7.2u PD=13.2u
* device instance $517 m0 *1 100,210.7 PMOS
XM$517 \$I3750 \$I3751 VDD VDD PMOS L=1u W=3.4u AS=10.88p AD=6.46p PS=13.2u
+ PD=7.2u
* device instance $518 m0 *1 104.8,210.7 PMOS
XM$518 VDD \$I3750 \$I3751 VDD PMOS L=1u W=3.4u AS=6.46p AD=10.88p PS=7.2u
+ PD=13.2u
* device instance $519 m0 *1 95.2,231.1 NMOS
XM$519 BL4 WL7 \$I3750 VSS NMOS L=1u W=3.4u AS=10.88p AD=6.46p PS=13.2u PD=7.2u
* device instance $520 m0 *1 100,231.1 NMOS
XM$520 \$I3750 \$I3751 VSS VSS NMOS L=1u W=3.4u AS=6.46p AD=6.46p PS=7.2u
+ PD=7.2u
* device instance $521 m0 *1 104.8,231.1 NMOS
XM$521 VSS \$I3750 \$I3751 VSS NMOS L=1u W=3.4u AS=6.46p AD=6.46p PS=7.2u
+ PD=7.2u
* device instance $522 m0 *1 109.6,231.1 NMOS
XM$522 \$I3751 WL7 BLB4 VSS NMOS L=1u W=3.4u AS=6.46p AD=10.88p PS=7.2u PD=13.2u
* device instance $523 m0 *1 123.2,210.7 PMOS
XM$523 \$I3752 \$I3753 VDD VDD PMOS L=1u W=3.4u AS=10.88p AD=6.46p PS=13.2u
+ PD=7.2u
* device instance $524 m0 *1 128,210.7 PMOS
XM$524 VDD \$I3752 \$I3753 VDD PMOS L=1u W=3.4u AS=6.46p AD=10.88p PS=7.2u
+ PD=13.2u
* device instance $525 m0 *1 118.4,231.1 NMOS
XM$525 BL5 WL7 \$I3752 VSS NMOS L=1u W=3.4u AS=10.88p AD=6.46p PS=13.2u PD=7.2u
* device instance $526 m0 *1 123.2,231.1 NMOS
XM$526 \$I3752 \$I3753 VSS VSS NMOS L=1u W=3.4u AS=6.46p AD=6.46p PS=7.2u
+ PD=7.2u
* device instance $527 m0 *1 128,231.1 NMOS
XM$527 VSS \$I3752 \$I3753 VSS NMOS L=1u W=3.4u AS=6.46p AD=6.46p PS=7.2u
+ PD=7.2u
* device instance $528 m0 *1 132.8,231.1 NMOS
XM$528 \$I3753 WL7 BLB5 VSS NMOS L=1u W=3.4u AS=6.46p AD=10.88p PS=7.2u PD=13.2u
* device instance $529 m0 *1 146.4,210.7 PMOS
XM$529 \$I3754 \$I3755 VDD VDD PMOS L=1u W=3.4u AS=10.88p AD=6.46p PS=13.2u
+ PD=7.2u
* device instance $530 m0 *1 151.2,210.7 PMOS
XM$530 VDD \$I3754 \$I3755 VDD PMOS L=1u W=3.4u AS=6.46p AD=10.88p PS=7.2u
+ PD=13.2u
* device instance $531 m0 *1 141.6,231.1 NMOS
XM$531 BL6 WL7 \$I3754 VSS NMOS L=1u W=3.4u AS=10.88p AD=6.46p PS=13.2u PD=7.2u
* device instance $532 m0 *1 146.4,231.1 NMOS
XM$532 \$I3754 \$I3755 VSS VSS NMOS L=1u W=3.4u AS=6.46p AD=6.46p PS=7.2u
+ PD=7.2u
* device instance $533 m0 *1 151.2,231.1 NMOS
XM$533 VSS \$I3754 \$I3755 VSS NMOS L=1u W=3.4u AS=6.46p AD=6.46p PS=7.2u
+ PD=7.2u
* device instance $534 m0 *1 156,231.1 NMOS
XM$534 \$I3755 WL7 BLB6 VSS NMOS L=1u W=3.4u AS=6.46p AD=10.88p PS=7.2u PD=13.2u
* device instance $535 m0 *1 169.6,210.7 PMOS
XM$535 \$I3756 \$I3757 VDD VDD PMOS L=1u W=3.4u AS=10.88p AD=6.46p PS=13.2u
+ PD=7.2u
* device instance $536 m0 *1 174.4,210.7 PMOS
XM$536 VDD \$I3756 \$I3757 VDD PMOS L=1u W=3.4u AS=6.46p AD=10.88p PS=7.2u
+ PD=13.2u
* device instance $537 m0 *1 164.8,231.1 NMOS
XM$537 BL7 WL7 \$I3756 VSS NMOS L=1u W=3.4u AS=10.88p AD=6.46p PS=13.2u PD=7.2u
* device instance $538 m0 *1 169.6,231.1 NMOS
XM$538 \$I3756 \$I3757 VSS VSS NMOS L=1u W=3.4u AS=6.46p AD=6.46p PS=7.2u
+ PD=7.2u
* device instance $539 m0 *1 174.4,231.1 NMOS
XM$539 VSS \$I3756 \$I3757 VSS NMOS L=1u W=3.4u AS=6.46p AD=6.46p PS=7.2u
+ PD=7.2u
* device instance $540 m0 *1 179.2,231.1 NMOS
XM$540 \$I3757 WL7 BLB7 VSS NMOS L=1u W=3.4u AS=6.46p AD=10.88p PS=7.2u PD=13.2u
* device instance $541 m0 *1 469.2,269.9 PMOS
XM$541 \$I3758 \$I3759 VDD VDD PMOS L=1u W=3.4u AS=10.88p AD=6.46p PS=13.2u
+ PD=7.2u
* device instance $542 m0 *1 474,269.9 PMOS
XM$542 VDD \$I3758 \$I3759 VDD PMOS L=1u W=3.4u AS=6.46p AD=10.88p PS=7.2u
+ PD=13.2u
* device instance $543 m0 *1 464.4,290.3 NMOS
XM$543 BL19 WL9 \$I3758 VSS NMOS L=1u W=3.4u AS=10.88p AD=6.46p PS=13.2u PD=7.2u
* device instance $544 m0 *1 469.2,290.3 NMOS
XM$544 \$I3758 \$I3759 VSS VSS NMOS L=1u W=3.4u AS=6.46p AD=6.46p PS=7.2u
+ PD=7.2u
* device instance $545 m0 *1 474,290.3 NMOS
XM$545 VSS \$I3758 \$I3759 VSS NMOS L=1u W=3.4u AS=6.46p AD=6.46p PS=7.2u
+ PD=7.2u
* device instance $546 m0 *1 478.8,290.3 NMOS
XM$546 \$I3759 WL9 BLB19 VSS NMOS L=1u W=3.4u AS=6.46p AD=10.88p PS=7.2u
+ PD=13.2u
* device instance $547 m0 *1 446,269.9 PMOS
XM$547 \$I3760 \$I3761 VDD VDD PMOS L=1u W=3.4u AS=10.88p AD=6.46p PS=13.2u
+ PD=7.2u
* device instance $548 m0 *1 450.8,269.9 PMOS
XM$548 VDD \$I3760 \$I3761 VDD PMOS L=1u W=3.4u AS=6.46p AD=10.88p PS=7.2u
+ PD=13.2u
* device instance $549 m0 *1 441.2,290.3 NMOS
XM$549 BL18 WL9 \$I3760 VSS NMOS L=1u W=3.4u AS=10.88p AD=6.46p PS=13.2u PD=7.2u
* device instance $550 m0 *1 446,290.3 NMOS
XM$550 \$I3760 \$I3761 VSS VSS NMOS L=1u W=3.4u AS=6.46p AD=6.46p PS=7.2u
+ PD=7.2u
* device instance $551 m0 *1 450.8,290.3 NMOS
XM$551 VSS \$I3760 \$I3761 VSS NMOS L=1u W=3.4u AS=6.46p AD=6.46p PS=7.2u
+ PD=7.2u
* device instance $552 m0 *1 455.6,290.3 NMOS
XM$552 \$I3761 WL9 BLB18 VSS NMOS L=1u W=3.4u AS=6.46p AD=10.88p PS=7.2u
+ PD=13.2u
* device instance $553 m0 *1 7.2,33.1 PMOS
XM$553 \$I3762 \$I3763 VDD VDD PMOS L=1u W=3.4u AS=10.88p AD=6.46p PS=13.2u
+ PD=7.2u
* device instance $554 m0 *1 12,33.1 PMOS
XM$554 VDD \$I3762 \$I3763 VDD PMOS L=1u W=3.4u AS=6.46p AD=10.88p PS=7.2u
+ PD=13.2u
* device instance $555 m0 *1 2.4,53.5 NMOS
XM$555 BL0 WL1 \$I3762 VSS NMOS L=1u W=3.4u AS=10.88p AD=6.46p PS=13.2u PD=7.2u
* device instance $556 m0 *1 7.2,53.5 NMOS
XM$556 \$I3762 \$I3763 VSS VSS NMOS L=1u W=3.4u AS=6.46p AD=6.46p PS=7.2u
+ PD=7.2u
* device instance $557 m0 *1 12,53.5 NMOS
XM$557 VSS \$I3762 \$I3763 VSS NMOS L=1u W=3.4u AS=6.46p AD=6.46p PS=7.2u
+ PD=7.2u
* device instance $558 m0 *1 16.8,53.5 NMOS
XM$558 \$I3763 WL1 BLB0 VSS NMOS L=1u W=3.4u AS=6.46p AD=10.88p PS=7.2u PD=13.2u
* device instance $559 m0 *1 30.4,33.1 PMOS
XM$559 \$I3764 \$I3765 VDD VDD PMOS L=1u W=3.4u AS=10.88p AD=6.46p PS=13.2u
+ PD=7.2u
* device instance $560 m0 *1 35.2,33.1 PMOS
XM$560 VDD \$I3764 \$I3765 VDD PMOS L=1u W=3.4u AS=6.46p AD=10.88p PS=7.2u
+ PD=13.2u
* device instance $561 m0 *1 25.6,53.5 NMOS
XM$561 BL1 WL1 \$I3764 VSS NMOS L=1u W=3.4u AS=10.88p AD=6.46p PS=13.2u PD=7.2u
* device instance $562 m0 *1 30.4,53.5 NMOS
XM$562 \$I3764 \$I3765 VSS VSS NMOS L=1u W=3.4u AS=6.46p AD=6.46p PS=7.2u
+ PD=7.2u
* device instance $563 m0 *1 35.2,53.5 NMOS
XM$563 VSS \$I3764 \$I3765 VSS NMOS L=1u W=3.4u AS=6.46p AD=6.46p PS=7.2u
+ PD=7.2u
* device instance $564 m0 *1 40,53.5 NMOS
XM$564 \$I3765 WL1 BLB1 VSS NMOS L=1u W=3.4u AS=6.46p AD=10.88p PS=7.2u PD=13.2u
* device instance $565 m0 *1 515.6,329.1 PMOS
XM$565 \$I3766 \$I3767 VDD VDD PMOS L=1u W=3.4u AS=10.88p AD=6.46p PS=13.2u
+ PD=7.2u
* device instance $566 m0 *1 520.4,329.1 PMOS
XM$566 VDD \$I3766 \$I3767 VDD PMOS L=1u W=3.4u AS=6.46p AD=10.88p PS=7.2u
+ PD=13.2u
* device instance $567 m0 *1 510.8,349.5 NMOS
XM$567 BL21 WL11 \$I3766 VSS NMOS L=1u W=3.4u AS=10.88p AD=6.46p PS=13.2u
+ PD=7.2u
* device instance $568 m0 *1 515.6,349.5 NMOS
XM$568 \$I3766 \$I3767 VSS VSS NMOS L=1u W=3.4u AS=6.46p AD=6.46p PS=7.2u
+ PD=7.2u
* device instance $569 m0 *1 520.4,349.5 NMOS
XM$569 VSS \$I3766 \$I3767 VSS NMOS L=1u W=3.4u AS=6.46p AD=6.46p PS=7.2u
+ PD=7.2u
* device instance $570 m0 *1 525.2,349.5 NMOS
XM$570 \$I3767 WL11 BLB21 VSS NMOS L=1u W=3.4u AS=6.46p AD=10.88p PS=7.2u
+ PD=13.2u
* device instance $571 m0 *1 76.8,33.1 PMOS
XM$571 \$I3768 \$I3769 VDD VDD PMOS L=1u W=3.4u AS=10.88p AD=6.46p PS=13.2u
+ PD=7.2u
* device instance $572 m0 *1 81.6,33.1 PMOS
XM$572 VDD \$I3768 \$I3769 VDD PMOS L=1u W=3.4u AS=6.46p AD=10.88p PS=7.2u
+ PD=13.2u
* device instance $573 m0 *1 72,53.5 NMOS
XM$573 BL3 WL1 \$I3768 VSS NMOS L=1u W=3.4u AS=10.88p AD=6.46p PS=13.2u PD=7.2u
* device instance $574 m0 *1 76.8,53.5 NMOS
XM$574 \$I3768 \$I3769 VSS VSS NMOS L=1u W=3.4u AS=6.46p AD=6.46p PS=7.2u
+ PD=7.2u
* device instance $575 m0 *1 81.6,53.5 NMOS
XM$575 VSS \$I3768 \$I3769 VSS NMOS L=1u W=3.4u AS=6.46p AD=6.46p PS=7.2u
+ PD=7.2u
* device instance $576 m0 *1 86.4,53.5 NMOS
XM$576 \$I3769 WL1 BLB3 VSS NMOS L=1u W=3.4u AS=6.46p AD=10.88p PS=7.2u PD=13.2u
* device instance $577 m0 *1 100,33.1 PMOS
XM$577 \$I3770 \$I3771 VDD VDD PMOS L=1u W=3.4u AS=10.88p AD=6.46p PS=13.2u
+ PD=7.2u
* device instance $578 m0 *1 104.8,33.1 PMOS
XM$578 VDD \$I3770 \$I3771 VDD PMOS L=1u W=3.4u AS=6.46p AD=10.88p PS=7.2u
+ PD=13.2u
* device instance $579 m0 *1 95.2,53.5 NMOS
XM$579 BL4 WL1 \$I3770 VSS NMOS L=1u W=3.4u AS=10.88p AD=6.46p PS=13.2u PD=7.2u
* device instance $580 m0 *1 100,53.5 NMOS
XM$580 \$I3770 \$I3771 VSS VSS NMOS L=1u W=3.4u AS=6.46p AD=6.46p PS=7.2u
+ PD=7.2u
* device instance $581 m0 *1 104.8,53.5 NMOS
XM$581 VSS \$I3770 \$I3771 VSS NMOS L=1u W=3.4u AS=6.46p AD=6.46p PS=7.2u
+ PD=7.2u
* device instance $582 m0 *1 109.6,53.5 NMOS
XM$582 \$I3771 WL1 BLB4 VSS NMOS L=1u W=3.4u AS=6.46p AD=10.88p PS=7.2u PD=13.2u
* device instance $583 m0 *1 123.2,33.1 PMOS
XM$583 \$I3772 \$I3773 VDD VDD PMOS L=1u W=3.4u AS=10.88p AD=6.46p PS=13.2u
+ PD=7.2u
* device instance $584 m0 *1 128,33.1 PMOS
XM$584 VDD \$I3772 \$I3773 VDD PMOS L=1u W=3.4u AS=6.46p AD=10.88p PS=7.2u
+ PD=13.2u
* device instance $585 m0 *1 118.4,53.5 NMOS
XM$585 BL5 WL1 \$I3772 VSS NMOS L=1u W=3.4u AS=10.88p AD=6.46p PS=13.2u PD=7.2u
* device instance $586 m0 *1 123.2,53.5 NMOS
XM$586 \$I3772 \$I3773 VSS VSS NMOS L=1u W=3.4u AS=6.46p AD=6.46p PS=7.2u
+ PD=7.2u
* device instance $587 m0 *1 128,53.5 NMOS
XM$587 VSS \$I3772 \$I3773 VSS NMOS L=1u W=3.4u AS=6.46p AD=6.46p PS=7.2u
+ PD=7.2u
* device instance $588 m0 *1 132.8,53.5 NMOS
XM$588 \$I3773 WL1 BLB5 VSS NMOS L=1u W=3.4u AS=6.46p AD=10.88p PS=7.2u PD=13.2u
* device instance $589 m0 *1 146.4,33.1 PMOS
XM$589 \$I3774 \$I3775 VDD VDD PMOS L=1u W=3.4u AS=10.88p AD=6.46p PS=13.2u
+ PD=7.2u
* device instance $590 m0 *1 151.2,33.1 PMOS
XM$590 VDD \$I3774 \$I3775 VDD PMOS L=1u W=3.4u AS=6.46p AD=10.88p PS=7.2u
+ PD=13.2u
* device instance $591 m0 *1 141.6,53.5 NMOS
XM$591 BL6 WL1 \$I3774 VSS NMOS L=1u W=3.4u AS=10.88p AD=6.46p PS=13.2u PD=7.2u
* device instance $592 m0 *1 146.4,53.5 NMOS
XM$592 \$I3774 \$I3775 VSS VSS NMOS L=1u W=3.4u AS=6.46p AD=6.46p PS=7.2u
+ PD=7.2u
* device instance $593 m0 *1 151.2,53.5 NMOS
XM$593 VSS \$I3774 \$I3775 VSS NMOS L=1u W=3.4u AS=6.46p AD=6.46p PS=7.2u
+ PD=7.2u
* device instance $594 m0 *1 156,53.5 NMOS
XM$594 \$I3775 WL1 BLB6 VSS NMOS L=1u W=3.4u AS=6.46p AD=10.88p PS=7.2u PD=13.2u
* device instance $595 m0 *1 169.6,33.1 PMOS
XM$595 \$I3776 \$I3777 VDD VDD PMOS L=1u W=3.4u AS=10.88p AD=6.46p PS=13.2u
+ PD=7.2u
* device instance $596 m0 *1 174.4,33.1 PMOS
XM$596 VDD \$I3776 \$I3777 VDD PMOS L=1u W=3.4u AS=6.46p AD=10.88p PS=7.2u
+ PD=13.2u
* device instance $597 m0 *1 164.8,53.5 NMOS
XM$597 BL7 WL1 \$I3776 VSS NMOS L=1u W=3.4u AS=10.88p AD=6.46p PS=13.2u PD=7.2u
* device instance $598 m0 *1 169.6,53.5 NMOS
XM$598 \$I3776 \$I3777 VSS VSS NMOS L=1u W=3.4u AS=6.46p AD=6.46p PS=7.2u
+ PD=7.2u
* device instance $599 m0 *1 174.4,53.5 NMOS
XM$599 VSS \$I3776 \$I3777 VSS NMOS L=1u W=3.4u AS=6.46p AD=6.46p PS=7.2u
+ PD=7.2u
* device instance $600 m0 *1 179.2,53.5 NMOS
XM$600 \$I3777 WL1 BLB7 VSS NMOS L=1u W=3.4u AS=6.46p AD=10.88p PS=7.2u PD=13.2u
* device instance $601 m0 *1 422.8,269.9 PMOS
XM$601 \$I3778 \$I3779 VDD VDD PMOS L=1u W=3.4u AS=10.88p AD=6.46p PS=13.2u
+ PD=7.2u
* device instance $602 m0 *1 427.6,269.9 PMOS
XM$602 VDD \$I3778 \$I3779 VDD PMOS L=1u W=3.4u AS=6.46p AD=10.88p PS=7.2u
+ PD=13.2u
* device instance $603 m0 *1 418,290.3 NMOS
XM$603 BL17 WL9 \$I3778 VSS NMOS L=1u W=3.4u AS=10.88p AD=6.46p PS=13.2u PD=7.2u
* device instance $604 m0 *1 422.8,290.3 NMOS
XM$604 \$I3778 \$I3779 VSS VSS NMOS L=1u W=3.4u AS=6.46p AD=6.46p PS=7.2u
+ PD=7.2u
* device instance $605 m0 *1 427.6,290.3 NMOS
XM$605 VSS \$I3778 \$I3779 VSS NMOS L=1u W=3.4u AS=6.46p AD=6.46p PS=7.2u
+ PD=7.2u
* device instance $606 m0 *1 432.4,290.3 NMOS
XM$606 \$I3779 WL9 BLB17 VSS NMOS L=1u W=3.4u AS=6.46p AD=10.88p PS=7.2u
+ PD=13.2u
* device instance $607 m0 *1 399.6,269.9 PMOS
XM$607 \$I3780 \$I3781 VDD VDD PMOS L=1u W=3.4u AS=10.88p AD=6.46p PS=13.2u
+ PD=7.2u
* device instance $608 m0 *1 404.4,269.9 PMOS
XM$608 VDD \$I3780 \$I3781 VDD PMOS L=1u W=3.4u AS=6.46p AD=10.88p PS=7.2u
+ PD=13.2u
* device instance $609 m0 *1 394.8,290.3 NMOS
XM$609 BL16 WL9 \$I3780 VSS NMOS L=1u W=3.4u AS=10.88p AD=6.46p PS=13.2u PD=7.2u
* device instance $610 m0 *1 399.6,290.3 NMOS
XM$610 \$I3780 \$I3781 VSS VSS NMOS L=1u W=3.4u AS=6.46p AD=6.46p PS=7.2u
+ PD=7.2u
* device instance $611 m0 *1 404.4,290.3 NMOS
XM$611 VSS \$I3780 \$I3781 VSS NMOS L=1u W=3.4u AS=6.46p AD=6.46p PS=7.2u
+ PD=7.2u
* device instance $612 m0 *1 409.2,290.3 NMOS
XM$612 \$I3781 WL9 BLB16 VSS NMOS L=1u W=3.4u AS=6.46p AD=10.88p PS=7.2u
+ PD=13.2u
* device instance $613 m0 *1 538.8,329.1 PMOS
XM$613 \$I3782 \$I3783 VDD VDD PMOS L=1u W=3.4u AS=10.88p AD=6.46p PS=13.2u
+ PD=7.2u
* device instance $614 m0 *1 543.6,329.1 PMOS
XM$614 VDD \$I3782 \$I3783 VDD PMOS L=1u W=3.4u AS=6.46p AD=10.88p PS=7.2u
+ PD=13.2u
* device instance $615 m0 *1 534,349.5 NMOS
XM$615 BL22 WL11 \$I3782 VSS NMOS L=1u W=3.4u AS=10.88p AD=6.46p PS=13.2u
+ PD=7.2u
* device instance $616 m0 *1 538.8,349.5 NMOS
XM$616 \$I3782 \$I3783 VSS VSS NMOS L=1u W=3.4u AS=6.46p AD=6.46p PS=7.2u
+ PD=7.2u
* device instance $617 m0 *1 543.6,349.5 NMOS
XM$617 VSS \$I3782 \$I3783 VSS NMOS L=1u W=3.4u AS=6.46p AD=6.46p PS=7.2u
+ PD=7.2u
* device instance $618 m0 *1 548.4,349.5 NMOS
XM$618 \$I3783 WL11 BLB22 VSS NMOS L=1u W=3.4u AS=6.46p AD=10.88p PS=7.2u
+ PD=13.2u
* device instance $619 m0 *1 53.6,33.1 PMOS
XM$619 \$I3784 \$I3785 VDD VDD PMOS L=1u W=3.4u AS=10.88p AD=6.46p PS=13.2u
+ PD=7.2u
* device instance $620 m0 *1 58.4,33.1 PMOS
XM$620 VDD \$I3784 \$I3785 VDD PMOS L=1u W=3.4u AS=6.46p AD=10.88p PS=7.2u
+ PD=13.2u
* device instance $621 m0 *1 48.8,53.5 NMOS
XM$621 BL2 WL1 \$I3784 VSS NMOS L=1u W=3.4u AS=10.88p AD=6.46p PS=13.2u PD=7.2u
* device instance $622 m0 *1 53.6,53.5 NMOS
XM$622 \$I3784 \$I3785 VSS VSS NMOS L=1u W=3.4u AS=6.46p AD=6.46p PS=7.2u
+ PD=7.2u
* device instance $623 m0 *1 58.4,53.5 NMOS
XM$623 VSS \$I3784 \$I3785 VSS NMOS L=1u W=3.4u AS=6.46p AD=6.46p PS=7.2u
+ PD=7.2u
* device instance $624 m0 *1 63.2,53.5 NMOS
XM$624 \$I3785 WL1 BLB2 VSS NMOS L=1u W=3.4u AS=6.46p AD=10.88p PS=7.2u PD=13.2u
* device instance $625 m0 *1 169.6,329.1 PMOS
XM$625 \$I3786 \$I3787 VDD VDD PMOS L=1u W=3.4u AS=10.88p AD=6.46p PS=13.2u
+ PD=7.2u
* device instance $626 m0 *1 174.4,329.1 PMOS
XM$626 VDD \$I3786 \$I3787 VDD PMOS L=1u W=3.4u AS=6.46p AD=10.88p PS=7.2u
+ PD=13.2u
* device instance $627 m0 *1 164.8,349.5 NMOS
XM$627 BL7 WL11 \$I3786 VSS NMOS L=1u W=3.4u AS=10.88p AD=6.46p PS=13.2u PD=7.2u
* device instance $628 m0 *1 169.6,349.5 NMOS
XM$628 \$I3786 \$I3787 VSS VSS NMOS L=1u W=3.4u AS=6.46p AD=6.46p PS=7.2u
+ PD=7.2u
* device instance $629 m0 *1 174.4,349.5 NMOS
XM$629 VSS \$I3786 \$I3787 VSS NMOS L=1u W=3.4u AS=6.46p AD=6.46p PS=7.2u
+ PD=7.2u
* device instance $630 m0 *1 179.2,349.5 NMOS
XM$630 \$I3787 WL11 BLB7 VSS NMOS L=1u W=3.4u AS=6.46p AD=10.88p PS=7.2u
+ PD=13.2u
* device instance $631 m0 *1 355.2,447.5 PMOS
XM$631 \$I3788 \$I3789 VDD VDD PMOS L=1u W=3.4u AS=10.88p AD=6.46p PS=13.2u
+ PD=7.2u
* device instance $632 m0 *1 360,447.5 PMOS
XM$632 VDD \$I3788 \$I3789 VDD PMOS L=1u W=3.4u AS=6.46p AD=10.88p PS=7.2u
+ PD=13.2u
* device instance $633 m0 *1 350.4,467.9 NMOS
XM$633 BL15 WL15 \$I3788 VSS NMOS L=1u W=3.4u AS=10.88p AD=6.46p PS=13.2u
+ PD=7.2u
* device instance $634 m0 *1 355.2,467.9 NMOS
XM$634 \$I3788 \$I3789 VSS VSS NMOS L=1u W=3.4u AS=6.46p AD=6.46p PS=7.2u
+ PD=7.2u
* device instance $635 m0 *1 360,467.9 NMOS
XM$635 VSS \$I3788 \$I3789 VSS NMOS L=1u W=3.4u AS=6.46p AD=6.46p PS=7.2u
+ PD=7.2u
* device instance $636 m0 *1 364.8,467.9 NMOS
XM$636 \$I3789 WL15 BLB15 VSS NMOS L=1u W=3.4u AS=6.46p AD=10.88p PS=7.2u
+ PD=13.2u
* device instance $637 m0 *1 332,447.5 PMOS
XM$637 \$I3790 \$I3791 VDD VDD PMOS L=1u W=3.4u AS=10.88p AD=6.46p PS=13.2u
+ PD=7.2u
* device instance $638 m0 *1 336.8,447.5 PMOS
XM$638 VDD \$I3790 \$I3791 VDD PMOS L=1u W=3.4u AS=6.46p AD=10.88p PS=7.2u
+ PD=13.2u
* device instance $639 m0 *1 327.2,467.9 NMOS
XM$639 BL14 WL15 \$I3790 VSS NMOS L=1u W=3.4u AS=10.88p AD=6.46p PS=13.2u
+ PD=7.2u
* device instance $640 m0 *1 332,467.9 NMOS
XM$640 \$I3790 \$I3791 VSS VSS NMOS L=1u W=3.4u AS=6.46p AD=6.46p PS=7.2u
+ PD=7.2u
* device instance $641 m0 *1 336.8,467.9 NMOS
XM$641 VSS \$I3790 \$I3791 VSS NMOS L=1u W=3.4u AS=6.46p AD=6.46p PS=7.2u
+ PD=7.2u
* device instance $642 m0 *1 341.6,467.9 NMOS
XM$642 \$I3791 WL15 BLB14 VSS NMOS L=1u W=3.4u AS=6.46p AD=10.88p PS=7.2u
+ PD=13.2u
* device instance $643 m0 *1 308.8,447.5 PMOS
XM$643 \$I3792 \$I3793 VDD VDD PMOS L=1u W=3.4u AS=10.88p AD=6.46p PS=13.2u
+ PD=7.2u
* device instance $644 m0 *1 313.6,447.5 PMOS
XM$644 VDD \$I3792 \$I3793 VDD PMOS L=1u W=3.4u AS=6.46p AD=10.88p PS=7.2u
+ PD=13.2u
* device instance $645 m0 *1 304,467.9 NMOS
XM$645 BL13 WL15 \$I3792 VSS NMOS L=1u W=3.4u AS=10.88p AD=6.46p PS=13.2u
+ PD=7.2u
* device instance $646 m0 *1 308.8,467.9 NMOS
XM$646 \$I3792 \$I3793 VSS VSS NMOS L=1u W=3.4u AS=6.46p AD=6.46p PS=7.2u
+ PD=7.2u
* device instance $647 m0 *1 313.6,467.9 NMOS
XM$647 VSS \$I3792 \$I3793 VSS NMOS L=1u W=3.4u AS=6.46p AD=6.46p PS=7.2u
+ PD=7.2u
* device instance $648 m0 *1 318.4,467.9 NMOS
XM$648 \$I3793 WL15 BLB13 VSS NMOS L=1u W=3.4u AS=6.46p AD=10.88p PS=7.2u
+ PD=13.2u
* device instance $649 m0 *1 285.6,447.5 PMOS
XM$649 \$I3794 \$I3795 VDD VDD PMOS L=1u W=3.4u AS=10.88p AD=6.46p PS=13.2u
+ PD=7.2u
* device instance $650 m0 *1 290.4,447.5 PMOS
XM$650 VDD \$I3794 \$I3795 VDD PMOS L=1u W=3.4u AS=6.46p AD=10.88p PS=7.2u
+ PD=13.2u
* device instance $651 m0 *1 280.8,467.9 NMOS
XM$651 BL12 WL15 \$I3794 VSS NMOS L=1u W=3.4u AS=10.88p AD=6.46p PS=13.2u
+ PD=7.2u
* device instance $652 m0 *1 285.6,467.9 NMOS
XM$652 \$I3794 \$I3795 VSS VSS NMOS L=1u W=3.4u AS=6.46p AD=6.46p PS=7.2u
+ PD=7.2u
* device instance $653 m0 *1 290.4,467.9 NMOS
XM$653 VSS \$I3794 \$I3795 VSS NMOS L=1u W=3.4u AS=6.46p AD=6.46p PS=7.2u
+ PD=7.2u
* device instance $654 m0 *1 295.2,467.9 NMOS
XM$654 \$I3795 WL15 BLB12 VSS NMOS L=1u W=3.4u AS=6.46p AD=10.88p PS=7.2u
+ PD=13.2u
* device instance $655 m0 *1 262.4,447.5 PMOS
XM$655 \$I3796 \$I3797 VDD VDD PMOS L=1u W=3.4u AS=10.88p AD=6.46p PS=13.2u
+ PD=7.2u
* device instance $656 m0 *1 267.2,447.5 PMOS
XM$656 VDD \$I3796 \$I3797 VDD PMOS L=1u W=3.4u AS=6.46p AD=10.88p PS=7.2u
+ PD=13.2u
* device instance $657 m0 *1 257.6,467.9 NMOS
XM$657 BL11 WL15 \$I3796 VSS NMOS L=1u W=3.4u AS=10.88p AD=6.46p PS=13.2u
+ PD=7.2u
* device instance $658 m0 *1 262.4,467.9 NMOS
XM$658 \$I3796 \$I3797 VSS VSS NMOS L=1u W=3.4u AS=6.46p AD=6.46p PS=7.2u
+ PD=7.2u
* device instance $659 m0 *1 267.2,467.9 NMOS
XM$659 VSS \$I3796 \$I3797 VSS NMOS L=1u W=3.4u AS=6.46p AD=6.46p PS=7.2u
+ PD=7.2u
* device instance $660 m0 *1 272,467.9 NMOS
XM$660 \$I3797 WL15 BLB11 VSS NMOS L=1u W=3.4u AS=6.46p AD=10.88p PS=7.2u
+ PD=13.2u
* device instance $661 m0 *1 239.2,447.5 PMOS
XM$661 \$I3798 \$I3799 VDD VDD PMOS L=1u W=3.4u AS=10.88p AD=6.46p PS=13.2u
+ PD=7.2u
* device instance $662 m0 *1 244,447.5 PMOS
XM$662 VDD \$I3798 \$I3799 VDD PMOS L=1u W=3.4u AS=6.46p AD=10.88p PS=7.2u
+ PD=13.2u
* device instance $663 m0 *1 234.4,467.9 NMOS
XM$663 BL10 WL15 \$I3798 VSS NMOS L=1u W=3.4u AS=10.88p AD=6.46p PS=13.2u
+ PD=7.2u
* device instance $664 m0 *1 239.2,467.9 NMOS
XM$664 \$I3798 \$I3799 VSS VSS NMOS L=1u W=3.4u AS=6.46p AD=6.46p PS=7.2u
+ PD=7.2u
* device instance $665 m0 *1 244,467.9 NMOS
XM$665 VSS \$I3798 \$I3799 VSS NMOS L=1u W=3.4u AS=6.46p AD=6.46p PS=7.2u
+ PD=7.2u
* device instance $666 m0 *1 248.8,467.9 NMOS
XM$666 \$I3799 WL15 BLB10 VSS NMOS L=1u W=3.4u AS=6.46p AD=10.88p PS=7.2u
+ PD=13.2u
* device instance $667 m0 *1 216,447.5 PMOS
XM$667 \$I3800 \$I3801 VDD VDD PMOS L=1u W=3.4u AS=10.88p AD=6.46p PS=13.2u
+ PD=7.2u
* device instance $668 m0 *1 220.8,447.5 PMOS
XM$668 VDD \$I3800 \$I3801 VDD PMOS L=1u W=3.4u AS=6.46p AD=10.88p PS=7.2u
+ PD=13.2u
* device instance $669 m0 *1 211.2,467.9 NMOS
XM$669 BL9 WL15 \$I3800 VSS NMOS L=1u W=3.4u AS=10.88p AD=6.46p PS=13.2u PD=7.2u
* device instance $670 m0 *1 216,467.9 NMOS
XM$670 \$I3800 \$I3801 VSS VSS NMOS L=1u W=3.4u AS=6.46p AD=6.46p PS=7.2u
+ PD=7.2u
* device instance $671 m0 *1 220.8,467.9 NMOS
XM$671 VSS \$I3800 \$I3801 VSS NMOS L=1u W=3.4u AS=6.46p AD=6.46p PS=7.2u
+ PD=7.2u
* device instance $672 m0 *1 225.6,467.9 NMOS
XM$672 \$I3801 WL15 BLB9 VSS NMOS L=1u W=3.4u AS=6.46p AD=10.88p PS=7.2u
+ PD=13.2u
* device instance $673 m0 *1 239.2,151.5 PMOS
XM$673 \$I3802 \$I3803 VDD VDD PMOS L=1u W=3.4u AS=10.88p AD=6.46p PS=13.2u
+ PD=7.2u
* device instance $674 m0 *1 244,151.5 PMOS
XM$674 VDD \$I3802 \$I3803 VDD PMOS L=1u W=3.4u AS=6.46p AD=10.88p PS=7.2u
+ PD=13.2u
* device instance $675 m0 *1 234.4,171.9 NMOS
XM$675 BL10 WL5 \$I3802 VSS NMOS L=1u W=3.4u AS=10.88p AD=6.46p PS=13.2u PD=7.2u
* device instance $676 m0 *1 239.2,171.9 NMOS
XM$676 \$I3802 \$I3803 VSS VSS NMOS L=1u W=3.4u AS=6.46p AD=6.46p PS=7.2u
+ PD=7.2u
* device instance $677 m0 *1 244,171.9 NMOS
XM$677 VSS \$I3802 \$I3803 VSS NMOS L=1u W=3.4u AS=6.46p AD=6.46p PS=7.2u
+ PD=7.2u
* device instance $678 m0 *1 248.8,171.9 NMOS
XM$678 \$I3803 WL5 BLB10 VSS NMOS L=1u W=3.4u AS=6.46p AD=10.88p PS=7.2u
+ PD=13.2u
* device instance $679 m0 *1 30.4,269.9 PMOS
XM$679 \$I3804 \$I3805 VDD VDD PMOS L=1u W=3.4u AS=10.88p AD=6.46p PS=13.2u
+ PD=7.2u
* device instance $680 m0 *1 35.2,269.9 PMOS
XM$680 VDD \$I3804 \$I3805 VDD PMOS L=1u W=3.4u AS=6.46p AD=10.88p PS=7.2u
+ PD=13.2u
* device instance $681 m0 *1 25.6,290.3 NMOS
XM$681 BL1 WL9 \$I3804 VSS NMOS L=1u W=3.4u AS=10.88p AD=6.46p PS=13.2u PD=7.2u
* device instance $682 m0 *1 30.4,290.3 NMOS
XM$682 \$I3804 \$I3805 VSS VSS NMOS L=1u W=3.4u AS=6.46p AD=6.46p PS=7.2u
+ PD=7.2u
* device instance $683 m0 *1 35.2,290.3 NMOS
XM$683 VSS \$I3804 \$I3805 VSS NMOS L=1u W=3.4u AS=6.46p AD=6.46p PS=7.2u
+ PD=7.2u
* device instance $684 m0 *1 40,290.3 NMOS
XM$684 \$I3805 WL9 BLB1 VSS NMOS L=1u W=3.4u AS=6.46p AD=10.88p PS=7.2u PD=13.2u
* device instance $685 m0 *1 53.6,269.9 PMOS
XM$685 \$I3806 \$I3807 VDD VDD PMOS L=1u W=3.4u AS=10.88p AD=6.46p PS=13.2u
+ PD=7.2u
* device instance $686 m0 *1 58.4,269.9 PMOS
XM$686 VDD \$I3806 \$I3807 VDD PMOS L=1u W=3.4u AS=6.46p AD=10.88p PS=7.2u
+ PD=13.2u
* device instance $687 m0 *1 48.8,290.3 NMOS
XM$687 BL2 WL9 \$I3806 VSS NMOS L=1u W=3.4u AS=10.88p AD=6.46p PS=13.2u PD=7.2u
* device instance $688 m0 *1 53.6,290.3 NMOS
XM$688 \$I3806 \$I3807 VSS VSS NMOS L=1u W=3.4u AS=6.46p AD=6.46p PS=7.2u
+ PD=7.2u
* device instance $689 m0 *1 58.4,290.3 NMOS
XM$689 VSS \$I3806 \$I3807 VSS NMOS L=1u W=3.4u AS=6.46p AD=6.46p PS=7.2u
+ PD=7.2u
* device instance $690 m0 *1 63.2,290.3 NMOS
XM$690 \$I3807 WL9 BLB2 VSS NMOS L=1u W=3.4u AS=6.46p AD=10.88p PS=7.2u PD=13.2u
* device instance $691 m0 *1 76.8,269.9 PMOS
XM$691 \$I3808 \$I3809 VDD VDD PMOS L=1u W=3.4u AS=10.88p AD=6.46p PS=13.2u
+ PD=7.2u
* device instance $692 m0 *1 81.6,269.9 PMOS
XM$692 VDD \$I3808 \$I3809 VDD PMOS L=1u W=3.4u AS=6.46p AD=10.88p PS=7.2u
+ PD=13.2u
* device instance $693 m0 *1 72,290.3 NMOS
XM$693 BL3 WL9 \$I3808 VSS NMOS L=1u W=3.4u AS=10.88p AD=6.46p PS=13.2u PD=7.2u
* device instance $694 m0 *1 76.8,290.3 NMOS
XM$694 \$I3808 \$I3809 VSS VSS NMOS L=1u W=3.4u AS=6.46p AD=6.46p PS=7.2u
+ PD=7.2u
* device instance $695 m0 *1 81.6,290.3 NMOS
XM$695 VSS \$I3808 \$I3809 VSS NMOS L=1u W=3.4u AS=6.46p AD=6.46p PS=7.2u
+ PD=7.2u
* device instance $696 m0 *1 86.4,290.3 NMOS
XM$696 \$I3809 WL9 BLB3 VSS NMOS L=1u W=3.4u AS=6.46p AD=10.88p PS=7.2u PD=13.2u
* device instance $697 m0 *1 100,269.9 PMOS
XM$697 \$I3810 \$I3811 VDD VDD PMOS L=1u W=3.4u AS=10.88p AD=6.46p PS=13.2u
+ PD=7.2u
* device instance $698 m0 *1 104.8,269.9 PMOS
XM$698 VDD \$I3810 \$I3811 VDD PMOS L=1u W=3.4u AS=6.46p AD=10.88p PS=7.2u
+ PD=13.2u
* device instance $699 m0 *1 95.2,290.3 NMOS
XM$699 BL4 WL9 \$I3810 VSS NMOS L=1u W=3.4u AS=10.88p AD=6.46p PS=13.2u PD=7.2u
* device instance $700 m0 *1 100,290.3 NMOS
XM$700 \$I3810 \$I3811 VSS VSS NMOS L=1u W=3.4u AS=6.46p AD=6.46p PS=7.2u
+ PD=7.2u
* device instance $701 m0 *1 104.8,290.3 NMOS
XM$701 VSS \$I3810 \$I3811 VSS NMOS L=1u W=3.4u AS=6.46p AD=6.46p PS=7.2u
+ PD=7.2u
* device instance $702 m0 *1 109.6,290.3 NMOS
XM$702 \$I3811 WL9 BLB4 VSS NMOS L=1u W=3.4u AS=6.46p AD=10.88p PS=7.2u PD=13.2u
* device instance $703 m0 *1 123.2,269.9 PMOS
XM$703 \$I3812 \$I3813 VDD VDD PMOS L=1u W=3.4u AS=10.88p AD=6.46p PS=13.2u
+ PD=7.2u
* device instance $704 m0 *1 128,269.9 PMOS
XM$704 VDD \$I3812 \$I3813 VDD PMOS L=1u W=3.4u AS=6.46p AD=10.88p PS=7.2u
+ PD=13.2u
* device instance $705 m0 *1 118.4,290.3 NMOS
XM$705 BL5 WL9 \$I3812 VSS NMOS L=1u W=3.4u AS=10.88p AD=6.46p PS=13.2u PD=7.2u
* device instance $706 m0 *1 123.2,290.3 NMOS
XM$706 \$I3812 \$I3813 VSS VSS NMOS L=1u W=3.4u AS=6.46p AD=6.46p PS=7.2u
+ PD=7.2u
* device instance $707 m0 *1 128,290.3 NMOS
XM$707 VSS \$I3812 \$I3813 VSS NMOS L=1u W=3.4u AS=6.46p AD=6.46p PS=7.2u
+ PD=7.2u
* device instance $708 m0 *1 132.8,290.3 NMOS
XM$708 \$I3813 WL9 BLB5 VSS NMOS L=1u W=3.4u AS=6.46p AD=10.88p PS=7.2u PD=13.2u
* device instance $709 m0 *1 146.4,269.9 PMOS
XM$709 \$I3814 \$I3815 VDD VDD PMOS L=1u W=3.4u AS=10.88p AD=6.46p PS=13.2u
+ PD=7.2u
* device instance $710 m0 *1 151.2,269.9 PMOS
XM$710 VDD \$I3814 \$I3815 VDD PMOS L=1u W=3.4u AS=6.46p AD=10.88p PS=7.2u
+ PD=13.2u
* device instance $711 m0 *1 141.6,290.3 NMOS
XM$711 BL6 WL9 \$I3814 VSS NMOS L=1u W=3.4u AS=10.88p AD=6.46p PS=13.2u PD=7.2u
* device instance $712 m0 *1 146.4,290.3 NMOS
XM$712 \$I3814 \$I3815 VSS VSS NMOS L=1u W=3.4u AS=6.46p AD=6.46p PS=7.2u
+ PD=7.2u
* device instance $713 m0 *1 151.2,290.3 NMOS
XM$713 VSS \$I3814 \$I3815 VSS NMOS L=1u W=3.4u AS=6.46p AD=6.46p PS=7.2u
+ PD=7.2u
* device instance $714 m0 *1 156,290.3 NMOS
XM$714 \$I3815 WL9 BLB6 VSS NMOS L=1u W=3.4u AS=6.46p AD=10.88p PS=7.2u PD=13.2u
* device instance $715 m0 *1 169.6,269.9 PMOS
XM$715 \$I3816 \$I3817 VDD VDD PMOS L=1u W=3.4u AS=10.88p AD=6.46p PS=13.2u
+ PD=7.2u
* device instance $716 m0 *1 174.4,269.9 PMOS
XM$716 VDD \$I3816 \$I3817 VDD PMOS L=1u W=3.4u AS=6.46p AD=10.88p PS=7.2u
+ PD=13.2u
* device instance $717 m0 *1 164.8,290.3 NMOS
XM$717 BL7 WL9 \$I3816 VSS NMOS L=1u W=3.4u AS=10.88p AD=6.46p PS=13.2u PD=7.2u
* device instance $718 m0 *1 169.6,290.3 NMOS
XM$718 \$I3816 \$I3817 VSS VSS NMOS L=1u W=3.4u AS=6.46p AD=6.46p PS=7.2u
+ PD=7.2u
* device instance $719 m0 *1 174.4,290.3 NMOS
XM$719 VSS \$I3816 \$I3817 VSS NMOS L=1u W=3.4u AS=6.46p AD=6.46p PS=7.2u
+ PD=7.2u
* device instance $720 m0 *1 179.2,290.3 NMOS
XM$720 \$I3817 WL9 BLB7 VSS NMOS L=1u W=3.4u AS=6.46p AD=10.88p PS=7.2u PD=13.2u
* device instance $721 m0 *1 7.2,329.1 PMOS
XM$721 \$I3818 \$I3819 VDD VDD PMOS L=1u W=3.4u AS=10.88p AD=6.46p PS=13.2u
+ PD=7.2u
* device instance $722 m0 *1 12,329.1 PMOS
XM$722 VDD \$I3818 \$I3819 VDD PMOS L=1u W=3.4u AS=6.46p AD=10.88p PS=7.2u
+ PD=13.2u
* device instance $723 m0 *1 2.4,349.5 NMOS
XM$723 BL0 WL11 \$I3818 VSS NMOS L=1u W=3.4u AS=10.88p AD=6.46p PS=13.2u PD=7.2u
* device instance $724 m0 *1 7.2,349.5 NMOS
XM$724 \$I3818 \$I3819 VSS VSS NMOS L=1u W=3.4u AS=6.46p AD=6.46p PS=7.2u
+ PD=7.2u
* device instance $725 m0 *1 12,349.5 NMOS
XM$725 VSS \$I3818 \$I3819 VSS NMOS L=1u W=3.4u AS=6.46p AD=6.46p PS=7.2u
+ PD=7.2u
* device instance $726 m0 *1 16.8,349.5 NMOS
XM$726 \$I3819 WL11 BLB0 VSS NMOS L=1u W=3.4u AS=6.46p AD=10.88p PS=7.2u
+ PD=13.2u
* device instance $727 m0 *1 7.2,269.9 PMOS
XM$727 \$I3820 \$I3821 VDD VDD PMOS L=1u W=3.4u AS=10.88p AD=6.46p PS=13.2u
+ PD=7.2u
* device instance $728 m0 *1 12,269.9 PMOS
XM$728 VDD \$I3820 \$I3821 VDD PMOS L=1u W=3.4u AS=6.46p AD=10.88p PS=7.2u
+ PD=13.2u
* device instance $729 m0 *1 2.4,290.3 NMOS
XM$729 BL0 WL9 \$I3820 VSS NMOS L=1u W=3.4u AS=10.88p AD=6.46p PS=13.2u PD=7.2u
* device instance $730 m0 *1 7.2,290.3 NMOS
XM$730 \$I3820 \$I3821 VSS VSS NMOS L=1u W=3.4u AS=6.46p AD=6.46p PS=7.2u
+ PD=7.2u
* device instance $731 m0 *1 12,290.3 NMOS
XM$731 VSS \$I3820 \$I3821 VSS NMOS L=1u W=3.4u AS=6.46p AD=6.46p PS=7.2u
+ PD=7.2u
* device instance $732 m0 *1 16.8,290.3 NMOS
XM$732 \$I3821 WL9 BLB0 VSS NMOS L=1u W=3.4u AS=6.46p AD=10.88p PS=7.2u PD=13.2u
* device instance $733 m0 *1 146.4,388.3 PMOS
XM$733 \$I3822 \$I3823 VDD VDD PMOS L=1u W=3.4u AS=10.88p AD=6.46p PS=13.2u
+ PD=7.2u
* device instance $734 m0 *1 151.2,388.3 PMOS
XM$734 VDD \$I3822 \$I3823 VDD PMOS L=1u W=3.4u AS=6.46p AD=10.88p PS=7.2u
+ PD=13.2u
* device instance $735 m0 *1 141.6,408.7 NMOS
XM$735 BL6 WL13 \$I3822 VSS NMOS L=1u W=3.4u AS=10.88p AD=6.46p PS=13.2u PD=7.2u
* device instance $736 m0 *1 146.4,408.7 NMOS
XM$736 \$I3822 \$I3823 VSS VSS NMOS L=1u W=3.4u AS=6.46p AD=6.46p PS=7.2u
+ PD=7.2u
* device instance $737 m0 *1 151.2,408.7 NMOS
XM$737 VSS \$I3822 \$I3823 VSS NMOS L=1u W=3.4u AS=6.46p AD=6.46p PS=7.2u
+ PD=7.2u
* device instance $738 m0 *1 156,408.7 NMOS
XM$738 \$I3823 WL13 BLB6 VSS NMOS L=1u W=3.4u AS=6.46p AD=10.88p PS=7.2u
+ PD=13.2u
* device instance $739 m0 *1 7.2,447.5 PMOS
XM$739 \$I3824 \$I3825 VDD VDD PMOS L=1u W=3.4u AS=10.88p AD=6.46p PS=13.2u
+ PD=7.2u
* device instance $740 m0 *1 12,447.5 PMOS
XM$740 VDD \$I3824 \$I3825 VDD PMOS L=1u W=3.4u AS=6.46p AD=10.88p PS=7.2u
+ PD=13.2u
* device instance $741 m0 *1 2.4,467.9 NMOS
XM$741 BL0 WL15 \$I3824 VSS NMOS L=1u W=3.4u AS=10.88p AD=6.46p PS=13.2u PD=7.2u
* device instance $742 m0 *1 7.2,467.9 NMOS
XM$742 \$I3824 \$I3825 VSS VSS NMOS L=1u W=3.4u AS=6.46p AD=6.46p PS=7.2u
+ PD=7.2u
* device instance $743 m0 *1 12,467.9 NMOS
XM$743 VSS \$I3824 \$I3825 VSS NMOS L=1u W=3.4u AS=6.46p AD=6.46p PS=7.2u
+ PD=7.2u
* device instance $744 m0 *1 16.8,467.9 NMOS
XM$744 \$I3825 WL15 BLB0 VSS NMOS L=1u W=3.4u AS=6.46p AD=10.88p PS=7.2u
+ PD=13.2u
* device instance $745 m0 *1 30.4,447.5 PMOS
XM$745 \$I3826 \$I3827 VDD VDD PMOS L=1u W=3.4u AS=10.88p AD=6.46p PS=13.2u
+ PD=7.2u
* device instance $746 m0 *1 35.2,447.5 PMOS
XM$746 VDD \$I3826 \$I3827 VDD PMOS L=1u W=3.4u AS=6.46p AD=10.88p PS=7.2u
+ PD=13.2u
* device instance $747 m0 *1 25.6,467.9 NMOS
XM$747 BL1 WL15 \$I3826 VSS NMOS L=1u W=3.4u AS=10.88p AD=6.46p PS=13.2u PD=7.2u
* device instance $748 m0 *1 30.4,467.9 NMOS
XM$748 \$I3826 \$I3827 VSS VSS NMOS L=1u W=3.4u AS=6.46p AD=6.46p PS=7.2u
+ PD=7.2u
* device instance $749 m0 *1 35.2,467.9 NMOS
XM$749 VSS \$I3826 \$I3827 VSS NMOS L=1u W=3.4u AS=6.46p AD=6.46p PS=7.2u
+ PD=7.2u
* device instance $750 m0 *1 40,467.9 NMOS
XM$750 \$I3827 WL15 BLB1 VSS NMOS L=1u W=3.4u AS=6.46p AD=10.88p PS=7.2u
+ PD=13.2u
* device instance $751 m0 *1 53.6,447.5 PMOS
XM$751 \$I3828 \$I3829 VDD VDD PMOS L=1u W=3.4u AS=10.88p AD=6.46p PS=13.2u
+ PD=7.2u
* device instance $752 m0 *1 58.4,447.5 PMOS
XM$752 VDD \$I3828 \$I3829 VDD PMOS L=1u W=3.4u AS=6.46p AD=10.88p PS=7.2u
+ PD=13.2u
* device instance $753 m0 *1 48.8,467.9 NMOS
XM$753 BL2 WL15 \$I3828 VSS NMOS L=1u W=3.4u AS=10.88p AD=6.46p PS=13.2u PD=7.2u
* device instance $754 m0 *1 53.6,467.9 NMOS
XM$754 \$I3828 \$I3829 VSS VSS NMOS L=1u W=3.4u AS=6.46p AD=6.46p PS=7.2u
+ PD=7.2u
* device instance $755 m0 *1 58.4,467.9 NMOS
XM$755 VSS \$I3828 \$I3829 VSS NMOS L=1u W=3.4u AS=6.46p AD=6.46p PS=7.2u
+ PD=7.2u
* device instance $756 m0 *1 63.2,467.9 NMOS
XM$756 \$I3829 WL15 BLB2 VSS NMOS L=1u W=3.4u AS=6.46p AD=10.88p PS=7.2u
+ PD=13.2u
* device instance $757 m0 *1 76.8,447.5 PMOS
XM$757 \$I3830 \$I3831 VDD VDD PMOS L=1u W=3.4u AS=10.88p AD=6.46p PS=13.2u
+ PD=7.2u
* device instance $758 m0 *1 81.6,447.5 PMOS
XM$758 VDD \$I3830 \$I3831 VDD PMOS L=1u W=3.4u AS=6.46p AD=10.88p PS=7.2u
+ PD=13.2u
* device instance $759 m0 *1 72,467.9 NMOS
XM$759 BL3 WL15 \$I3830 VSS NMOS L=1u W=3.4u AS=10.88p AD=6.46p PS=13.2u PD=7.2u
* device instance $760 m0 *1 76.8,467.9 NMOS
XM$760 \$I3830 \$I3831 VSS VSS NMOS L=1u W=3.4u AS=6.46p AD=6.46p PS=7.2u
+ PD=7.2u
* device instance $761 m0 *1 81.6,467.9 NMOS
XM$761 VSS \$I3830 \$I3831 VSS NMOS L=1u W=3.4u AS=6.46p AD=6.46p PS=7.2u
+ PD=7.2u
* device instance $762 m0 *1 86.4,467.9 NMOS
XM$762 \$I3831 WL15 BLB3 VSS NMOS L=1u W=3.4u AS=6.46p AD=10.88p PS=7.2u
+ PD=13.2u
* device instance $763 m0 *1 100,447.5 PMOS
XM$763 \$I3832 \$I3833 VDD VDD PMOS L=1u W=3.4u AS=10.88p AD=6.46p PS=13.2u
+ PD=7.2u
* device instance $764 m0 *1 104.8,447.5 PMOS
XM$764 VDD \$I3832 \$I3833 VDD PMOS L=1u W=3.4u AS=6.46p AD=10.88p PS=7.2u
+ PD=13.2u
* device instance $765 m0 *1 95.2,467.9 NMOS
XM$765 BL4 WL15 \$I3832 VSS NMOS L=1u W=3.4u AS=10.88p AD=6.46p PS=13.2u PD=7.2u
* device instance $766 m0 *1 100,467.9 NMOS
XM$766 \$I3832 \$I3833 VSS VSS NMOS L=1u W=3.4u AS=6.46p AD=6.46p PS=7.2u
+ PD=7.2u
* device instance $767 m0 *1 104.8,467.9 NMOS
XM$767 VSS \$I3832 \$I3833 VSS NMOS L=1u W=3.4u AS=6.46p AD=6.46p PS=7.2u
+ PD=7.2u
* device instance $768 m0 *1 109.6,467.9 NMOS
XM$768 \$I3833 WL15 BLB4 VSS NMOS L=1u W=3.4u AS=6.46p AD=10.88p PS=7.2u
+ PD=13.2u
* device instance $769 m0 *1 123.2,447.5 PMOS
XM$769 \$I3834 \$I3835 VDD VDD PMOS L=1u W=3.4u AS=10.88p AD=6.46p PS=13.2u
+ PD=7.2u
* device instance $770 m0 *1 128,447.5 PMOS
XM$770 VDD \$I3834 \$I3835 VDD PMOS L=1u W=3.4u AS=6.46p AD=10.88p PS=7.2u
+ PD=13.2u
* device instance $771 m0 *1 118.4,467.9 NMOS
XM$771 BL5 WL15 \$I3834 VSS NMOS L=1u W=3.4u AS=10.88p AD=6.46p PS=13.2u PD=7.2u
* device instance $772 m0 *1 123.2,467.9 NMOS
XM$772 \$I3834 \$I3835 VSS VSS NMOS L=1u W=3.4u AS=6.46p AD=6.46p PS=7.2u
+ PD=7.2u
* device instance $773 m0 *1 128,467.9 NMOS
XM$773 VSS \$I3834 \$I3835 VSS NMOS L=1u W=3.4u AS=6.46p AD=6.46p PS=7.2u
+ PD=7.2u
* device instance $774 m0 *1 132.8,467.9 NMOS
XM$774 \$I3835 WL15 BLB5 VSS NMOS L=1u W=3.4u AS=6.46p AD=10.88p PS=7.2u
+ PD=13.2u
* device instance $775 m0 *1 146.4,447.5 PMOS
XM$775 \$I3836 \$I3837 VDD VDD PMOS L=1u W=3.4u AS=10.88p AD=6.46p PS=13.2u
+ PD=7.2u
* device instance $776 m0 *1 151.2,447.5 PMOS
XM$776 VDD \$I3836 \$I3837 VDD PMOS L=1u W=3.4u AS=6.46p AD=10.88p PS=7.2u
+ PD=13.2u
* device instance $777 m0 *1 141.6,467.9 NMOS
XM$777 BL6 WL15 \$I3836 VSS NMOS L=1u W=3.4u AS=10.88p AD=6.46p PS=13.2u PD=7.2u
* device instance $778 m0 *1 146.4,467.9 NMOS
XM$778 \$I3836 \$I3837 VSS VSS NMOS L=1u W=3.4u AS=6.46p AD=6.46p PS=7.2u
+ PD=7.2u
* device instance $779 m0 *1 151.2,467.9 NMOS
XM$779 VSS \$I3836 \$I3837 VSS NMOS L=1u W=3.4u AS=6.46p AD=6.46p PS=7.2u
+ PD=7.2u
* device instance $780 m0 *1 156,467.9 NMOS
XM$780 \$I3837 WL15 BLB6 VSS NMOS L=1u W=3.4u AS=6.46p AD=10.88p PS=7.2u
+ PD=13.2u
* device instance $781 m0 *1 146.4,329.1 PMOS
XM$781 \$I3838 \$I3839 VDD VDD PMOS L=1u W=3.4u AS=10.88p AD=6.46p PS=13.2u
+ PD=7.2u
* device instance $782 m0 *1 151.2,329.1 PMOS
XM$782 VDD \$I3838 \$I3839 VDD PMOS L=1u W=3.4u AS=6.46p AD=10.88p PS=7.2u
+ PD=13.2u
* device instance $783 m0 *1 141.6,349.5 NMOS
XM$783 BL6 WL11 \$I3838 VSS NMOS L=1u W=3.4u AS=10.88p AD=6.46p PS=13.2u PD=7.2u
* device instance $784 m0 *1 146.4,349.5 NMOS
XM$784 \$I3838 \$I3839 VSS VSS NMOS L=1u W=3.4u AS=6.46p AD=6.46p PS=7.2u
+ PD=7.2u
* device instance $785 m0 *1 151.2,349.5 NMOS
XM$785 VSS \$I3838 \$I3839 VSS NMOS L=1u W=3.4u AS=6.46p AD=6.46p PS=7.2u
+ PD=7.2u
* device instance $786 m0 *1 156,349.5 NMOS
XM$786 \$I3839 WL11 BLB6 VSS NMOS L=1u W=3.4u AS=6.46p AD=10.88p PS=7.2u
+ PD=13.2u
* device instance $787 m0 *1 123.2,388.3 PMOS
XM$787 \$I3840 \$I3841 VDD VDD PMOS L=1u W=3.4u AS=10.88p AD=6.46p PS=13.2u
+ PD=7.2u
* device instance $788 m0 *1 128,388.3 PMOS
XM$788 VDD \$I3840 \$I3841 VDD PMOS L=1u W=3.4u AS=6.46p AD=10.88p PS=7.2u
+ PD=13.2u
* device instance $789 m0 *1 118.4,408.7 NMOS
XM$789 BL5 WL13 \$I3840 VSS NMOS L=1u W=3.4u AS=10.88p AD=6.46p PS=13.2u PD=7.2u
* device instance $790 m0 *1 123.2,408.7 NMOS
XM$790 \$I3840 \$I3841 VSS VSS NMOS L=1u W=3.4u AS=6.46p AD=6.46p PS=7.2u
+ PD=7.2u
* device instance $791 m0 *1 128,408.7 NMOS
XM$791 VSS \$I3840 \$I3841 VSS NMOS L=1u W=3.4u AS=6.46p AD=6.46p PS=7.2u
+ PD=7.2u
* device instance $792 m0 *1 132.8,408.7 NMOS
XM$792 \$I3841 WL13 BLB5 VSS NMOS L=1u W=3.4u AS=6.46p AD=10.88p PS=7.2u
+ PD=13.2u
* device instance $793 m0 *1 100,388.3 PMOS
XM$793 \$I3842 \$I3843 VDD VDD PMOS L=1u W=3.4u AS=10.88p AD=6.46p PS=13.2u
+ PD=7.2u
* device instance $794 m0 *1 104.8,388.3 PMOS
XM$794 VDD \$I3842 \$I3843 VDD PMOS L=1u W=3.4u AS=6.46p AD=10.88p PS=7.2u
+ PD=13.2u
* device instance $795 m0 *1 95.2,408.7 NMOS
XM$795 BL4 WL13 \$I3842 VSS NMOS L=1u W=3.4u AS=10.88p AD=6.46p PS=13.2u PD=7.2u
* device instance $796 m0 *1 100,408.7 NMOS
XM$796 \$I3842 \$I3843 VSS VSS NMOS L=1u W=3.4u AS=6.46p AD=6.46p PS=7.2u
+ PD=7.2u
* device instance $797 m0 *1 104.8,408.7 NMOS
XM$797 VSS \$I3842 \$I3843 VSS NMOS L=1u W=3.4u AS=6.46p AD=6.46p PS=7.2u
+ PD=7.2u
* device instance $798 m0 *1 109.6,408.7 NMOS
XM$798 \$I3843 WL13 BLB4 VSS NMOS L=1u W=3.4u AS=6.46p AD=10.88p PS=7.2u
+ PD=13.2u
* device instance $799 m0 *1 76.8,388.3 PMOS
XM$799 \$I3844 \$I3845 VDD VDD PMOS L=1u W=3.4u AS=10.88p AD=6.46p PS=13.2u
+ PD=7.2u
* device instance $800 m0 *1 81.6,388.3 PMOS
XM$800 VDD \$I3844 \$I3845 VDD PMOS L=1u W=3.4u AS=6.46p AD=10.88p PS=7.2u
+ PD=13.2u
* device instance $801 m0 *1 72,408.7 NMOS
XM$801 BL3 WL13 \$I3844 VSS NMOS L=1u W=3.4u AS=10.88p AD=6.46p PS=13.2u PD=7.2u
* device instance $802 m0 *1 76.8,408.7 NMOS
XM$802 \$I3844 \$I3845 VSS VSS NMOS L=1u W=3.4u AS=6.46p AD=6.46p PS=7.2u
+ PD=7.2u
* device instance $803 m0 *1 81.6,408.7 NMOS
XM$803 VSS \$I3844 \$I3845 VSS NMOS L=1u W=3.4u AS=6.46p AD=6.46p PS=7.2u
+ PD=7.2u
* device instance $804 m0 *1 86.4,408.7 NMOS
XM$804 \$I3845 WL13 BLB3 VSS NMOS L=1u W=3.4u AS=6.46p AD=10.88p PS=7.2u
+ PD=13.2u
* device instance $805 m0 *1 53.6,388.3 PMOS
XM$805 \$I3846 \$I3847 VDD VDD PMOS L=1u W=3.4u AS=10.88p AD=6.46p PS=13.2u
+ PD=7.2u
* device instance $806 m0 *1 58.4,388.3 PMOS
XM$806 VDD \$I3846 \$I3847 VDD PMOS L=1u W=3.4u AS=6.46p AD=10.88p PS=7.2u
+ PD=13.2u
* device instance $807 m0 *1 48.8,408.7 NMOS
XM$807 BL2 WL13 \$I3846 VSS NMOS L=1u W=3.4u AS=10.88p AD=6.46p PS=13.2u PD=7.2u
* device instance $808 m0 *1 53.6,408.7 NMOS
XM$808 \$I3846 \$I3847 VSS VSS NMOS L=1u W=3.4u AS=6.46p AD=6.46p PS=7.2u
+ PD=7.2u
* device instance $809 m0 *1 58.4,408.7 NMOS
XM$809 VSS \$I3846 \$I3847 VSS NMOS L=1u W=3.4u AS=6.46p AD=6.46p PS=7.2u
+ PD=7.2u
* device instance $810 m0 *1 63.2,408.7 NMOS
XM$810 \$I3847 WL13 BLB2 VSS NMOS L=1u W=3.4u AS=6.46p AD=10.88p PS=7.2u
+ PD=13.2u
* device instance $811 m0 *1 30.4,388.3 PMOS
XM$811 \$I3848 \$I3849 VDD VDD PMOS L=1u W=3.4u AS=10.88p AD=6.46p PS=13.2u
+ PD=7.2u
* device instance $812 m0 *1 35.2,388.3 PMOS
XM$812 VDD \$I3848 \$I3849 VDD PMOS L=1u W=3.4u AS=6.46p AD=10.88p PS=7.2u
+ PD=13.2u
* device instance $813 m0 *1 25.6,408.7 NMOS
XM$813 BL1 WL13 \$I3848 VSS NMOS L=1u W=3.4u AS=10.88p AD=6.46p PS=13.2u PD=7.2u
* device instance $814 m0 *1 30.4,408.7 NMOS
XM$814 \$I3848 \$I3849 VSS VSS NMOS L=1u W=3.4u AS=6.46p AD=6.46p PS=7.2u
+ PD=7.2u
* device instance $815 m0 *1 35.2,408.7 NMOS
XM$815 VSS \$I3848 \$I3849 VSS NMOS L=1u W=3.4u AS=6.46p AD=6.46p PS=7.2u
+ PD=7.2u
* device instance $816 m0 *1 40,408.7 NMOS
XM$816 \$I3849 WL13 BLB1 VSS NMOS L=1u W=3.4u AS=6.46p AD=10.88p PS=7.2u
+ PD=13.2u
* device instance $817 m0 *1 7.2,388.3 PMOS
XM$817 \$I3850 \$I3851 VDD VDD PMOS L=1u W=3.4u AS=10.88p AD=6.46p PS=13.2u
+ PD=7.2u
* device instance $818 m0 *1 12,388.3 PMOS
XM$818 VDD \$I3850 \$I3851 VDD PMOS L=1u W=3.4u AS=6.46p AD=10.88p PS=7.2u
+ PD=13.2u
* device instance $819 m0 *1 2.4,408.7 NMOS
XM$819 BL0 WL13 \$I3850 VSS NMOS L=1u W=3.4u AS=10.88p AD=6.46p PS=13.2u PD=7.2u
* device instance $820 m0 *1 7.2,408.7 NMOS
XM$820 \$I3850 \$I3851 VSS VSS NMOS L=1u W=3.4u AS=6.46p AD=6.46p PS=7.2u
+ PD=7.2u
* device instance $821 m0 *1 12,408.7 NMOS
XM$821 VSS \$I3850 \$I3851 VSS NMOS L=1u W=3.4u AS=6.46p AD=6.46p PS=7.2u
+ PD=7.2u
* device instance $822 m0 *1 16.8,408.7 NMOS
XM$822 \$I3851 WL13 BLB0 VSS NMOS L=1u W=3.4u AS=6.46p AD=10.88p PS=7.2u
+ PD=13.2u
* device instance $823 m0 *1 239.2,388.3 PMOS
XM$823 \$I3852 \$I3853 VDD VDD PMOS L=1u W=3.4u AS=10.88p AD=6.46p PS=13.2u
+ PD=7.2u
* device instance $824 m0 *1 244,388.3 PMOS
XM$824 VDD \$I3852 \$I3853 VDD PMOS L=1u W=3.4u AS=6.46p AD=10.88p PS=7.2u
+ PD=13.2u
* device instance $825 m0 *1 234.4,408.7 NMOS
XM$825 BL10 WL13 \$I3852 VSS NMOS L=1u W=3.4u AS=10.88p AD=6.46p PS=13.2u
+ PD=7.2u
* device instance $826 m0 *1 239.2,408.7 NMOS
XM$826 \$I3852 \$I3853 VSS VSS NMOS L=1u W=3.4u AS=6.46p AD=6.46p PS=7.2u
+ PD=7.2u
* device instance $827 m0 *1 244,408.7 NMOS
XM$827 VSS \$I3852 \$I3853 VSS NMOS L=1u W=3.4u AS=6.46p AD=6.46p PS=7.2u
+ PD=7.2u
* device instance $828 m0 *1 248.8,408.7 NMOS
XM$828 \$I3853 WL13 BLB10 VSS NMOS L=1u W=3.4u AS=6.46p AD=10.88p PS=7.2u
+ PD=13.2u
* device instance $829 m0 *1 216,388.3 PMOS
XM$829 \$I3854 \$I3855 VDD VDD PMOS L=1u W=3.4u AS=10.88p AD=6.46p PS=13.2u
+ PD=7.2u
* device instance $830 m0 *1 220.8,388.3 PMOS
XM$830 VDD \$I3854 \$I3855 VDD PMOS L=1u W=3.4u AS=6.46p AD=10.88p PS=7.2u
+ PD=13.2u
* device instance $831 m0 *1 211.2,408.7 NMOS
XM$831 BL9 WL13 \$I3854 VSS NMOS L=1u W=3.4u AS=10.88p AD=6.46p PS=13.2u PD=7.2u
* device instance $832 m0 *1 216,408.7 NMOS
XM$832 \$I3854 \$I3855 VSS VSS NMOS L=1u W=3.4u AS=6.46p AD=6.46p PS=7.2u
+ PD=7.2u
* device instance $833 m0 *1 220.8,408.7 NMOS
XM$833 VSS \$I3854 \$I3855 VSS NMOS L=1u W=3.4u AS=6.46p AD=6.46p PS=7.2u
+ PD=7.2u
* device instance $834 m0 *1 225.6,408.7 NMOS
XM$834 \$I3855 WL13 BLB9 VSS NMOS L=1u W=3.4u AS=6.46p AD=10.88p PS=7.2u
+ PD=13.2u
* device instance $835 m0 *1 169.6,447.5 PMOS
XM$835 \$I3856 \$I3857 VDD VDD PMOS L=1u W=3.4u AS=10.88p AD=6.46p PS=13.2u
+ PD=7.2u
* device instance $836 m0 *1 174.4,447.5 PMOS
XM$836 VDD \$I3856 \$I3857 VDD PMOS L=1u W=3.4u AS=6.46p AD=10.88p PS=7.2u
+ PD=13.2u
* device instance $837 m0 *1 164.8,467.9 NMOS
XM$837 BL7 WL15 \$I3856 VSS NMOS L=1u W=3.4u AS=10.88p AD=6.46p PS=13.2u PD=7.2u
* device instance $838 m0 *1 169.6,467.9 NMOS
XM$838 \$I3856 \$I3857 VSS VSS NMOS L=1u W=3.4u AS=6.46p AD=6.46p PS=7.2u
+ PD=7.2u
* device instance $839 m0 *1 174.4,467.9 NMOS
XM$839 VSS \$I3856 \$I3857 VSS NMOS L=1u W=3.4u AS=6.46p AD=6.46p PS=7.2u
+ PD=7.2u
* device instance $840 m0 *1 179.2,467.9 NMOS
XM$840 \$I3857 WL15 BLB7 VSS NMOS L=1u W=3.4u AS=6.46p AD=10.88p PS=7.2u
+ PD=13.2u
* device instance $841 m0 *1 308.8,269.9 PMOS
XM$841 \$I3858 \$I3859 VDD VDD PMOS L=1u W=3.4u AS=10.88p AD=6.46p PS=13.2u
+ PD=7.2u
* device instance $842 m0 *1 313.6,269.9 PMOS
XM$842 VDD \$I3858 \$I3859 VDD PMOS L=1u W=3.4u AS=6.46p AD=10.88p PS=7.2u
+ PD=13.2u
* device instance $843 m0 *1 304,290.3 NMOS
XM$843 BL13 WL9 \$I3858 VSS NMOS L=1u W=3.4u AS=10.88p AD=6.46p PS=13.2u PD=7.2u
* device instance $844 m0 *1 308.8,290.3 NMOS
XM$844 \$I3858 \$I3859 VSS VSS NMOS L=1u W=3.4u AS=6.46p AD=6.46p PS=7.2u
+ PD=7.2u
* device instance $845 m0 *1 313.6,290.3 NMOS
XM$845 VSS \$I3858 \$I3859 VSS NMOS L=1u W=3.4u AS=6.46p AD=6.46p PS=7.2u
+ PD=7.2u
* device instance $846 m0 *1 318.4,290.3 NMOS
XM$846 \$I3859 WL9 BLB13 VSS NMOS L=1u W=3.4u AS=6.46p AD=10.88p PS=7.2u
+ PD=13.2u
* device instance $847 m0 *1 332,269.9 PMOS
XM$847 \$I3860 \$I3861 VDD VDD PMOS L=1u W=3.4u AS=10.88p AD=6.46p PS=13.2u
+ PD=7.2u
* device instance $848 m0 *1 336.8,269.9 PMOS
XM$848 VDD \$I3860 \$I3861 VDD PMOS L=1u W=3.4u AS=6.46p AD=10.88p PS=7.2u
+ PD=13.2u
* device instance $849 m0 *1 327.2,290.3 NMOS
XM$849 BL14 WL9 \$I3860 VSS NMOS L=1u W=3.4u AS=10.88p AD=6.46p PS=13.2u PD=7.2u
* device instance $850 m0 *1 332,290.3 NMOS
XM$850 \$I3860 \$I3861 VSS VSS NMOS L=1u W=3.4u AS=6.46p AD=6.46p PS=7.2u
+ PD=7.2u
* device instance $851 m0 *1 336.8,290.3 NMOS
XM$851 VSS \$I3860 \$I3861 VSS NMOS L=1u W=3.4u AS=6.46p AD=6.46p PS=7.2u
+ PD=7.2u
* device instance $852 m0 *1 341.6,290.3 NMOS
XM$852 \$I3861 WL9 BLB14 VSS NMOS L=1u W=3.4u AS=6.46p AD=10.88p PS=7.2u
+ PD=13.2u
* device instance $853 m0 *1 355.2,269.9 PMOS
XM$853 \$I3862 \$I3863 VDD VDD PMOS L=1u W=3.4u AS=10.88p AD=6.46p PS=13.2u
+ PD=7.2u
* device instance $854 m0 *1 360,269.9 PMOS
XM$854 VDD \$I3862 \$I3863 VDD PMOS L=1u W=3.4u AS=6.46p AD=10.88p PS=7.2u
+ PD=13.2u
* device instance $855 m0 *1 350.4,290.3 NMOS
XM$855 BL15 WL9 \$I3862 VSS NMOS L=1u W=3.4u AS=10.88p AD=6.46p PS=13.2u PD=7.2u
* device instance $856 m0 *1 355.2,290.3 NMOS
XM$856 \$I3862 \$I3863 VSS VSS NMOS L=1u W=3.4u AS=6.46p AD=6.46p PS=7.2u
+ PD=7.2u
* device instance $857 m0 *1 360,290.3 NMOS
XM$857 VSS \$I3862 \$I3863 VSS NMOS L=1u W=3.4u AS=6.46p AD=6.46p PS=7.2u
+ PD=7.2u
* device instance $858 m0 *1 364.8,290.3 NMOS
XM$858 \$I3863 WL9 BLB15 VSS NMOS L=1u W=3.4u AS=6.46p AD=10.88p PS=7.2u
+ PD=13.2u
* device instance $859 m0 *1 262.4,388.3 PMOS
XM$859 \$I3864 \$I3865 VDD VDD PMOS L=1u W=3.4u AS=10.88p AD=6.46p PS=13.2u
+ PD=7.2u
* device instance $860 m0 *1 267.2,388.3 PMOS
XM$860 VDD \$I3864 \$I3865 VDD PMOS L=1u W=3.4u AS=6.46p AD=10.88p PS=7.2u
+ PD=13.2u
* device instance $861 m0 *1 257.6,408.7 NMOS
XM$861 BL11 WL13 \$I3864 VSS NMOS L=1u W=3.4u AS=10.88p AD=6.46p PS=13.2u
+ PD=7.2u
* device instance $862 m0 *1 262.4,408.7 NMOS
XM$862 \$I3864 \$I3865 VSS VSS NMOS L=1u W=3.4u AS=6.46p AD=6.46p PS=7.2u
+ PD=7.2u
* device instance $863 m0 *1 267.2,408.7 NMOS
XM$863 VSS \$I3864 \$I3865 VSS NMOS L=1u W=3.4u AS=6.46p AD=6.46p PS=7.2u
+ PD=7.2u
* device instance $864 m0 *1 272,408.7 NMOS
XM$864 \$I3865 WL13 BLB11 VSS NMOS L=1u W=3.4u AS=6.46p AD=10.88p PS=7.2u
+ PD=13.2u
* device instance $865 m0 *1 192.8,269.9 PMOS
XM$865 \$I3866 \$I3867 VDD VDD PMOS L=1u W=3.4u AS=10.88p AD=6.46p PS=13.2u
+ PD=7.2u
* device instance $866 m0 *1 197.6,269.9 PMOS
XM$866 VDD \$I3866 \$I3867 VDD PMOS L=1u W=3.4u AS=6.46p AD=10.88p PS=7.2u
+ PD=13.2u
* device instance $867 m0 *1 188,290.3 NMOS
XM$867 BL8 WL9 \$I3866 VSS NMOS L=1u W=3.4u AS=10.88p AD=6.46p PS=13.2u PD=7.2u
* device instance $868 m0 *1 192.8,290.3 NMOS
XM$868 \$I3866 \$I3867 VSS VSS NMOS L=1u W=3.4u AS=6.46p AD=6.46p PS=7.2u
+ PD=7.2u
* device instance $869 m0 *1 197.6,290.3 NMOS
XM$869 VSS \$I3866 \$I3867 VSS NMOS L=1u W=3.4u AS=6.46p AD=6.46p PS=7.2u
+ PD=7.2u
* device instance $870 m0 *1 202.4,290.3 NMOS
XM$870 \$I3867 WL9 BLB8 VSS NMOS L=1u W=3.4u AS=6.46p AD=10.88p PS=7.2u PD=13.2u
* device instance $871 m0 *1 192.8,329.1 PMOS
XM$871 \$I3868 \$I3869 VDD VDD PMOS L=1u W=3.4u AS=10.88p AD=6.46p PS=13.2u
+ PD=7.2u
* device instance $872 m0 *1 197.6,329.1 PMOS
XM$872 VDD \$I3868 \$I3869 VDD PMOS L=1u W=3.4u AS=6.46p AD=10.88p PS=7.2u
+ PD=13.2u
* device instance $873 m0 *1 188,349.5 NMOS
XM$873 BL8 WL11 \$I3868 VSS NMOS L=1u W=3.4u AS=10.88p AD=6.46p PS=13.2u PD=7.2u
* device instance $874 m0 *1 192.8,349.5 NMOS
XM$874 \$I3868 \$I3869 VSS VSS NMOS L=1u W=3.4u AS=6.46p AD=6.46p PS=7.2u
+ PD=7.2u
* device instance $875 m0 *1 197.6,349.5 NMOS
XM$875 VSS \$I3868 \$I3869 VSS NMOS L=1u W=3.4u AS=6.46p AD=6.46p PS=7.2u
+ PD=7.2u
* device instance $876 m0 *1 202.4,349.5 NMOS
XM$876 \$I3869 WL11 BLB8 VSS NMOS L=1u W=3.4u AS=6.46p AD=10.88p PS=7.2u
+ PD=13.2u
* device instance $877 m0 *1 192.8,447.5 PMOS
XM$877 \$I3870 \$I3871 VDD VDD PMOS L=1u W=3.4u AS=10.88p AD=6.46p PS=13.2u
+ PD=7.2u
* device instance $878 m0 *1 197.6,447.5 PMOS
XM$878 VDD \$I3870 \$I3871 VDD PMOS L=1u W=3.4u AS=6.46p AD=10.88p PS=7.2u
+ PD=13.2u
* device instance $879 m0 *1 188,467.9 NMOS
XM$879 BL8 WL15 \$I3870 VSS NMOS L=1u W=3.4u AS=10.88p AD=6.46p PS=13.2u PD=7.2u
* device instance $880 m0 *1 192.8,467.9 NMOS
XM$880 \$I3870 \$I3871 VSS VSS NMOS L=1u W=3.4u AS=6.46p AD=6.46p PS=7.2u
+ PD=7.2u
* device instance $881 m0 *1 197.6,467.9 NMOS
XM$881 VSS \$I3870 \$I3871 VSS NMOS L=1u W=3.4u AS=6.46p AD=6.46p PS=7.2u
+ PD=7.2u
* device instance $882 m0 *1 202.4,467.9 NMOS
XM$882 \$I3871 WL15 BLB8 VSS NMOS L=1u W=3.4u AS=6.46p AD=10.88p PS=7.2u
+ PD=13.2u
* device instance $883 m0 *1 192.8,388.3 PMOS
XM$883 \$I3872 \$I3873 VDD VDD PMOS L=1u W=3.4u AS=10.88p AD=6.46p PS=13.2u
+ PD=7.2u
* device instance $884 m0 *1 197.6,388.3 PMOS
XM$884 VDD \$I3872 \$I3873 VDD PMOS L=1u W=3.4u AS=6.46p AD=10.88p PS=7.2u
+ PD=13.2u
* device instance $885 m0 *1 188,408.7 NMOS
XM$885 BL8 WL13 \$I3872 VSS NMOS L=1u W=3.4u AS=10.88p AD=6.46p PS=13.2u PD=7.2u
* device instance $886 m0 *1 192.8,408.7 NMOS
XM$886 \$I3872 \$I3873 VSS VSS NMOS L=1u W=3.4u AS=6.46p AD=6.46p PS=7.2u
+ PD=7.2u
* device instance $887 m0 *1 197.6,408.7 NMOS
XM$887 VSS \$I3872 \$I3873 VSS NMOS L=1u W=3.4u AS=6.46p AD=6.46p PS=7.2u
+ PD=7.2u
* device instance $888 m0 *1 202.4,408.7 NMOS
XM$888 \$I3873 WL13 BLB8 VSS NMOS L=1u W=3.4u AS=6.46p AD=10.88p PS=7.2u
+ PD=13.2u
* device instance $889 m0 *1 30.4,329.1 PMOS
XM$889 \$I3874 \$I3875 VDD VDD PMOS L=1u W=3.4u AS=10.88p AD=6.46p PS=13.2u
+ PD=7.2u
* device instance $890 m0 *1 35.2,329.1 PMOS
XM$890 VDD \$I3874 \$I3875 VDD PMOS L=1u W=3.4u AS=6.46p AD=10.88p PS=7.2u
+ PD=13.2u
* device instance $891 m0 *1 25.6,349.5 NMOS
XM$891 BL1 WL11 \$I3874 VSS NMOS L=1u W=3.4u AS=10.88p AD=6.46p PS=13.2u PD=7.2u
* device instance $892 m0 *1 30.4,349.5 NMOS
XM$892 \$I3874 \$I3875 VSS VSS NMOS L=1u W=3.4u AS=6.46p AD=6.46p PS=7.2u
+ PD=7.2u
* device instance $893 m0 *1 35.2,349.5 NMOS
XM$893 VSS \$I3874 \$I3875 VSS NMOS L=1u W=3.4u AS=6.46p AD=6.46p PS=7.2u
+ PD=7.2u
* device instance $894 m0 *1 40,349.5 NMOS
XM$894 \$I3875 WL11 BLB1 VSS NMOS L=1u W=3.4u AS=6.46p AD=10.88p PS=7.2u
+ PD=13.2u
* device instance $895 m0 *1 747.6,329.1 PMOS
XM$895 \$I3876 \$I3877 VDD VDD PMOS L=1u W=3.4u AS=10.88p AD=6.46p PS=13.2u
+ PD=7.2u
* device instance $896 m0 *1 752.4,329.1 PMOS
XM$896 VDD \$I3876 \$I3877 VDD PMOS L=1u W=3.4u AS=6.46p AD=10.88p PS=7.2u
+ PD=13.2u
* device instance $897 m0 *1 742.8,349.5 NMOS
XM$897 BL31 WL11 \$I3876 VSS NMOS L=1u W=3.4u AS=10.88p AD=6.46p PS=13.2u
+ PD=7.2u
* device instance $898 m0 *1 747.6,349.5 NMOS
XM$898 \$I3876 \$I3877 VSS VSS NMOS L=1u W=3.4u AS=6.46p AD=6.46p PS=7.2u
+ PD=7.2u
* device instance $899 m0 *1 752.4,349.5 NMOS
XM$899 VSS \$I3876 \$I3877 VSS NMOS L=1u W=3.4u AS=6.46p AD=6.46p PS=7.2u
+ PD=7.2u
* device instance $900 m0 *1 757.2,349.5 NMOS
XM$900 \$I3877 WL11 BLB31 VSS NMOS L=1u W=3.4u AS=6.46p AD=10.88p PS=7.2u
+ PD=13.2u
* device instance $901 m0 *1 192.8,210.7 PMOS
XM$901 \$I3878 \$I3879 VDD VDD PMOS L=1u W=3.4u AS=10.88p AD=6.46p PS=13.2u
+ PD=7.2u
* device instance $902 m0 *1 197.6,210.7 PMOS
XM$902 VDD \$I3878 \$I3879 VDD PMOS L=1u W=3.4u AS=6.46p AD=10.88p PS=7.2u
+ PD=13.2u
* device instance $903 m0 *1 188,231.1 NMOS
XM$903 BL8 WL7 \$I3878 VSS NMOS L=1u W=3.4u AS=10.88p AD=6.46p PS=13.2u PD=7.2u
* device instance $904 m0 *1 192.8,231.1 NMOS
XM$904 \$I3878 \$I3879 VSS VSS NMOS L=1u W=3.4u AS=6.46p AD=6.46p PS=7.2u
+ PD=7.2u
* device instance $905 m0 *1 197.6,231.1 NMOS
XM$905 VSS \$I3878 \$I3879 VSS NMOS L=1u W=3.4u AS=6.46p AD=6.46p PS=7.2u
+ PD=7.2u
* device instance $906 m0 *1 202.4,231.1 NMOS
XM$906 \$I3879 WL7 BLB8 VSS NMOS L=1u W=3.4u AS=6.46p AD=10.88p PS=7.2u PD=13.2u
* device instance $907 m0 *1 724.4,329.1 PMOS
XM$907 \$I3880 \$I3881 VDD VDD PMOS L=1u W=3.4u AS=10.88p AD=6.46p PS=13.2u
+ PD=7.2u
* device instance $908 m0 *1 729.2,329.1 PMOS
XM$908 VDD \$I3880 \$I3881 VDD PMOS L=1u W=3.4u AS=6.46p AD=10.88p PS=7.2u
+ PD=13.2u
* device instance $909 m0 *1 719.6,349.5 NMOS
XM$909 BL30 WL11 \$I3880 VSS NMOS L=1u W=3.4u AS=10.88p AD=6.46p PS=13.2u
+ PD=7.2u
* device instance $910 m0 *1 724.4,349.5 NMOS
XM$910 \$I3880 \$I3881 VSS VSS NMOS L=1u W=3.4u AS=6.46p AD=6.46p PS=7.2u
+ PD=7.2u
* device instance $911 m0 *1 729.2,349.5 NMOS
XM$911 VSS \$I3880 \$I3881 VSS NMOS L=1u W=3.4u AS=6.46p AD=6.46p PS=7.2u
+ PD=7.2u
* device instance $912 m0 *1 734,349.5 NMOS
XM$912 \$I3881 WL11 BLB30 VSS NMOS L=1u W=3.4u AS=6.46p AD=10.88p PS=7.2u
+ PD=13.2u
* device instance $913 m0 *1 192.8,33.1 PMOS
XM$913 \$I3882 \$I3883 VDD VDD PMOS L=1u W=3.4u AS=10.88p AD=6.46p PS=13.2u
+ PD=7.2u
* device instance $914 m0 *1 197.6,33.1 PMOS
XM$914 VDD \$I3882 \$I3883 VDD PMOS L=1u W=3.4u AS=6.46p AD=10.88p PS=7.2u
+ PD=13.2u
* device instance $915 m0 *1 188,53.5 NMOS
XM$915 BL8 WL1 \$I3882 VSS NMOS L=1u W=3.4u AS=10.88p AD=6.46p PS=13.2u PD=7.2u
* device instance $916 m0 *1 192.8,53.5 NMOS
XM$916 \$I3882 \$I3883 VSS VSS NMOS L=1u W=3.4u AS=6.46p AD=6.46p PS=7.2u
+ PD=7.2u
* device instance $917 m0 *1 197.6,53.5 NMOS
XM$917 VSS \$I3882 \$I3883 VSS NMOS L=1u W=3.4u AS=6.46p AD=6.46p PS=7.2u
+ PD=7.2u
* device instance $918 m0 *1 202.4,53.5 NMOS
XM$918 \$I3883 WL1 BLB8 VSS NMOS L=1u W=3.4u AS=6.46p AD=10.88p PS=7.2u PD=13.2u
* device instance $919 m0 *1 701.2,329.1 PMOS
XM$919 \$I3884 \$I3885 VDD VDD PMOS L=1u W=3.4u AS=10.88p AD=6.46p PS=13.2u
+ PD=7.2u
* device instance $920 m0 *1 706,329.1 PMOS
XM$920 VDD \$I3884 \$I3885 VDD PMOS L=1u W=3.4u AS=6.46p AD=10.88p PS=7.2u
+ PD=13.2u
* device instance $921 m0 *1 696.4,349.5 NMOS
XM$921 BL29 WL11 \$I3884 VSS NMOS L=1u W=3.4u AS=10.88p AD=6.46p PS=13.2u
+ PD=7.2u
* device instance $922 m0 *1 701.2,349.5 NMOS
XM$922 \$I3884 \$I3885 VSS VSS NMOS L=1u W=3.4u AS=6.46p AD=6.46p PS=7.2u
+ PD=7.2u
* device instance $923 m0 *1 706,349.5 NMOS
XM$923 VSS \$I3884 \$I3885 VSS NMOS L=1u W=3.4u AS=6.46p AD=6.46p PS=7.2u
+ PD=7.2u
* device instance $924 m0 *1 710.8,349.5 NMOS
XM$924 \$I3885 WL11 BLB29 VSS NMOS L=1u W=3.4u AS=6.46p AD=10.88p PS=7.2u
+ PD=13.2u
* device instance $925 m0 *1 192.8,92.3 PMOS
XM$925 \$I3886 \$I3887 VDD VDD PMOS L=1u W=3.4u AS=10.88p AD=6.46p PS=13.2u
+ PD=7.2u
* device instance $926 m0 *1 197.6,92.3 PMOS
XM$926 VDD \$I3886 \$I3887 VDD PMOS L=1u W=3.4u AS=6.46p AD=10.88p PS=7.2u
+ PD=13.2u
* device instance $927 m0 *1 188,112.7 NMOS
XM$927 BL8 WL3 \$I3886 VSS NMOS L=1u W=3.4u AS=10.88p AD=6.46p PS=13.2u PD=7.2u
* device instance $928 m0 *1 192.8,112.7 NMOS
XM$928 \$I3886 \$I3887 VSS VSS NMOS L=1u W=3.4u AS=6.46p AD=6.46p PS=7.2u
+ PD=7.2u
* device instance $929 m0 *1 197.6,112.7 NMOS
XM$929 VSS \$I3886 \$I3887 VSS NMOS L=1u W=3.4u AS=6.46p AD=6.46p PS=7.2u
+ PD=7.2u
* device instance $930 m0 *1 202.4,112.7 NMOS
XM$930 \$I3887 WL3 BLB8 VSS NMOS L=1u W=3.4u AS=6.46p AD=10.88p PS=7.2u PD=13.2u
* device instance $931 m0 *1 678,329.1 PMOS
XM$931 \$I3888 \$I3889 VDD VDD PMOS L=1u W=3.4u AS=10.88p AD=6.46p PS=13.2u
+ PD=7.2u
* device instance $932 m0 *1 682.8,329.1 PMOS
XM$932 VDD \$I3888 \$I3889 VDD PMOS L=1u W=3.4u AS=6.46p AD=10.88p PS=7.2u
+ PD=13.2u
* device instance $933 m0 *1 673.2,349.5 NMOS
XM$933 BL28 WL11 \$I3888 VSS NMOS L=1u W=3.4u AS=10.88p AD=6.46p PS=13.2u
+ PD=7.2u
* device instance $934 m0 *1 678,349.5 NMOS
XM$934 \$I3888 \$I3889 VSS VSS NMOS L=1u W=3.4u AS=6.46p AD=6.46p PS=7.2u
+ PD=7.2u
* device instance $935 m0 *1 682.8,349.5 NMOS
XM$935 VSS \$I3888 \$I3889 VSS NMOS L=1u W=3.4u AS=6.46p AD=6.46p PS=7.2u
+ PD=7.2u
* device instance $936 m0 *1 687.6,349.5 NMOS
XM$936 \$I3889 WL11 BLB28 VSS NMOS L=1u W=3.4u AS=6.46p AD=10.88p PS=7.2u
+ PD=13.2u
* device instance $937 m0 *1 216,151.5 PMOS
XM$937 \$I3890 \$I3891 VDD VDD PMOS L=1u W=3.4u AS=10.88p AD=6.46p PS=13.2u
+ PD=7.2u
* device instance $938 m0 *1 220.8,151.5 PMOS
XM$938 VDD \$I3890 \$I3891 VDD PMOS L=1u W=3.4u AS=6.46p AD=10.88p PS=7.2u
+ PD=13.2u
* device instance $939 m0 *1 211.2,171.9 NMOS
XM$939 BL9 WL5 \$I3890 VSS NMOS L=1u W=3.4u AS=10.88p AD=6.46p PS=13.2u PD=7.2u
* device instance $940 m0 *1 216,171.9 NMOS
XM$940 \$I3890 \$I3891 VSS VSS NMOS L=1u W=3.4u AS=6.46p AD=6.46p PS=7.2u
+ PD=7.2u
* device instance $941 m0 *1 220.8,171.9 NMOS
XM$941 VSS \$I3890 \$I3891 VSS NMOS L=1u W=3.4u AS=6.46p AD=6.46p PS=7.2u
+ PD=7.2u
* device instance $942 m0 *1 225.6,171.9 NMOS
XM$942 \$I3891 WL5 BLB9 VSS NMOS L=1u W=3.4u AS=6.46p AD=10.88p PS=7.2u PD=13.2u
* device instance $943 m0 *1 192.8,151.5 PMOS
XM$943 \$I3892 \$I3893 VDD VDD PMOS L=1u W=3.4u AS=10.88p AD=6.46p PS=13.2u
+ PD=7.2u
* device instance $944 m0 *1 197.6,151.5 PMOS
XM$944 VDD \$I3892 \$I3893 VDD PMOS L=1u W=3.4u AS=6.46p AD=10.88p PS=7.2u
+ PD=13.2u
* device instance $945 m0 *1 188,171.9 NMOS
XM$945 BL8 WL5 \$I3892 VSS NMOS L=1u W=3.4u AS=10.88p AD=6.46p PS=13.2u PD=7.2u
* device instance $946 m0 *1 192.8,171.9 NMOS
XM$946 \$I3892 \$I3893 VSS VSS NMOS L=1u W=3.4u AS=6.46p AD=6.46p PS=7.2u
+ PD=7.2u
* device instance $947 m0 *1 197.6,171.9 NMOS
XM$947 VSS \$I3892 \$I3893 VSS NMOS L=1u W=3.4u AS=6.46p AD=6.46p PS=7.2u
+ PD=7.2u
* device instance $948 m0 *1 202.4,171.9 NMOS
XM$948 \$I3893 WL5 BLB8 VSS NMOS L=1u W=3.4u AS=6.46p AD=10.88p PS=7.2u PD=13.2u
* device instance $949 m0 *1 53.6,329.1 PMOS
XM$949 \$I3894 \$I3895 VDD VDD PMOS L=1u W=3.4u AS=10.88p AD=6.46p PS=13.2u
+ PD=7.2u
* device instance $950 m0 *1 58.4,329.1 PMOS
XM$950 VDD \$I3894 \$I3895 VDD PMOS L=1u W=3.4u AS=6.46p AD=10.88p PS=7.2u
+ PD=13.2u
* device instance $951 m0 *1 48.8,349.5 NMOS
XM$951 BL2 WL11 \$I3894 VSS NMOS L=1u W=3.4u AS=10.88p AD=6.46p PS=13.2u PD=7.2u
* device instance $952 m0 *1 53.6,349.5 NMOS
XM$952 \$I3894 \$I3895 VSS VSS NMOS L=1u W=3.4u AS=6.46p AD=6.46p PS=7.2u
+ PD=7.2u
* device instance $953 m0 *1 58.4,349.5 NMOS
XM$953 VSS \$I3894 \$I3895 VSS NMOS L=1u W=3.4u AS=6.46p AD=6.46p PS=7.2u
+ PD=7.2u
* device instance $954 m0 *1 63.2,349.5 NMOS
XM$954 \$I3895 WL11 BLB2 VSS NMOS L=1u W=3.4u AS=6.46p AD=10.88p PS=7.2u
+ PD=13.2u
* device instance $955 m0 *1 76.8,329.1 PMOS
XM$955 \$I3896 \$I3897 VDD VDD PMOS L=1u W=3.4u AS=10.88p AD=6.46p PS=13.2u
+ PD=7.2u
* device instance $956 m0 *1 81.6,329.1 PMOS
XM$956 VDD \$I3896 \$I3897 VDD PMOS L=1u W=3.4u AS=6.46p AD=10.88p PS=7.2u
+ PD=13.2u
* device instance $957 m0 *1 72,349.5 NMOS
XM$957 BL3 WL11 \$I3896 VSS NMOS L=1u W=3.4u AS=10.88p AD=6.46p PS=13.2u PD=7.2u
* device instance $958 m0 *1 76.8,349.5 NMOS
XM$958 \$I3896 \$I3897 VSS VSS NMOS L=1u W=3.4u AS=6.46p AD=6.46p PS=7.2u
+ PD=7.2u
* device instance $959 m0 *1 81.6,349.5 NMOS
XM$959 VSS \$I3896 \$I3897 VSS NMOS L=1u W=3.4u AS=6.46p AD=6.46p PS=7.2u
+ PD=7.2u
* device instance $960 m0 *1 86.4,349.5 NMOS
XM$960 \$I3897 WL11 BLB3 VSS NMOS L=1u W=3.4u AS=6.46p AD=10.88p PS=7.2u
+ PD=13.2u
* device instance $961 m0 *1 100,329.1 PMOS
XM$961 \$I3898 \$I3899 VDD VDD PMOS L=1u W=3.4u AS=10.88p AD=6.46p PS=13.2u
+ PD=7.2u
* device instance $962 m0 *1 104.8,329.1 PMOS
XM$962 VDD \$I3898 \$I3899 VDD PMOS L=1u W=3.4u AS=6.46p AD=10.88p PS=7.2u
+ PD=13.2u
* device instance $963 m0 *1 95.2,349.5 NMOS
XM$963 BL4 WL11 \$I3898 VSS NMOS L=1u W=3.4u AS=10.88p AD=6.46p PS=13.2u PD=7.2u
* device instance $964 m0 *1 100,349.5 NMOS
XM$964 \$I3898 \$I3899 VSS VSS NMOS L=1u W=3.4u AS=6.46p AD=6.46p PS=7.2u
+ PD=7.2u
* device instance $965 m0 *1 104.8,349.5 NMOS
XM$965 VSS \$I3898 \$I3899 VSS NMOS L=1u W=3.4u AS=6.46p AD=6.46p PS=7.2u
+ PD=7.2u
* device instance $966 m0 *1 109.6,349.5 NMOS
XM$966 \$I3899 WL11 BLB4 VSS NMOS L=1u W=3.4u AS=6.46p AD=10.88p PS=7.2u
+ PD=13.2u
* device instance $967 m0 *1 123.2,329.1 PMOS
XM$967 \$I3900 \$I3901 VDD VDD PMOS L=1u W=3.4u AS=10.88p AD=6.46p PS=13.2u
+ PD=7.2u
* device instance $968 m0 *1 128,329.1 PMOS
XM$968 VDD \$I3900 \$I3901 VDD PMOS L=1u W=3.4u AS=6.46p AD=10.88p PS=7.2u
+ PD=13.2u
* device instance $969 m0 *1 118.4,349.5 NMOS
XM$969 BL5 WL11 \$I3900 VSS NMOS L=1u W=3.4u AS=10.88p AD=6.46p PS=13.2u PD=7.2u
* device instance $970 m0 *1 123.2,349.5 NMOS
XM$970 \$I3900 \$I3901 VSS VSS NMOS L=1u W=3.4u AS=6.46p AD=6.46p PS=7.2u
+ PD=7.2u
* device instance $971 m0 *1 128,349.5 NMOS
XM$971 VSS \$I3900 \$I3901 VSS NMOS L=1u W=3.4u AS=6.46p AD=6.46p PS=7.2u
+ PD=7.2u
* device instance $972 m0 *1 132.8,349.5 NMOS
XM$972 \$I3901 WL11 BLB5 VSS NMOS L=1u W=3.4u AS=6.46p AD=10.88p PS=7.2u
+ PD=13.2u
* device instance $973 m0 *1 355.2,388.3 PMOS
XM$973 \$I3902 \$I3903 VDD VDD PMOS L=1u W=3.4u AS=10.88p AD=6.46p PS=13.2u
+ PD=7.2u
* device instance $974 m0 *1 360,388.3 PMOS
XM$974 VDD \$I3902 \$I3903 VDD PMOS L=1u W=3.4u AS=6.46p AD=10.88p PS=7.2u
+ PD=13.2u
* device instance $975 m0 *1 350.4,408.7 NMOS
XM$975 BL15 WL13 \$I3902 VSS NMOS L=1u W=3.4u AS=10.88p AD=6.46p PS=13.2u
+ PD=7.2u
* device instance $976 m0 *1 355.2,408.7 NMOS
XM$976 \$I3902 \$I3903 VSS VSS NMOS L=1u W=3.4u AS=6.46p AD=6.46p PS=7.2u
+ PD=7.2u
* device instance $977 m0 *1 360,408.7 NMOS
XM$977 VSS \$I3902 \$I3903 VSS NMOS L=1u W=3.4u AS=6.46p AD=6.46p PS=7.2u
+ PD=7.2u
* device instance $978 m0 *1 364.8,408.7 NMOS
XM$978 \$I3903 WL13 BLB15 VSS NMOS L=1u W=3.4u AS=6.46p AD=10.88p PS=7.2u
+ PD=13.2u
* device instance $979 m0 *1 332,388.3 PMOS
XM$979 \$I3904 \$I3905 VDD VDD PMOS L=1u W=3.4u AS=10.88p AD=6.46p PS=13.2u
+ PD=7.2u
* device instance $980 m0 *1 336.8,388.3 PMOS
XM$980 VDD \$I3904 \$I3905 VDD PMOS L=1u W=3.4u AS=6.46p AD=10.88p PS=7.2u
+ PD=13.2u
* device instance $981 m0 *1 327.2,408.7 NMOS
XM$981 BL14 WL13 \$I3904 VSS NMOS L=1u W=3.4u AS=10.88p AD=6.46p PS=13.2u
+ PD=7.2u
* device instance $982 m0 *1 332,408.7 NMOS
XM$982 \$I3904 \$I3905 VSS VSS NMOS L=1u W=3.4u AS=6.46p AD=6.46p PS=7.2u
+ PD=7.2u
* device instance $983 m0 *1 336.8,408.7 NMOS
XM$983 VSS \$I3904 \$I3905 VSS NMOS L=1u W=3.4u AS=6.46p AD=6.46p PS=7.2u
+ PD=7.2u
* device instance $984 m0 *1 341.6,408.7 NMOS
XM$984 \$I3905 WL13 BLB14 VSS NMOS L=1u W=3.4u AS=6.46p AD=10.88p PS=7.2u
+ PD=13.2u
* device instance $985 m0 *1 308.8,388.3 PMOS
XM$985 \$I3906 \$I3907 VDD VDD PMOS L=1u W=3.4u AS=10.88p AD=6.46p PS=13.2u
+ PD=7.2u
* device instance $986 m0 *1 313.6,388.3 PMOS
XM$986 VDD \$I3906 \$I3907 VDD PMOS L=1u W=3.4u AS=6.46p AD=10.88p PS=7.2u
+ PD=13.2u
* device instance $987 m0 *1 304,408.7 NMOS
XM$987 BL13 WL13 \$I3906 VSS NMOS L=1u W=3.4u AS=10.88p AD=6.46p PS=13.2u
+ PD=7.2u
* device instance $988 m0 *1 308.8,408.7 NMOS
XM$988 \$I3906 \$I3907 VSS VSS NMOS L=1u W=3.4u AS=6.46p AD=6.46p PS=7.2u
+ PD=7.2u
* device instance $989 m0 *1 313.6,408.7 NMOS
XM$989 VSS \$I3906 \$I3907 VSS NMOS L=1u W=3.4u AS=6.46p AD=6.46p PS=7.2u
+ PD=7.2u
* device instance $990 m0 *1 318.4,408.7 NMOS
XM$990 \$I3907 WL13 BLB13 VSS NMOS L=1u W=3.4u AS=6.46p AD=10.88p PS=7.2u
+ PD=13.2u
* device instance $991 m0 *1 285.6,388.3 PMOS
XM$991 \$I3908 \$I3909 VDD VDD PMOS L=1u W=3.4u AS=10.88p AD=6.46p PS=13.2u
+ PD=7.2u
* device instance $992 m0 *1 290.4,388.3 PMOS
XM$992 VDD \$I3908 \$I3909 VDD PMOS L=1u W=3.4u AS=6.46p AD=10.88p PS=7.2u
+ PD=13.2u
* device instance $993 m0 *1 280.8,408.7 NMOS
XM$993 BL12 WL13 \$I3908 VSS NMOS L=1u W=3.4u AS=10.88p AD=6.46p PS=13.2u
+ PD=7.2u
* device instance $994 m0 *1 285.6,408.7 NMOS
XM$994 \$I3908 \$I3909 VSS VSS NMOS L=1u W=3.4u AS=6.46p AD=6.46p PS=7.2u
+ PD=7.2u
* device instance $995 m0 *1 290.4,408.7 NMOS
XM$995 VSS \$I3908 \$I3909 VSS NMOS L=1u W=3.4u AS=6.46p AD=6.46p PS=7.2u
+ PD=7.2u
* device instance $996 m0 *1 295.2,408.7 NMOS
XM$996 \$I3909 WL13 BLB12 VSS NMOS L=1u W=3.4u AS=6.46p AD=10.88p PS=7.2u
+ PD=13.2u
* device instance $997 m0 *1 355.2,329.1 PMOS
XM$997 \$I3910 \$I3911 VDD VDD PMOS L=1u W=3.4u AS=10.88p AD=6.46p PS=13.2u
+ PD=7.2u
* device instance $998 m0 *1 360,329.1 PMOS
XM$998 VDD \$I3910 \$I3911 VDD PMOS L=1u W=3.4u AS=6.46p AD=10.88p PS=7.2u
+ PD=13.2u
* device instance $999 m0 *1 350.4,349.5 NMOS
XM$999 BL15 WL11 \$I3910 VSS NMOS L=1u W=3.4u AS=10.88p AD=6.46p PS=13.2u
+ PD=7.2u
* device instance $1000 m0 *1 355.2,349.5 NMOS
XM$1000 \$I3910 \$I3911 VSS VSS NMOS L=1u W=3.4u AS=6.46p AD=6.46p PS=7.2u
+ PD=7.2u
* device instance $1001 m0 *1 360,349.5 NMOS
XM$1001 VSS \$I3910 \$I3911 VSS NMOS L=1u W=3.4u AS=6.46p AD=6.46p PS=7.2u
+ PD=7.2u
* device instance $1002 m0 *1 364.8,349.5 NMOS
XM$1002 \$I3911 WL11 BLB15 VSS NMOS L=1u W=3.4u AS=6.46p AD=10.88p PS=7.2u
+ PD=13.2u
* device instance $1003 m0 *1 239.2,269.9 PMOS
XM$1003 \$I3912 \$I3913 VDD VDD PMOS L=1u W=3.4u AS=10.88p AD=6.46p PS=13.2u
+ PD=7.2u
* device instance $1004 m0 *1 244,269.9 PMOS
XM$1004 VDD \$I3912 \$I3913 VDD PMOS L=1u W=3.4u AS=6.46p AD=10.88p PS=7.2u
+ PD=13.2u
* device instance $1005 m0 *1 234.4,290.3 NMOS
XM$1005 BL10 WL9 \$I3912 VSS NMOS L=1u W=3.4u AS=10.88p AD=6.46p PS=13.2u
+ PD=7.2u
* device instance $1006 m0 *1 239.2,290.3 NMOS
XM$1006 \$I3912 \$I3913 VSS VSS NMOS L=1u W=3.4u AS=6.46p AD=6.46p PS=7.2u
+ PD=7.2u
* device instance $1007 m0 *1 244,290.3 NMOS
XM$1007 VSS \$I3912 \$I3913 VSS NMOS L=1u W=3.4u AS=6.46p AD=6.46p PS=7.2u
+ PD=7.2u
* device instance $1008 m0 *1 248.8,290.3 NMOS
XM$1008 \$I3913 WL9 BLB10 VSS NMOS L=1u W=3.4u AS=6.46p AD=10.88p PS=7.2u
+ PD=13.2u
* device instance $1009 m0 *1 262.4,269.9 PMOS
XM$1009 \$I3914 \$I3915 VDD VDD PMOS L=1u W=3.4u AS=10.88p AD=6.46p PS=13.2u
+ PD=7.2u
* device instance $1010 m0 *1 267.2,269.9 PMOS
XM$1010 VDD \$I3914 \$I3915 VDD PMOS L=1u W=3.4u AS=6.46p AD=10.88p PS=7.2u
+ PD=13.2u
* device instance $1011 m0 *1 257.6,290.3 NMOS
XM$1011 BL11 WL9 \$I3914 VSS NMOS L=1u W=3.4u AS=10.88p AD=6.46p PS=13.2u
+ PD=7.2u
* device instance $1012 m0 *1 262.4,290.3 NMOS
XM$1012 \$I3914 \$I3915 VSS VSS NMOS L=1u W=3.4u AS=6.46p AD=6.46p PS=7.2u
+ PD=7.2u
* device instance $1013 m0 *1 267.2,290.3 NMOS
XM$1013 VSS \$I3914 \$I3915 VSS NMOS L=1u W=3.4u AS=6.46p AD=6.46p PS=7.2u
+ PD=7.2u
* device instance $1014 m0 *1 272,290.3 NMOS
XM$1014 \$I3915 WL9 BLB11 VSS NMOS L=1u W=3.4u AS=6.46p AD=10.88p PS=7.2u
+ PD=13.2u
* device instance $1015 m0 *1 285.6,269.9 PMOS
XM$1015 \$I3916 \$I3917 VDD VDD PMOS L=1u W=3.4u AS=10.88p AD=6.46p PS=13.2u
+ PD=7.2u
* device instance $1016 m0 *1 290.4,269.9 PMOS
XM$1016 VDD \$I3916 \$I3917 VDD PMOS L=1u W=3.4u AS=6.46p AD=10.88p PS=7.2u
+ PD=13.2u
* device instance $1017 m0 *1 280.8,290.3 NMOS
XM$1017 BL12 WL9 \$I3916 VSS NMOS L=1u W=3.4u AS=10.88p AD=6.46p PS=13.2u
+ PD=7.2u
* device instance $1018 m0 *1 285.6,290.3 NMOS
XM$1018 \$I3916 \$I3917 VSS VSS NMOS L=1u W=3.4u AS=6.46p AD=6.46p PS=7.2u
+ PD=7.2u
* device instance $1019 m0 *1 290.4,290.3 NMOS
XM$1019 VSS \$I3916 \$I3917 VSS NMOS L=1u W=3.4u AS=6.46p AD=6.46p PS=7.2u
+ PD=7.2u
* device instance $1020 m0 *1 295.2,290.3 NMOS
XM$1020 \$I3917 WL9 BLB12 VSS NMOS L=1u W=3.4u AS=6.46p AD=10.88p PS=7.2u
+ PD=13.2u
* device instance $1021 m0 *1 216,329.1 PMOS
XM$1021 \$I3918 \$I3919 VDD VDD PMOS L=1u W=3.4u AS=10.88p AD=6.46p PS=13.2u
+ PD=7.2u
* device instance $1022 m0 *1 220.8,329.1 PMOS
XM$1022 VDD \$I3918 \$I3919 VDD PMOS L=1u W=3.4u AS=6.46p AD=10.88p PS=7.2u
+ PD=13.2u
* device instance $1023 m0 *1 211.2,349.5 NMOS
XM$1023 BL9 WL11 \$I3918 VSS NMOS L=1u W=3.4u AS=10.88p AD=6.46p PS=13.2u
+ PD=7.2u
* device instance $1024 m0 *1 216,349.5 NMOS
XM$1024 \$I3918 \$I3919 VSS VSS NMOS L=1u W=3.4u AS=6.46p AD=6.46p PS=7.2u
+ PD=7.2u
* device instance $1025 m0 *1 220.8,349.5 NMOS
XM$1025 VSS \$I3918 \$I3919 VSS NMOS L=1u W=3.4u AS=6.46p AD=6.46p PS=7.2u
+ PD=7.2u
* device instance $1026 m0 *1 225.6,349.5 NMOS
XM$1026 \$I3919 WL11 BLB9 VSS NMOS L=1u W=3.4u AS=6.46p AD=10.88p PS=7.2u
+ PD=13.2u
* device instance $1027 m0 *1 239.2,329.1 PMOS
XM$1027 \$I3920 \$I3921 VDD VDD PMOS L=1u W=3.4u AS=10.88p AD=6.46p PS=13.2u
+ PD=7.2u
* device instance $1028 m0 *1 244,329.1 PMOS
XM$1028 VDD \$I3920 \$I3921 VDD PMOS L=1u W=3.4u AS=6.46p AD=10.88p PS=7.2u
+ PD=13.2u
* device instance $1029 m0 *1 234.4,349.5 NMOS
XM$1029 BL10 WL11 \$I3920 VSS NMOS L=1u W=3.4u AS=10.88p AD=6.46p PS=13.2u
+ PD=7.2u
* device instance $1030 m0 *1 239.2,349.5 NMOS
XM$1030 \$I3920 \$I3921 VSS VSS NMOS L=1u W=3.4u AS=6.46p AD=6.46p PS=7.2u
+ PD=7.2u
* device instance $1031 m0 *1 244,349.5 NMOS
XM$1031 VSS \$I3920 \$I3921 VSS NMOS L=1u W=3.4u AS=6.46p AD=6.46p PS=7.2u
+ PD=7.2u
* device instance $1032 m0 *1 248.8,349.5 NMOS
XM$1032 \$I3921 WL11 BLB10 VSS NMOS L=1u W=3.4u AS=6.46p AD=10.88p PS=7.2u
+ PD=13.2u
* device instance $1033 m0 *1 262.4,329.1 PMOS
XM$1033 \$I3922 \$I3923 VDD VDD PMOS L=1u W=3.4u AS=10.88p AD=6.46p PS=13.2u
+ PD=7.2u
* device instance $1034 m0 *1 267.2,329.1 PMOS
XM$1034 VDD \$I3922 \$I3923 VDD PMOS L=1u W=3.4u AS=6.46p AD=10.88p PS=7.2u
+ PD=13.2u
* device instance $1035 m0 *1 257.6,349.5 NMOS
XM$1035 BL11 WL11 \$I3922 VSS NMOS L=1u W=3.4u AS=10.88p AD=6.46p PS=13.2u
+ PD=7.2u
* device instance $1036 m0 *1 262.4,349.5 NMOS
XM$1036 \$I3922 \$I3923 VSS VSS NMOS L=1u W=3.4u AS=6.46p AD=6.46p PS=7.2u
+ PD=7.2u
* device instance $1037 m0 *1 267.2,349.5 NMOS
XM$1037 VSS \$I3922 \$I3923 VSS NMOS L=1u W=3.4u AS=6.46p AD=6.46p PS=7.2u
+ PD=7.2u
* device instance $1038 m0 *1 272,349.5 NMOS
XM$1038 \$I3923 WL11 BLB11 VSS NMOS L=1u W=3.4u AS=6.46p AD=10.88p PS=7.2u
+ PD=13.2u
* device instance $1039 m0 *1 285.6,329.1 PMOS
XM$1039 \$I3924 \$I3925 VDD VDD PMOS L=1u W=3.4u AS=10.88p AD=6.46p PS=13.2u
+ PD=7.2u
* device instance $1040 m0 *1 290.4,329.1 PMOS
XM$1040 VDD \$I3924 \$I3925 VDD PMOS L=1u W=3.4u AS=6.46p AD=10.88p PS=7.2u
+ PD=13.2u
* device instance $1041 m0 *1 280.8,349.5 NMOS
XM$1041 BL12 WL11 \$I3924 VSS NMOS L=1u W=3.4u AS=10.88p AD=6.46p PS=13.2u
+ PD=7.2u
* device instance $1042 m0 *1 285.6,349.5 NMOS
XM$1042 \$I3924 \$I3925 VSS VSS NMOS L=1u W=3.4u AS=6.46p AD=6.46p PS=7.2u
+ PD=7.2u
* device instance $1043 m0 *1 290.4,349.5 NMOS
XM$1043 VSS \$I3924 \$I3925 VSS NMOS L=1u W=3.4u AS=6.46p AD=6.46p PS=7.2u
+ PD=7.2u
* device instance $1044 m0 *1 295.2,349.5 NMOS
XM$1044 \$I3925 WL11 BLB12 VSS NMOS L=1u W=3.4u AS=6.46p AD=10.88p PS=7.2u
+ PD=13.2u
* device instance $1045 m0 *1 308.8,329.1 PMOS
XM$1045 \$I3926 \$I3927 VDD VDD PMOS L=1u W=3.4u AS=10.88p AD=6.46p PS=13.2u
+ PD=7.2u
* device instance $1046 m0 *1 313.6,329.1 PMOS
XM$1046 VDD \$I3926 \$I3927 VDD PMOS L=1u W=3.4u AS=6.46p AD=10.88p PS=7.2u
+ PD=13.2u
* device instance $1047 m0 *1 304,349.5 NMOS
XM$1047 BL13 WL11 \$I3926 VSS NMOS L=1u W=3.4u AS=10.88p AD=6.46p PS=13.2u
+ PD=7.2u
* device instance $1048 m0 *1 308.8,349.5 NMOS
XM$1048 \$I3926 \$I3927 VSS VSS NMOS L=1u W=3.4u AS=6.46p AD=6.46p PS=7.2u
+ PD=7.2u
* device instance $1049 m0 *1 313.6,349.5 NMOS
XM$1049 VSS \$I3926 \$I3927 VSS NMOS L=1u W=3.4u AS=6.46p AD=6.46p PS=7.2u
+ PD=7.2u
* device instance $1050 m0 *1 318.4,349.5 NMOS
XM$1050 \$I3927 WL11 BLB13 VSS NMOS L=1u W=3.4u AS=6.46p AD=10.88p PS=7.2u
+ PD=13.2u
* device instance $1051 m0 *1 332,329.1 PMOS
XM$1051 \$I3928 \$I3929 VDD VDD PMOS L=1u W=3.4u AS=10.88p AD=6.46p PS=13.2u
+ PD=7.2u
* device instance $1052 m0 *1 336.8,329.1 PMOS
XM$1052 VDD \$I3928 \$I3929 VDD PMOS L=1u W=3.4u AS=6.46p AD=10.88p PS=7.2u
+ PD=13.2u
* device instance $1053 m0 *1 327.2,349.5 NMOS
XM$1053 BL14 WL11 \$I3928 VSS NMOS L=1u W=3.4u AS=10.88p AD=6.46p PS=13.2u
+ PD=7.2u
* device instance $1054 m0 *1 332,349.5 NMOS
XM$1054 \$I3928 \$I3929 VSS VSS NMOS L=1u W=3.4u AS=6.46p AD=6.46p PS=7.2u
+ PD=7.2u
* device instance $1055 m0 *1 336.8,349.5 NMOS
XM$1055 VSS \$I3928 \$I3929 VSS NMOS L=1u W=3.4u AS=6.46p AD=6.46p PS=7.2u
+ PD=7.2u
* device instance $1056 m0 *1 341.6,349.5 NMOS
XM$1056 \$I3929 WL11 BLB14 VSS NMOS L=1u W=3.4u AS=6.46p AD=10.88p PS=7.2u
+ PD=13.2u
* device instance $1057 m0 *1 216,269.9 PMOS
XM$1057 \$I3930 \$I3931 VDD VDD PMOS L=1u W=3.4u AS=10.88p AD=6.46p PS=13.2u
+ PD=7.2u
* device instance $1058 m0 *1 220.8,269.9 PMOS
XM$1058 VDD \$I3930 \$I3931 VDD PMOS L=1u W=3.4u AS=6.46p AD=10.88p PS=7.2u
+ PD=13.2u
* device instance $1059 m0 *1 211.2,290.3 NMOS
XM$1059 BL9 WL9 \$I3930 VSS NMOS L=1u W=3.4u AS=10.88p AD=6.46p PS=13.2u PD=7.2u
* device instance $1060 m0 *1 216,290.3 NMOS
XM$1060 \$I3930 \$I3931 VSS VSS NMOS L=1u W=3.4u AS=6.46p AD=6.46p PS=7.2u
+ PD=7.2u
* device instance $1061 m0 *1 220.8,290.3 NMOS
XM$1061 VSS \$I3930 \$I3931 VSS NMOS L=1u W=3.4u AS=6.46p AD=6.46p PS=7.2u
+ PD=7.2u
* device instance $1062 m0 *1 225.6,290.3 NMOS
XM$1062 \$I3931 WL9 BLB9 VSS NMOS L=1u W=3.4u AS=6.46p AD=10.88p PS=7.2u
+ PD=13.2u
* device instance $1063 m0 *1 585.2,388.3 PMOS
XM$1063 \$I3932 \$I3933 VDD VDD PMOS L=1u W=3.4u AS=10.88p AD=6.46p PS=13.2u
+ PD=7.2u
* device instance $1064 m0 *1 590,388.3 PMOS
XM$1064 VDD \$I3932 \$I3933 VDD PMOS L=1u W=3.4u AS=6.46p AD=10.88p PS=7.2u
+ PD=13.2u
* device instance $1065 m0 *1 580.4,408.7 NMOS
XM$1065 BL24 WL13 \$I3932 VSS NMOS L=1u W=3.4u AS=10.88p AD=6.46p PS=13.2u
+ PD=7.2u
* device instance $1066 m0 *1 585.2,408.7 NMOS
XM$1066 \$I3932 \$I3933 VSS VSS NMOS L=1u W=3.4u AS=6.46p AD=6.46p PS=7.2u
+ PD=7.2u
* device instance $1067 m0 *1 590,408.7 NMOS
XM$1067 VSS \$I3932 \$I3933 VSS NMOS L=1u W=3.4u AS=6.46p AD=6.46p PS=7.2u
+ PD=7.2u
* device instance $1068 m0 *1 594.8,408.7 NMOS
XM$1068 \$I3933 WL13 BLB24 VSS NMOS L=1u W=3.4u AS=6.46p AD=10.88p PS=7.2u
+ PD=13.2u
* device instance $1069 m0 *1 399.6,151.5 PMOS
XM$1069 \$I3934 \$I3935 VDD VDD PMOS L=1u W=3.4u AS=10.88p AD=6.46p PS=13.2u
+ PD=7.2u
* device instance $1070 m0 *1 404.4,151.5 PMOS
XM$1070 VDD \$I3934 \$I3935 VDD PMOS L=1u W=3.4u AS=6.46p AD=10.88p PS=7.2u
+ PD=13.2u
* device instance $1071 m0 *1 394.8,171.9 NMOS
XM$1071 BL16 WL5 \$I3934 VSS NMOS L=1u W=3.4u AS=10.88p AD=6.46p PS=13.2u
+ PD=7.2u
* device instance $1072 m0 *1 399.6,171.9 NMOS
XM$1072 \$I3934 \$I3935 VSS VSS NMOS L=1u W=3.4u AS=6.46p AD=6.46p PS=7.2u
+ PD=7.2u
* device instance $1073 m0 *1 404.4,171.9 NMOS
XM$1073 VSS \$I3934 \$I3935 VSS NMOS L=1u W=3.4u AS=6.46p AD=6.46p PS=7.2u
+ PD=7.2u
* device instance $1074 m0 *1 409.2,171.9 NMOS
XM$1074 \$I3935 WL5 BLB16 VSS NMOS L=1u W=3.4u AS=6.46p AD=10.88p PS=7.2u
+ PD=13.2u
* device instance $1075 m0 *1 422.8,151.5 PMOS
XM$1075 \$I3936 \$I3937 VDD VDD PMOS L=1u W=3.4u AS=10.88p AD=6.46p PS=13.2u
+ PD=7.2u
* device instance $1076 m0 *1 427.6,151.5 PMOS
XM$1076 VDD \$I3936 \$I3937 VDD PMOS L=1u W=3.4u AS=6.46p AD=10.88p PS=7.2u
+ PD=13.2u
* device instance $1077 m0 *1 418,171.9 NMOS
XM$1077 BL17 WL5 \$I3936 VSS NMOS L=1u W=3.4u AS=10.88p AD=6.46p PS=13.2u
+ PD=7.2u
* device instance $1078 m0 *1 422.8,171.9 NMOS
XM$1078 \$I3936 \$I3937 VSS VSS NMOS L=1u W=3.4u AS=6.46p AD=6.46p PS=7.2u
+ PD=7.2u
* device instance $1079 m0 *1 427.6,171.9 NMOS
XM$1079 VSS \$I3936 \$I3937 VSS NMOS L=1u W=3.4u AS=6.46p AD=6.46p PS=7.2u
+ PD=7.2u
* device instance $1080 m0 *1 432.4,171.9 NMOS
XM$1080 \$I3937 WL5 BLB17 VSS NMOS L=1u W=3.4u AS=6.46p AD=10.88p PS=7.2u
+ PD=13.2u
* device instance $1081 m0 *1 446,151.5 PMOS
XM$1081 \$I3938 \$I3939 VDD VDD PMOS L=1u W=3.4u AS=10.88p AD=6.46p PS=13.2u
+ PD=7.2u
* device instance $1082 m0 *1 450.8,151.5 PMOS
XM$1082 VDD \$I3938 \$I3939 VDD PMOS L=1u W=3.4u AS=6.46p AD=10.88p PS=7.2u
+ PD=13.2u
* device instance $1083 m0 *1 441.2,171.9 NMOS
XM$1083 BL18 WL5 \$I3938 VSS NMOS L=1u W=3.4u AS=10.88p AD=6.46p PS=13.2u
+ PD=7.2u
* device instance $1084 m0 *1 446,171.9 NMOS
XM$1084 \$I3938 \$I3939 VSS VSS NMOS L=1u W=3.4u AS=6.46p AD=6.46p PS=7.2u
+ PD=7.2u
* device instance $1085 m0 *1 450.8,171.9 NMOS
XM$1085 VSS \$I3938 \$I3939 VSS NMOS L=1u W=3.4u AS=6.46p AD=6.46p PS=7.2u
+ PD=7.2u
* device instance $1086 m0 *1 455.6,171.9 NMOS
XM$1086 \$I3939 WL5 BLB18 VSS NMOS L=1u W=3.4u AS=6.46p AD=10.88p PS=7.2u
+ PD=13.2u
* device instance $1087 m0 *1 747.6,447.5 PMOS
XM$1087 \$I3940 \$I3941 VDD VDD PMOS L=1u W=3.4u AS=10.88p AD=6.46p PS=13.2u
+ PD=7.2u
* device instance $1088 m0 *1 752.4,447.5 PMOS
XM$1088 VDD \$I3940 \$I3941 VDD PMOS L=1u W=3.4u AS=6.46p AD=10.88p PS=7.2u
+ PD=13.2u
* device instance $1089 m0 *1 742.8,467.9 NMOS
XM$1089 BL31 WL15 \$I3940 VSS NMOS L=1u W=3.4u AS=10.88p AD=6.46p PS=13.2u
+ PD=7.2u
* device instance $1090 m0 *1 747.6,467.9 NMOS
XM$1090 \$I3940 \$I3941 VSS VSS NMOS L=1u W=3.4u AS=6.46p AD=6.46p PS=7.2u
+ PD=7.2u
* device instance $1091 m0 *1 752.4,467.9 NMOS
XM$1091 VSS \$I3940 \$I3941 VSS NMOS L=1u W=3.4u AS=6.46p AD=6.46p PS=7.2u
+ PD=7.2u
* device instance $1092 m0 *1 757.2,467.9 NMOS
XM$1092 \$I3941 WL15 BLB31 VSS NMOS L=1u W=3.4u AS=6.46p AD=10.88p PS=7.2u
+ PD=13.2u
* device instance $1093 m0 *1 469.2,151.5 PMOS
XM$1093 \$I3942 \$I3943 VDD VDD PMOS L=1u W=3.4u AS=10.88p AD=6.46p PS=13.2u
+ PD=7.2u
* device instance $1094 m0 *1 474,151.5 PMOS
XM$1094 VDD \$I3942 \$I3943 VDD PMOS L=1u W=3.4u AS=6.46p AD=10.88p PS=7.2u
+ PD=13.2u
* device instance $1095 m0 *1 464.4,171.9 NMOS
XM$1095 BL19 WL5 \$I3942 VSS NMOS L=1u W=3.4u AS=10.88p AD=6.46p PS=13.2u
+ PD=7.2u
* device instance $1096 m0 *1 469.2,171.9 NMOS
XM$1096 \$I3942 \$I3943 VSS VSS NMOS L=1u W=3.4u AS=6.46p AD=6.46p PS=7.2u
+ PD=7.2u
* device instance $1097 m0 *1 474,171.9 NMOS
XM$1097 VSS \$I3942 \$I3943 VSS NMOS L=1u W=3.4u AS=6.46p AD=6.46p PS=7.2u
+ PD=7.2u
* device instance $1098 m0 *1 478.8,171.9 NMOS
XM$1098 \$I3943 WL5 BLB19 VSS NMOS L=1u W=3.4u AS=6.46p AD=10.88p PS=7.2u
+ PD=13.2u
* device instance $1099 m0 *1 492.4,151.5 PMOS
XM$1099 \$I3944 \$I3945 VDD VDD PMOS L=1u W=3.4u AS=10.88p AD=6.46p PS=13.2u
+ PD=7.2u
* device instance $1100 m0 *1 497.2,151.5 PMOS
XM$1100 VDD \$I3944 \$I3945 VDD PMOS L=1u W=3.4u AS=6.46p AD=10.88p PS=7.2u
+ PD=13.2u
* device instance $1101 m0 *1 487.6,171.9 NMOS
XM$1101 BL20 WL5 \$I3944 VSS NMOS L=1u W=3.4u AS=10.88p AD=6.46p PS=13.2u
+ PD=7.2u
* device instance $1102 m0 *1 492.4,171.9 NMOS
XM$1102 \$I3944 \$I3945 VSS VSS NMOS L=1u W=3.4u AS=6.46p AD=6.46p PS=7.2u
+ PD=7.2u
* device instance $1103 m0 *1 497.2,171.9 NMOS
XM$1103 VSS \$I3944 \$I3945 VSS NMOS L=1u W=3.4u AS=6.46p AD=6.46p PS=7.2u
+ PD=7.2u
* device instance $1104 m0 *1 502,171.9 NMOS
XM$1104 \$I3945 WL5 BLB20 VSS NMOS L=1u W=3.4u AS=6.46p AD=10.88p PS=7.2u
+ PD=13.2u
* device instance $1105 m0 *1 724.4,447.5 PMOS
XM$1105 \$I3946 \$I3947 VDD VDD PMOS L=1u W=3.4u AS=10.88p AD=6.46p PS=13.2u
+ PD=7.2u
* device instance $1106 m0 *1 729.2,447.5 PMOS
XM$1106 VDD \$I3946 \$I3947 VDD PMOS L=1u W=3.4u AS=6.46p AD=10.88p PS=7.2u
+ PD=13.2u
* device instance $1107 m0 *1 719.6,467.9 NMOS
XM$1107 BL30 WL15 \$I3946 VSS NMOS L=1u W=3.4u AS=10.88p AD=6.46p PS=13.2u
+ PD=7.2u
* device instance $1108 m0 *1 724.4,467.9 NMOS
XM$1108 \$I3946 \$I3947 VSS VSS NMOS L=1u W=3.4u AS=6.46p AD=6.46p PS=7.2u
+ PD=7.2u
* device instance $1109 m0 *1 729.2,467.9 NMOS
XM$1109 VSS \$I3946 \$I3947 VSS NMOS L=1u W=3.4u AS=6.46p AD=6.46p PS=7.2u
+ PD=7.2u
* device instance $1110 m0 *1 734,467.9 NMOS
XM$1110 \$I3947 WL15 BLB30 VSS NMOS L=1u W=3.4u AS=6.46p AD=10.88p PS=7.2u
+ PD=13.2u
* device instance $1111 m0 *1 747.6,210.7 PMOS
XM$1111 \$I3948 \$I3949 VDD VDD PMOS L=1u W=3.4u AS=10.88p AD=6.46p PS=13.2u
+ PD=7.2u
* device instance $1112 m0 *1 752.4,210.7 PMOS
XM$1112 VDD \$I3948 \$I3949 VDD PMOS L=1u W=3.4u AS=6.46p AD=10.88p PS=7.2u
+ PD=13.2u
* device instance $1113 m0 *1 742.8,231.1 NMOS
XM$1113 BL31 WL7 \$I3948 VSS NMOS L=1u W=3.4u AS=10.88p AD=6.46p PS=13.2u
+ PD=7.2u
* device instance $1114 m0 *1 747.6,231.1 NMOS
XM$1114 \$I3948 \$I3949 VSS VSS NMOS L=1u W=3.4u AS=6.46p AD=6.46p PS=7.2u
+ PD=7.2u
* device instance $1115 m0 *1 752.4,231.1 NMOS
XM$1115 VSS \$I3948 \$I3949 VSS NMOS L=1u W=3.4u AS=6.46p AD=6.46p PS=7.2u
+ PD=7.2u
* device instance $1116 m0 *1 757.2,231.1 NMOS
XM$1116 \$I3949 WL7 BLB31 VSS NMOS L=1u W=3.4u AS=6.46p AD=10.88p PS=7.2u
+ PD=13.2u
* device instance $1117 m0 *1 422.8,33.1 PMOS
XM$1117 \$I3950 \$I3951 VDD VDD PMOS L=1u W=3.4u AS=10.88p AD=6.46p PS=13.2u
+ PD=7.2u
* device instance $1118 m0 *1 427.6,33.1 PMOS
XM$1118 VDD \$I3950 \$I3951 VDD PMOS L=1u W=3.4u AS=6.46p AD=10.88p PS=7.2u
+ PD=13.2u
* device instance $1119 m0 *1 418,53.5 NMOS
XM$1119 BL17 WL1 \$I3950 VSS NMOS L=1u W=3.4u AS=10.88p AD=6.46p PS=13.2u
+ PD=7.2u
* device instance $1120 m0 *1 422.8,53.5 NMOS
XM$1120 \$I3950 \$I3951 VSS VSS NMOS L=1u W=3.4u AS=6.46p AD=6.46p PS=7.2u
+ PD=7.2u
* device instance $1121 m0 *1 427.6,53.5 NMOS
XM$1121 VSS \$I3950 \$I3951 VSS NMOS L=1u W=3.4u AS=6.46p AD=6.46p PS=7.2u
+ PD=7.2u
* device instance $1122 m0 *1 432.4,53.5 NMOS
XM$1122 \$I3951 WL1 BLB17 VSS NMOS L=1u W=3.4u AS=6.46p AD=10.88p PS=7.2u
+ PD=13.2u
* device instance $1123 m0 *1 446,33.1 PMOS
XM$1123 \$I3952 \$I3953 VDD VDD PMOS L=1u W=3.4u AS=10.88p AD=6.46p PS=13.2u
+ PD=7.2u
* device instance $1124 m0 *1 450.8,33.1 PMOS
XM$1124 VDD \$I3952 \$I3953 VDD PMOS L=1u W=3.4u AS=6.46p AD=10.88p PS=7.2u
+ PD=13.2u
* device instance $1125 m0 *1 441.2,53.5 NMOS
XM$1125 BL18 WL1 \$I3952 VSS NMOS L=1u W=3.4u AS=10.88p AD=6.46p PS=13.2u
+ PD=7.2u
* device instance $1126 m0 *1 446,53.5 NMOS
XM$1126 \$I3952 \$I3953 VSS VSS NMOS L=1u W=3.4u AS=6.46p AD=6.46p PS=7.2u
+ PD=7.2u
* device instance $1127 m0 *1 450.8,53.5 NMOS
XM$1127 VSS \$I3952 \$I3953 VSS NMOS L=1u W=3.4u AS=6.46p AD=6.46p PS=7.2u
+ PD=7.2u
* device instance $1128 m0 *1 455.6,53.5 NMOS
XM$1128 \$I3953 WL1 BLB18 VSS NMOS L=1u W=3.4u AS=6.46p AD=10.88p PS=7.2u
+ PD=13.2u
* device instance $1129 m0 *1 399.6,92.3 PMOS
XM$1129 \$I3954 \$I3955 VDD VDD PMOS L=1u W=3.4u AS=10.88p AD=6.46p PS=13.2u
+ PD=7.2u
* device instance $1130 m0 *1 404.4,92.3 PMOS
XM$1130 VDD \$I3954 \$I3955 VDD PMOS L=1u W=3.4u AS=6.46p AD=10.88p PS=7.2u
+ PD=13.2u
* device instance $1131 m0 *1 394.8,112.7 NMOS
XM$1131 BL16 WL3 \$I3954 VSS NMOS L=1u W=3.4u AS=10.88p AD=6.46p PS=13.2u
+ PD=7.2u
* device instance $1132 m0 *1 399.6,112.7 NMOS
XM$1132 \$I3954 \$I3955 VSS VSS NMOS L=1u W=3.4u AS=6.46p AD=6.46p PS=7.2u
+ PD=7.2u
* device instance $1133 m0 *1 404.4,112.7 NMOS
XM$1133 VSS \$I3954 \$I3955 VSS NMOS L=1u W=3.4u AS=6.46p AD=6.46p PS=7.2u
+ PD=7.2u
* device instance $1134 m0 *1 409.2,112.7 NMOS
XM$1134 \$I3955 WL3 BLB16 VSS NMOS L=1u W=3.4u AS=6.46p AD=10.88p PS=7.2u
+ PD=13.2u
* device instance $1135 m0 *1 422.8,92.3 PMOS
XM$1135 \$I3956 \$I3957 VDD VDD PMOS L=1u W=3.4u AS=10.88p AD=6.46p PS=13.2u
+ PD=7.2u
* device instance $1136 m0 *1 427.6,92.3 PMOS
XM$1136 VDD \$I3956 \$I3957 VDD PMOS L=1u W=3.4u AS=6.46p AD=10.88p PS=7.2u
+ PD=13.2u
* device instance $1137 m0 *1 418,112.7 NMOS
XM$1137 BL17 WL3 \$I3956 VSS NMOS L=1u W=3.4u AS=10.88p AD=6.46p PS=13.2u
+ PD=7.2u
* device instance $1138 m0 *1 422.8,112.7 NMOS
XM$1138 \$I3956 \$I3957 VSS VSS NMOS L=1u W=3.4u AS=6.46p AD=6.46p PS=7.2u
+ PD=7.2u
* device instance $1139 m0 *1 427.6,112.7 NMOS
XM$1139 VSS \$I3956 \$I3957 VSS NMOS L=1u W=3.4u AS=6.46p AD=6.46p PS=7.2u
+ PD=7.2u
* device instance $1140 m0 *1 432.4,112.7 NMOS
XM$1140 \$I3957 WL3 BLB17 VSS NMOS L=1u W=3.4u AS=6.46p AD=10.88p PS=7.2u
+ PD=13.2u
* device instance $1141 m0 *1 446,92.3 PMOS
XM$1141 \$I3958 \$I3959 VDD VDD PMOS L=1u W=3.4u AS=10.88p AD=6.46p PS=13.2u
+ PD=7.2u
* device instance $1142 m0 *1 450.8,92.3 PMOS
XM$1142 VDD \$I3958 \$I3959 VDD PMOS L=1u W=3.4u AS=6.46p AD=10.88p PS=7.2u
+ PD=13.2u
* device instance $1143 m0 *1 441.2,112.7 NMOS
XM$1143 BL18 WL3 \$I3958 VSS NMOS L=1u W=3.4u AS=10.88p AD=6.46p PS=13.2u
+ PD=7.2u
* device instance $1144 m0 *1 446,112.7 NMOS
XM$1144 \$I3958 \$I3959 VSS VSS NMOS L=1u W=3.4u AS=6.46p AD=6.46p PS=7.2u
+ PD=7.2u
* device instance $1145 m0 *1 450.8,112.7 NMOS
XM$1145 VSS \$I3958 \$I3959 VSS NMOS L=1u W=3.4u AS=6.46p AD=6.46p PS=7.2u
+ PD=7.2u
* device instance $1146 m0 *1 455.6,112.7 NMOS
XM$1146 \$I3959 WL3 BLB18 VSS NMOS L=1u W=3.4u AS=6.46p AD=10.88p PS=7.2u
+ PD=13.2u
* device instance $1147 m0 *1 469.2,92.3 PMOS
XM$1147 \$I3960 \$I3961 VDD VDD PMOS L=1u W=3.4u AS=10.88p AD=6.46p PS=13.2u
+ PD=7.2u
* device instance $1148 m0 *1 474,92.3 PMOS
XM$1148 VDD \$I3960 \$I3961 VDD PMOS L=1u W=3.4u AS=6.46p AD=10.88p PS=7.2u
+ PD=13.2u
* device instance $1149 m0 *1 464.4,112.7 NMOS
XM$1149 BL19 WL3 \$I3960 VSS NMOS L=1u W=3.4u AS=10.88p AD=6.46p PS=13.2u
+ PD=7.2u
* device instance $1150 m0 *1 469.2,112.7 NMOS
XM$1150 \$I3960 \$I3961 VSS VSS NMOS L=1u W=3.4u AS=6.46p AD=6.46p PS=7.2u
+ PD=7.2u
* device instance $1151 m0 *1 474,112.7 NMOS
XM$1151 VSS \$I3960 \$I3961 VSS NMOS L=1u W=3.4u AS=6.46p AD=6.46p PS=7.2u
+ PD=7.2u
* device instance $1152 m0 *1 478.8,112.7 NMOS
XM$1152 \$I3961 WL3 BLB19 VSS NMOS L=1u W=3.4u AS=6.46p AD=10.88p PS=7.2u
+ PD=13.2u
* device instance $1153 m0 *1 492.4,92.3 PMOS
XM$1153 \$I3962 \$I3963 VDD VDD PMOS L=1u W=3.4u AS=10.88p AD=6.46p PS=13.2u
+ PD=7.2u
* device instance $1154 m0 *1 497.2,92.3 PMOS
XM$1154 VDD \$I3962 \$I3963 VDD PMOS L=1u W=3.4u AS=6.46p AD=10.88p PS=7.2u
+ PD=13.2u
* device instance $1155 m0 *1 487.6,112.7 NMOS
XM$1155 BL20 WL3 \$I3962 VSS NMOS L=1u W=3.4u AS=10.88p AD=6.46p PS=13.2u
+ PD=7.2u
* device instance $1156 m0 *1 492.4,112.7 NMOS
XM$1156 \$I3962 \$I3963 VSS VSS NMOS L=1u W=3.4u AS=6.46p AD=6.46p PS=7.2u
+ PD=7.2u
* device instance $1157 m0 *1 497.2,112.7 NMOS
XM$1157 VSS \$I3962 \$I3963 VSS NMOS L=1u W=3.4u AS=6.46p AD=6.46p PS=7.2u
+ PD=7.2u
* device instance $1158 m0 *1 502,112.7 NMOS
XM$1158 \$I3963 WL3 BLB20 VSS NMOS L=1u W=3.4u AS=6.46p AD=10.88p PS=7.2u
+ PD=13.2u
* device instance $1159 m0 *1 515.6,92.3 PMOS
XM$1159 \$I3964 \$I3965 VDD VDD PMOS L=1u W=3.4u AS=10.88p AD=6.46p PS=13.2u
+ PD=7.2u
* device instance $1160 m0 *1 520.4,92.3 PMOS
XM$1160 VDD \$I3964 \$I3965 VDD PMOS L=1u W=3.4u AS=6.46p AD=10.88p PS=7.2u
+ PD=13.2u
* device instance $1161 m0 *1 510.8,112.7 NMOS
XM$1161 BL21 WL3 \$I3964 VSS NMOS L=1u W=3.4u AS=10.88p AD=6.46p PS=13.2u
+ PD=7.2u
* device instance $1162 m0 *1 515.6,112.7 NMOS
XM$1162 \$I3964 \$I3965 VSS VSS NMOS L=1u W=3.4u AS=6.46p AD=6.46p PS=7.2u
+ PD=7.2u
* device instance $1163 m0 *1 520.4,112.7 NMOS
XM$1163 VSS \$I3964 \$I3965 VSS NMOS L=1u W=3.4u AS=6.46p AD=6.46p PS=7.2u
+ PD=7.2u
* device instance $1164 m0 *1 525.2,112.7 NMOS
XM$1164 \$I3965 WL3 BLB21 VSS NMOS L=1u W=3.4u AS=6.46p AD=10.88p PS=7.2u
+ PD=13.2u
* device instance $1165 m0 *1 399.6,33.1 PMOS
XM$1165 \$I3966 \$I3967 VDD VDD PMOS L=1u W=3.4u AS=10.88p AD=6.46p PS=13.2u
+ PD=7.2u
* device instance $1166 m0 *1 404.4,33.1 PMOS
XM$1166 VDD \$I3966 \$I3967 VDD PMOS L=1u W=3.4u AS=6.46p AD=10.88p PS=7.2u
+ PD=13.2u
* device instance $1167 m0 *1 394.8,53.5 NMOS
XM$1167 BL16 WL1 \$I3966 VSS NMOS L=1u W=3.4u AS=10.88p AD=6.46p PS=13.2u
+ PD=7.2u
* device instance $1168 m0 *1 399.6,53.5 NMOS
XM$1168 \$I3966 \$I3967 VSS VSS NMOS L=1u W=3.4u AS=6.46p AD=6.46p PS=7.2u
+ PD=7.2u
* device instance $1169 m0 *1 404.4,53.5 NMOS
XM$1169 VSS \$I3966 \$I3967 VSS NMOS L=1u W=3.4u AS=6.46p AD=6.46p PS=7.2u
+ PD=7.2u
* device instance $1170 m0 *1 409.2,53.5 NMOS
XM$1170 \$I3967 WL1 BLB16 VSS NMOS L=1u W=3.4u AS=6.46p AD=10.88p PS=7.2u
+ PD=13.2u
* device instance $1171 m0 *1 399.6,447.5 PMOS
XM$1171 \$I3968 \$I3969 VDD VDD PMOS L=1u W=3.4u AS=10.88p AD=6.46p PS=13.2u
+ PD=7.2u
* device instance $1172 m0 *1 404.4,447.5 PMOS
XM$1172 VDD \$I3968 \$I3969 VDD PMOS L=1u W=3.4u AS=6.46p AD=10.88p PS=7.2u
+ PD=13.2u
* device instance $1173 m0 *1 394.8,467.9 NMOS
XM$1173 BL16 WL15 \$I3968 VSS NMOS L=1u W=3.4u AS=10.88p AD=6.46p PS=13.2u
+ PD=7.2u
* device instance $1174 m0 *1 399.6,467.9 NMOS
XM$1174 \$I3968 \$I3969 VSS VSS NMOS L=1u W=3.4u AS=6.46p AD=6.46p PS=7.2u
+ PD=7.2u
* device instance $1175 m0 *1 404.4,467.9 NMOS
XM$1175 VSS \$I3968 \$I3969 VSS NMOS L=1u W=3.4u AS=6.46p AD=6.46p PS=7.2u
+ PD=7.2u
* device instance $1176 m0 *1 409.2,467.9 NMOS
XM$1176 \$I3969 WL15 BLB16 VSS NMOS L=1u W=3.4u AS=6.46p AD=10.88p PS=7.2u
+ PD=13.2u
* device instance $1177 m0 *1 585.2,151.5 PMOS
XM$1177 \$I3970 \$I3971 VDD VDD PMOS L=1u W=3.4u AS=10.88p AD=6.46p PS=13.2u
+ PD=7.2u
* device instance $1178 m0 *1 590,151.5 PMOS
XM$1178 VDD \$I3970 \$I3971 VDD PMOS L=1u W=3.4u AS=6.46p AD=10.88p PS=7.2u
+ PD=13.2u
* device instance $1179 m0 *1 580.4,171.9 NMOS
XM$1179 BL24 WL5 \$I3970 VSS NMOS L=1u W=3.4u AS=10.88p AD=6.46p PS=13.2u
+ PD=7.2u
* device instance $1180 m0 *1 585.2,171.9 NMOS
XM$1180 \$I3970 \$I3971 VSS VSS NMOS L=1u W=3.4u AS=6.46p AD=6.46p PS=7.2u
+ PD=7.2u
* device instance $1181 m0 *1 590,171.9 NMOS
XM$1181 VSS \$I3970 \$I3971 VSS NMOS L=1u W=3.4u AS=6.46p AD=6.46p PS=7.2u
+ PD=7.2u
* device instance $1182 m0 *1 594.8,171.9 NMOS
XM$1182 \$I3971 WL5 BLB24 VSS NMOS L=1u W=3.4u AS=6.46p AD=10.88p PS=7.2u
+ PD=13.2u
* device instance $1183 m0 *1 608.4,151.5 PMOS
XM$1183 \$I3972 \$I3973 VDD VDD PMOS L=1u W=3.4u AS=10.88p AD=6.46p PS=13.2u
+ PD=7.2u
* device instance $1184 m0 *1 613.2,151.5 PMOS
XM$1184 VDD \$I3972 \$I3973 VDD PMOS L=1u W=3.4u AS=6.46p AD=10.88p PS=7.2u
+ PD=13.2u
* device instance $1185 m0 *1 603.6,171.9 NMOS
XM$1185 BL25 WL5 \$I3972 VSS NMOS L=1u W=3.4u AS=10.88p AD=6.46p PS=13.2u
+ PD=7.2u
* device instance $1186 m0 *1 608.4,171.9 NMOS
XM$1186 \$I3972 \$I3973 VSS VSS NMOS L=1u W=3.4u AS=6.46p AD=6.46p PS=7.2u
+ PD=7.2u
* device instance $1187 m0 *1 613.2,171.9 NMOS
XM$1187 VSS \$I3972 \$I3973 VSS NMOS L=1u W=3.4u AS=6.46p AD=6.46p PS=7.2u
+ PD=7.2u
* device instance $1188 m0 *1 618,171.9 NMOS
XM$1188 \$I3973 WL5 BLB25 VSS NMOS L=1u W=3.4u AS=6.46p AD=10.88p PS=7.2u
+ PD=13.2u
* device instance $1189 m0 *1 631.6,151.5 PMOS
XM$1189 \$I3974 \$I3975 VDD VDD PMOS L=1u W=3.4u AS=10.88p AD=6.46p PS=13.2u
+ PD=7.2u
* device instance $1190 m0 *1 636.4,151.5 PMOS
XM$1190 VDD \$I3974 \$I3975 VDD PMOS L=1u W=3.4u AS=6.46p AD=10.88p PS=7.2u
+ PD=13.2u
* device instance $1191 m0 *1 626.8,171.9 NMOS
XM$1191 BL26 WL5 \$I3974 VSS NMOS L=1u W=3.4u AS=10.88p AD=6.46p PS=13.2u
+ PD=7.2u
* device instance $1192 m0 *1 631.6,171.9 NMOS
XM$1192 \$I3974 \$I3975 VSS VSS NMOS L=1u W=3.4u AS=6.46p AD=6.46p PS=7.2u
+ PD=7.2u
* device instance $1193 m0 *1 636.4,171.9 NMOS
XM$1193 VSS \$I3974 \$I3975 VSS NMOS L=1u W=3.4u AS=6.46p AD=6.46p PS=7.2u
+ PD=7.2u
* device instance $1194 m0 *1 641.2,171.9 NMOS
XM$1194 \$I3975 WL5 BLB26 VSS NMOS L=1u W=3.4u AS=6.46p AD=10.88p PS=7.2u
+ PD=13.2u
* device instance $1195 m0 *1 654.8,151.5 PMOS
XM$1195 \$I3976 \$I3977 VDD VDD PMOS L=1u W=3.4u AS=10.88p AD=6.46p PS=13.2u
+ PD=7.2u
* device instance $1196 m0 *1 659.6,151.5 PMOS
XM$1196 VDD \$I3976 \$I3977 VDD PMOS L=1u W=3.4u AS=6.46p AD=10.88p PS=7.2u
+ PD=13.2u
* device instance $1197 m0 *1 650,171.9 NMOS
XM$1197 BL27 WL5 \$I3976 VSS NMOS L=1u W=3.4u AS=10.88p AD=6.46p PS=13.2u
+ PD=7.2u
* device instance $1198 m0 *1 654.8,171.9 NMOS
XM$1198 \$I3976 \$I3977 VSS VSS NMOS L=1u W=3.4u AS=6.46p AD=6.46p PS=7.2u
+ PD=7.2u
* device instance $1199 m0 *1 659.6,171.9 NMOS
XM$1199 VSS \$I3976 \$I3977 VSS NMOS L=1u W=3.4u AS=6.46p AD=6.46p PS=7.2u
+ PD=7.2u
* device instance $1200 m0 *1 664.4,171.9 NMOS
XM$1200 \$I3977 WL5 BLB27 VSS NMOS L=1u W=3.4u AS=6.46p AD=10.88p PS=7.2u
+ PD=13.2u
* device instance $1201 m0 *1 515.6,151.5 PMOS
XM$1201 \$I3978 \$I3979 VDD VDD PMOS L=1u W=3.4u AS=10.88p AD=6.46p PS=13.2u
+ PD=7.2u
* device instance $1202 m0 *1 520.4,151.5 PMOS
XM$1202 VDD \$I3978 \$I3979 VDD PMOS L=1u W=3.4u AS=6.46p AD=10.88p PS=7.2u
+ PD=13.2u
* device instance $1203 m0 *1 510.8,171.9 NMOS
XM$1203 BL21 WL5 \$I3978 VSS NMOS L=1u W=3.4u AS=10.88p AD=6.46p PS=13.2u
+ PD=7.2u
* device instance $1204 m0 *1 515.6,171.9 NMOS
XM$1204 \$I3978 \$I3979 VSS VSS NMOS L=1u W=3.4u AS=6.46p AD=6.46p PS=7.2u
+ PD=7.2u
* device instance $1205 m0 *1 520.4,171.9 NMOS
XM$1205 VSS \$I3978 \$I3979 VSS NMOS L=1u W=3.4u AS=6.46p AD=6.46p PS=7.2u
+ PD=7.2u
* device instance $1206 m0 *1 525.2,171.9 NMOS
XM$1206 \$I3979 WL5 BLB21 VSS NMOS L=1u W=3.4u AS=6.46p AD=10.88p PS=7.2u
+ PD=13.2u
* device instance $1207 m0 *1 538.8,151.5 PMOS
XM$1207 \$I3980 \$I3981 VDD VDD PMOS L=1u W=3.4u AS=10.88p AD=6.46p PS=13.2u
+ PD=7.2u
* device instance $1208 m0 *1 543.6,151.5 PMOS
XM$1208 VDD \$I3980 \$I3981 VDD PMOS L=1u W=3.4u AS=6.46p AD=10.88p PS=7.2u
+ PD=13.2u
* device instance $1209 m0 *1 534,171.9 NMOS
XM$1209 BL22 WL5 \$I3980 VSS NMOS L=1u W=3.4u AS=10.88p AD=6.46p PS=13.2u
+ PD=7.2u
* device instance $1210 m0 *1 538.8,171.9 NMOS
XM$1210 \$I3980 \$I3981 VSS VSS NMOS L=1u W=3.4u AS=6.46p AD=6.46p PS=7.2u
+ PD=7.2u
* device instance $1211 m0 *1 543.6,171.9 NMOS
XM$1211 VSS \$I3980 \$I3981 VSS NMOS L=1u W=3.4u AS=6.46p AD=6.46p PS=7.2u
+ PD=7.2u
* device instance $1212 m0 *1 548.4,171.9 NMOS
XM$1212 \$I3981 WL5 BLB22 VSS NMOS L=1u W=3.4u AS=6.46p AD=10.88p PS=7.2u
+ PD=13.2u
* device instance $1213 m0 *1 538.8,388.3 PMOS
XM$1213 \$I3982 \$I3983 VDD VDD PMOS L=1u W=3.4u AS=10.88p AD=6.46p PS=13.2u
+ PD=7.2u
* device instance $1214 m0 *1 543.6,388.3 PMOS
XM$1214 VDD \$I3982 \$I3983 VDD PMOS L=1u W=3.4u AS=6.46p AD=10.88p PS=7.2u
+ PD=13.2u
* device instance $1215 m0 *1 534,408.7 NMOS
XM$1215 BL22 WL13 \$I3982 VSS NMOS L=1u W=3.4u AS=10.88p AD=6.46p PS=13.2u
+ PD=7.2u
* device instance $1216 m0 *1 538.8,408.7 NMOS
XM$1216 \$I3982 \$I3983 VSS VSS NMOS L=1u W=3.4u AS=6.46p AD=6.46p PS=7.2u
+ PD=7.2u
* device instance $1217 m0 *1 543.6,408.7 NMOS
XM$1217 VSS \$I3982 \$I3983 VSS NMOS L=1u W=3.4u AS=6.46p AD=6.46p PS=7.2u
+ PD=7.2u
* device instance $1218 m0 *1 548.4,408.7 NMOS
XM$1218 \$I3983 WL13 BLB22 VSS NMOS L=1u W=3.4u AS=6.46p AD=10.88p PS=7.2u
+ PD=13.2u
* device instance $1219 m0 *1 538.8,210.7 PMOS
XM$1219 \$I3984 \$I3985 VDD VDD PMOS L=1u W=3.4u AS=10.88p AD=6.46p PS=13.2u
+ PD=7.2u
* device instance $1220 m0 *1 543.6,210.7 PMOS
XM$1220 VDD \$I3984 \$I3985 VDD PMOS L=1u W=3.4u AS=6.46p AD=10.88p PS=7.2u
+ PD=13.2u
* device instance $1221 m0 *1 534,231.1 NMOS
XM$1221 BL22 WL7 \$I3984 VSS NMOS L=1u W=3.4u AS=10.88p AD=6.46p PS=13.2u
+ PD=7.2u
* device instance $1222 m0 *1 538.8,231.1 NMOS
XM$1222 \$I3984 \$I3985 VSS VSS NMOS L=1u W=3.4u AS=6.46p AD=6.46p PS=7.2u
+ PD=7.2u
* device instance $1223 m0 *1 543.6,231.1 NMOS
XM$1223 VSS \$I3984 \$I3985 VSS NMOS L=1u W=3.4u AS=6.46p AD=6.46p PS=7.2u
+ PD=7.2u
* device instance $1224 m0 *1 548.4,231.1 NMOS
XM$1224 \$I3985 WL7 BLB22 VSS NMOS L=1u W=3.4u AS=6.46p AD=10.88p PS=7.2u
+ PD=13.2u
* device instance $1225 m0 *1 492.4,388.3 PMOS
XM$1225 \$I3986 \$I3987 VDD VDD PMOS L=1u W=3.4u AS=10.88p AD=6.46p PS=13.2u
+ PD=7.2u
* device instance $1226 m0 *1 497.2,388.3 PMOS
XM$1226 VDD \$I3986 \$I3987 VDD PMOS L=1u W=3.4u AS=6.46p AD=10.88p PS=7.2u
+ PD=13.2u
* device instance $1227 m0 *1 487.6,408.7 NMOS
XM$1227 BL20 WL13 \$I3986 VSS NMOS L=1u W=3.4u AS=10.88p AD=6.46p PS=13.2u
+ PD=7.2u
* device instance $1228 m0 *1 492.4,408.7 NMOS
XM$1228 \$I3986 \$I3987 VSS VSS NMOS L=1u W=3.4u AS=6.46p AD=6.46p PS=7.2u
+ PD=7.2u
* device instance $1229 m0 *1 497.2,408.7 NMOS
XM$1229 VSS \$I3986 \$I3987 VSS NMOS L=1u W=3.4u AS=6.46p AD=6.46p PS=7.2u
+ PD=7.2u
* device instance $1230 m0 *1 502,408.7 NMOS
XM$1230 \$I3987 WL13 BLB20 VSS NMOS L=1u W=3.4u AS=6.46p AD=10.88p PS=7.2u
+ PD=13.2u
* device instance $1231 m0 *1 469.2,388.3 PMOS
XM$1231 \$I3988 \$I3989 VDD VDD PMOS L=1u W=3.4u AS=10.88p AD=6.46p PS=13.2u
+ PD=7.2u
* device instance $1232 m0 *1 474,388.3 PMOS
XM$1232 VDD \$I3988 \$I3989 VDD PMOS L=1u W=3.4u AS=6.46p AD=10.88p PS=7.2u
+ PD=13.2u
* device instance $1233 m0 *1 464.4,408.7 NMOS
XM$1233 BL19 WL13 \$I3988 VSS NMOS L=1u W=3.4u AS=10.88p AD=6.46p PS=13.2u
+ PD=7.2u
* device instance $1234 m0 *1 469.2,408.7 NMOS
XM$1234 \$I3988 \$I3989 VSS VSS NMOS L=1u W=3.4u AS=6.46p AD=6.46p PS=7.2u
+ PD=7.2u
* device instance $1235 m0 *1 474,408.7 NMOS
XM$1235 VSS \$I3988 \$I3989 VSS NMOS L=1u W=3.4u AS=6.46p AD=6.46p PS=7.2u
+ PD=7.2u
* device instance $1236 m0 *1 478.8,408.7 NMOS
XM$1236 \$I3989 WL13 BLB19 VSS NMOS L=1u W=3.4u AS=6.46p AD=10.88p PS=7.2u
+ PD=13.2u
* device instance $1237 m0 *1 608.4,388.3 PMOS
XM$1237 \$I3990 \$I3991 VDD VDD PMOS L=1u W=3.4u AS=10.88p AD=6.46p PS=13.2u
+ PD=7.2u
* device instance $1238 m0 *1 613.2,388.3 PMOS
XM$1238 VDD \$I3990 \$I3991 VDD PMOS L=1u W=3.4u AS=6.46p AD=10.88p PS=7.2u
+ PD=13.2u
* device instance $1239 m0 *1 603.6,408.7 NMOS
XM$1239 BL25 WL13 \$I3990 VSS NMOS L=1u W=3.4u AS=10.88p AD=6.46p PS=13.2u
+ PD=7.2u
* device instance $1240 m0 *1 608.4,408.7 NMOS
XM$1240 \$I3990 \$I3991 VSS VSS NMOS L=1u W=3.4u AS=6.46p AD=6.46p PS=7.2u
+ PD=7.2u
* device instance $1241 m0 *1 613.2,408.7 NMOS
XM$1241 VSS \$I3990 \$I3991 VSS NMOS L=1u W=3.4u AS=6.46p AD=6.46p PS=7.2u
+ PD=7.2u
* device instance $1242 m0 *1 618,408.7 NMOS
XM$1242 \$I3991 WL13 BLB25 VSS NMOS L=1u W=3.4u AS=6.46p AD=10.88p PS=7.2u
+ PD=13.2u
* device instance $1243 m0 *1 399.6,210.7 PMOS
XM$1243 \$I3992 \$I3993 VDD VDD PMOS L=1u W=3.4u AS=10.88p AD=6.46p PS=13.2u
+ PD=7.2u
* device instance $1244 m0 *1 404.4,210.7 PMOS
XM$1244 VDD \$I3992 \$I3993 VDD PMOS L=1u W=3.4u AS=6.46p AD=10.88p PS=7.2u
+ PD=13.2u
* device instance $1245 m0 *1 394.8,231.1 NMOS
XM$1245 BL16 WL7 \$I3992 VSS NMOS L=1u W=3.4u AS=10.88p AD=6.46p PS=13.2u
+ PD=7.2u
* device instance $1246 m0 *1 399.6,231.1 NMOS
XM$1246 \$I3992 \$I3993 VSS VSS NMOS L=1u W=3.4u AS=6.46p AD=6.46p PS=7.2u
+ PD=7.2u
* device instance $1247 m0 *1 404.4,231.1 NMOS
XM$1247 VSS \$I3992 \$I3993 VSS NMOS L=1u W=3.4u AS=6.46p AD=6.46p PS=7.2u
+ PD=7.2u
* device instance $1248 m0 *1 409.2,231.1 NMOS
XM$1248 \$I3993 WL7 BLB16 VSS NMOS L=1u W=3.4u AS=6.46p AD=10.88p PS=7.2u
+ PD=13.2u
* device instance $1249 m0 *1 422.8,210.7 PMOS
XM$1249 \$I3994 \$I3995 VDD VDD PMOS L=1u W=3.4u AS=10.88p AD=6.46p PS=13.2u
+ PD=7.2u
* device instance $1250 m0 *1 427.6,210.7 PMOS
XM$1250 VDD \$I3994 \$I3995 VDD PMOS L=1u W=3.4u AS=6.46p AD=10.88p PS=7.2u
+ PD=13.2u
* device instance $1251 m0 *1 418,231.1 NMOS
XM$1251 BL17 WL7 \$I3994 VSS NMOS L=1u W=3.4u AS=10.88p AD=6.46p PS=13.2u
+ PD=7.2u
* device instance $1252 m0 *1 422.8,231.1 NMOS
XM$1252 \$I3994 \$I3995 VSS VSS NMOS L=1u W=3.4u AS=6.46p AD=6.46p PS=7.2u
+ PD=7.2u
* device instance $1253 m0 *1 427.6,231.1 NMOS
XM$1253 VSS \$I3994 \$I3995 VSS NMOS L=1u W=3.4u AS=6.46p AD=6.46p PS=7.2u
+ PD=7.2u
* device instance $1254 m0 *1 432.4,231.1 NMOS
XM$1254 \$I3995 WL7 BLB17 VSS NMOS L=1u W=3.4u AS=6.46p AD=10.88p PS=7.2u
+ PD=13.2u
* device instance $1255 m0 *1 446,210.7 PMOS
XM$1255 \$I3996 \$I3997 VDD VDD PMOS L=1u W=3.4u AS=10.88p AD=6.46p PS=13.2u
+ PD=7.2u
* device instance $1256 m0 *1 450.8,210.7 PMOS
XM$1256 VDD \$I3996 \$I3997 VDD PMOS L=1u W=3.4u AS=6.46p AD=10.88p PS=7.2u
+ PD=13.2u
* device instance $1257 m0 *1 441.2,231.1 NMOS
XM$1257 BL18 WL7 \$I3996 VSS NMOS L=1u W=3.4u AS=10.88p AD=6.46p PS=13.2u
+ PD=7.2u
* device instance $1258 m0 *1 446,231.1 NMOS
XM$1258 \$I3996 \$I3997 VSS VSS NMOS L=1u W=3.4u AS=6.46p AD=6.46p PS=7.2u
+ PD=7.2u
* device instance $1259 m0 *1 450.8,231.1 NMOS
XM$1259 VSS \$I3996 \$I3997 VSS NMOS L=1u W=3.4u AS=6.46p AD=6.46p PS=7.2u
+ PD=7.2u
* device instance $1260 m0 *1 455.6,231.1 NMOS
XM$1260 \$I3997 WL7 BLB18 VSS NMOS L=1u W=3.4u AS=6.46p AD=10.88p PS=7.2u
+ PD=13.2u
* device instance $1261 m0 *1 492.4,329.1 PMOS
XM$1261 \$I3998 \$I3999 VDD VDD PMOS L=1u W=3.4u AS=10.88p AD=6.46p PS=13.2u
+ PD=7.2u
* device instance $1262 m0 *1 497.2,329.1 PMOS
XM$1262 VDD \$I3998 \$I3999 VDD PMOS L=1u W=3.4u AS=6.46p AD=10.88p PS=7.2u
+ PD=13.2u
* device instance $1263 m0 *1 487.6,349.5 NMOS
XM$1263 BL20 WL11 \$I3998 VSS NMOS L=1u W=3.4u AS=10.88p AD=6.46p PS=13.2u
+ PD=7.2u
* device instance $1264 m0 *1 492.4,349.5 NMOS
XM$1264 \$I3998 \$I3999 VSS VSS NMOS L=1u W=3.4u AS=6.46p AD=6.46p PS=7.2u
+ PD=7.2u
* device instance $1265 m0 *1 497.2,349.5 NMOS
XM$1265 VSS \$I3998 \$I3999 VSS NMOS L=1u W=3.4u AS=6.46p AD=6.46p PS=7.2u
+ PD=7.2u
* device instance $1266 m0 *1 502,349.5 NMOS
XM$1266 \$I3999 WL11 BLB20 VSS NMOS L=1u W=3.4u AS=6.46p AD=10.88p PS=7.2u
+ PD=13.2u
* device instance $1267 m0 *1 492.4,210.7 PMOS
XM$1267 \$I4000 \$I4001 VDD VDD PMOS L=1u W=3.4u AS=10.88p AD=6.46p PS=13.2u
+ PD=7.2u
* device instance $1268 m0 *1 497.2,210.7 PMOS
XM$1268 VDD \$I4000 \$I4001 VDD PMOS L=1u W=3.4u AS=6.46p AD=10.88p PS=7.2u
+ PD=13.2u
* device instance $1269 m0 *1 487.6,231.1 NMOS
XM$1269 BL20 WL7 \$I4000 VSS NMOS L=1u W=3.4u AS=10.88p AD=6.46p PS=13.2u
+ PD=7.2u
* device instance $1270 m0 *1 492.4,231.1 NMOS
XM$1270 \$I4000 \$I4001 VSS VSS NMOS L=1u W=3.4u AS=6.46p AD=6.46p PS=7.2u
+ PD=7.2u
* device instance $1271 m0 *1 497.2,231.1 NMOS
XM$1271 VSS \$I4000 \$I4001 VSS NMOS L=1u W=3.4u AS=6.46p AD=6.46p PS=7.2u
+ PD=7.2u
* device instance $1272 m0 *1 502,231.1 NMOS
XM$1272 \$I4001 WL7 BLB20 VSS NMOS L=1u W=3.4u AS=6.46p AD=10.88p PS=7.2u
+ PD=13.2u
* device instance $1273 m0 *1 515.6,210.7 PMOS
XM$1273 \$I4002 \$I4003 VDD VDD PMOS L=1u W=3.4u AS=10.88p AD=6.46p PS=13.2u
+ PD=7.2u
* device instance $1274 m0 *1 520.4,210.7 PMOS
XM$1274 VDD \$I4002 \$I4003 VDD PMOS L=1u W=3.4u AS=6.46p AD=10.88p PS=7.2u
+ PD=13.2u
* device instance $1275 m0 *1 510.8,231.1 NMOS
XM$1275 BL21 WL7 \$I4002 VSS NMOS L=1u W=3.4u AS=10.88p AD=6.46p PS=13.2u
+ PD=7.2u
* device instance $1276 m0 *1 515.6,231.1 NMOS
XM$1276 \$I4002 \$I4003 VSS VSS NMOS L=1u W=3.4u AS=6.46p AD=6.46p PS=7.2u
+ PD=7.2u
* device instance $1277 m0 *1 520.4,231.1 NMOS
XM$1277 VSS \$I4002 \$I4003 VSS NMOS L=1u W=3.4u AS=6.46p AD=6.46p PS=7.2u
+ PD=7.2u
* device instance $1278 m0 *1 525.2,231.1 NMOS
XM$1278 \$I4003 WL7 BLB21 VSS NMOS L=1u W=3.4u AS=6.46p AD=10.88p PS=7.2u
+ PD=13.2u
* device instance $1279 m0 *1 515.6,388.3 PMOS
XM$1279 \$I4004 \$I4005 VDD VDD PMOS L=1u W=3.4u AS=10.88p AD=6.46p PS=13.2u
+ PD=7.2u
* device instance $1280 m0 *1 520.4,388.3 PMOS
XM$1280 VDD \$I4004 \$I4005 VDD PMOS L=1u W=3.4u AS=6.46p AD=10.88p PS=7.2u
+ PD=13.2u
* device instance $1281 m0 *1 510.8,408.7 NMOS
XM$1281 BL21 WL13 \$I4004 VSS NMOS L=1u W=3.4u AS=10.88p AD=6.46p PS=13.2u
+ PD=7.2u
* device instance $1282 m0 *1 515.6,408.7 NMOS
XM$1282 \$I4004 \$I4005 VSS VSS NMOS L=1u W=3.4u AS=6.46p AD=6.46p PS=7.2u
+ PD=7.2u
* device instance $1283 m0 *1 520.4,408.7 NMOS
XM$1283 VSS \$I4004 \$I4005 VSS NMOS L=1u W=3.4u AS=6.46p AD=6.46p PS=7.2u
+ PD=7.2u
* device instance $1284 m0 *1 525.2,408.7 NMOS
XM$1284 \$I4005 WL13 BLB21 VSS NMOS L=1u W=3.4u AS=6.46p AD=10.88p PS=7.2u
+ PD=13.2u
* device instance $1285 m0 *1 608.4,92.3 PMOS
XM$1285 \$I4006 \$I4007 VDD VDD PMOS L=1u W=3.4u AS=10.88p AD=6.46p PS=13.2u
+ PD=7.2u
* device instance $1286 m0 *1 613.2,92.3 PMOS
XM$1286 VDD \$I4006 \$I4007 VDD PMOS L=1u W=3.4u AS=6.46p AD=10.88p PS=7.2u
+ PD=13.2u
* device instance $1287 m0 *1 603.6,112.7 NMOS
XM$1287 BL25 WL3 \$I4006 VSS NMOS L=1u W=3.4u AS=10.88p AD=6.46p PS=13.2u
+ PD=7.2u
* device instance $1288 m0 *1 608.4,112.7 NMOS
XM$1288 \$I4006 \$I4007 VSS VSS NMOS L=1u W=3.4u AS=6.46p AD=6.46p PS=7.2u
+ PD=7.2u
* device instance $1289 m0 *1 613.2,112.7 NMOS
XM$1289 VSS \$I4006 \$I4007 VSS NMOS L=1u W=3.4u AS=6.46p AD=6.46p PS=7.2u
+ PD=7.2u
* device instance $1290 m0 *1 618,112.7 NMOS
XM$1290 \$I4007 WL3 BLB25 VSS NMOS L=1u W=3.4u AS=6.46p AD=10.88p PS=7.2u
+ PD=13.2u
* device instance $1291 m0 *1 631.6,92.3 PMOS
XM$1291 \$I4008 \$I4009 VDD VDD PMOS L=1u W=3.4u AS=10.88p AD=6.46p PS=13.2u
+ PD=7.2u
* device instance $1292 m0 *1 636.4,92.3 PMOS
XM$1292 VDD \$I4008 \$I4009 VDD PMOS L=1u W=3.4u AS=6.46p AD=10.88p PS=7.2u
+ PD=13.2u
* device instance $1293 m0 *1 626.8,112.7 NMOS
XM$1293 BL26 WL3 \$I4008 VSS NMOS L=1u W=3.4u AS=10.88p AD=6.46p PS=13.2u
+ PD=7.2u
* device instance $1294 m0 *1 631.6,112.7 NMOS
XM$1294 \$I4008 \$I4009 VSS VSS NMOS L=1u W=3.4u AS=6.46p AD=6.46p PS=7.2u
+ PD=7.2u
* device instance $1295 m0 *1 636.4,112.7 NMOS
XM$1295 VSS \$I4008 \$I4009 VSS NMOS L=1u W=3.4u AS=6.46p AD=6.46p PS=7.2u
+ PD=7.2u
* device instance $1296 m0 *1 641.2,112.7 NMOS
XM$1296 \$I4009 WL3 BLB26 VSS NMOS L=1u W=3.4u AS=6.46p AD=10.88p PS=7.2u
+ PD=13.2u
* device instance $1297 m0 *1 654.8,92.3 PMOS
XM$1297 \$I4010 \$I4011 VDD VDD PMOS L=1u W=3.4u AS=10.88p AD=6.46p PS=13.2u
+ PD=7.2u
* device instance $1298 m0 *1 659.6,92.3 PMOS
XM$1298 VDD \$I4010 \$I4011 VDD PMOS L=1u W=3.4u AS=6.46p AD=10.88p PS=7.2u
+ PD=13.2u
* device instance $1299 m0 *1 650,112.7 NMOS
XM$1299 BL27 WL3 \$I4010 VSS NMOS L=1u W=3.4u AS=10.88p AD=6.46p PS=13.2u
+ PD=7.2u
* device instance $1300 m0 *1 654.8,112.7 NMOS
XM$1300 \$I4010 \$I4011 VSS VSS NMOS L=1u W=3.4u AS=6.46p AD=6.46p PS=7.2u
+ PD=7.2u
* device instance $1301 m0 *1 659.6,112.7 NMOS
XM$1301 VSS \$I4010 \$I4011 VSS NMOS L=1u W=3.4u AS=6.46p AD=6.46p PS=7.2u
+ PD=7.2u
* device instance $1302 m0 *1 664.4,112.7 NMOS
XM$1302 \$I4011 WL3 BLB27 VSS NMOS L=1u W=3.4u AS=6.46p AD=10.88p PS=7.2u
+ PD=13.2u
* device instance $1303 m0 *1 678,92.3 PMOS
XM$1303 \$I4012 \$I4013 VDD VDD PMOS L=1u W=3.4u AS=10.88p AD=6.46p PS=13.2u
+ PD=7.2u
* device instance $1304 m0 *1 682.8,92.3 PMOS
XM$1304 VDD \$I4012 \$I4013 VDD PMOS L=1u W=3.4u AS=6.46p AD=10.88p PS=7.2u
+ PD=13.2u
* device instance $1305 m0 *1 673.2,112.7 NMOS
XM$1305 BL28 WL3 \$I4012 VSS NMOS L=1u W=3.4u AS=10.88p AD=6.46p PS=13.2u
+ PD=7.2u
* device instance $1306 m0 *1 678,112.7 NMOS
XM$1306 \$I4012 \$I4013 VSS VSS NMOS L=1u W=3.4u AS=6.46p AD=6.46p PS=7.2u
+ PD=7.2u
* device instance $1307 m0 *1 682.8,112.7 NMOS
XM$1307 VSS \$I4012 \$I4013 VSS NMOS L=1u W=3.4u AS=6.46p AD=6.46p PS=7.2u
+ PD=7.2u
* device instance $1308 m0 *1 687.6,112.7 NMOS
XM$1308 \$I4013 WL3 BLB28 VSS NMOS L=1u W=3.4u AS=6.46p AD=10.88p PS=7.2u
+ PD=13.2u
* device instance $1309 m0 *1 701.2,92.3 PMOS
XM$1309 \$I4014 \$I4015 VDD VDD PMOS L=1u W=3.4u AS=10.88p AD=6.46p PS=13.2u
+ PD=7.2u
* device instance $1310 m0 *1 706,92.3 PMOS
XM$1310 VDD \$I4014 \$I4015 VDD PMOS L=1u W=3.4u AS=6.46p AD=10.88p PS=7.2u
+ PD=13.2u
* device instance $1311 m0 *1 696.4,112.7 NMOS
XM$1311 BL29 WL3 \$I4014 VSS NMOS L=1u W=3.4u AS=10.88p AD=6.46p PS=13.2u
+ PD=7.2u
* device instance $1312 m0 *1 701.2,112.7 NMOS
XM$1312 \$I4014 \$I4015 VSS VSS NMOS L=1u W=3.4u AS=6.46p AD=6.46p PS=7.2u
+ PD=7.2u
* device instance $1313 m0 *1 706,112.7 NMOS
XM$1313 VSS \$I4014 \$I4015 VSS NMOS L=1u W=3.4u AS=6.46p AD=6.46p PS=7.2u
+ PD=7.2u
* device instance $1314 m0 *1 710.8,112.7 NMOS
XM$1314 \$I4015 WL3 BLB29 VSS NMOS L=1u W=3.4u AS=6.46p AD=10.88p PS=7.2u
+ PD=13.2u
* device instance $1315 m0 *1 724.4,92.3 PMOS
XM$1315 \$I4016 \$I4017 VDD VDD PMOS L=1u W=3.4u AS=10.88p AD=6.46p PS=13.2u
+ PD=7.2u
* device instance $1316 m0 *1 729.2,92.3 PMOS
XM$1316 VDD \$I4016 \$I4017 VDD PMOS L=1u W=3.4u AS=6.46p AD=10.88p PS=7.2u
+ PD=13.2u
* device instance $1317 m0 *1 719.6,112.7 NMOS
XM$1317 BL30 WL3 \$I4016 VSS NMOS L=1u W=3.4u AS=10.88p AD=6.46p PS=13.2u
+ PD=7.2u
* device instance $1318 m0 *1 724.4,112.7 NMOS
XM$1318 \$I4016 \$I4017 VSS VSS NMOS L=1u W=3.4u AS=6.46p AD=6.46p PS=7.2u
+ PD=7.2u
* device instance $1319 m0 *1 729.2,112.7 NMOS
XM$1319 VSS \$I4016 \$I4017 VSS NMOS L=1u W=3.4u AS=6.46p AD=6.46p PS=7.2u
+ PD=7.2u
* device instance $1320 m0 *1 734,112.7 NMOS
XM$1320 \$I4017 WL3 BLB30 VSS NMOS L=1u W=3.4u AS=6.46p AD=10.88p PS=7.2u
+ PD=13.2u
* device instance $1321 m0 *1 747.6,92.3 PMOS
XM$1321 \$I4018 \$I4019 VDD VDD PMOS L=1u W=3.4u AS=10.88p AD=6.46p PS=13.2u
+ PD=7.2u
* device instance $1322 m0 *1 752.4,92.3 PMOS
XM$1322 VDD \$I4018 \$I4019 VDD PMOS L=1u W=3.4u AS=6.46p AD=10.88p PS=7.2u
+ PD=13.2u
* device instance $1323 m0 *1 742.8,112.7 NMOS
XM$1323 BL31 WL3 \$I4018 VSS NMOS L=1u W=3.4u AS=10.88p AD=6.46p PS=13.2u
+ PD=7.2u
* device instance $1324 m0 *1 747.6,112.7 NMOS
XM$1324 \$I4018 \$I4019 VSS VSS NMOS L=1u W=3.4u AS=6.46p AD=6.46p PS=7.2u
+ PD=7.2u
* device instance $1325 m0 *1 752.4,112.7 NMOS
XM$1325 VSS \$I4018 \$I4019 VSS NMOS L=1u W=3.4u AS=6.46p AD=6.46p PS=7.2u
+ PD=7.2u
* device instance $1326 m0 *1 757.2,112.7 NMOS
XM$1326 \$I4019 WL3 BLB31 VSS NMOS L=1u W=3.4u AS=6.46p AD=10.88p PS=7.2u
+ PD=13.2u
* device instance $1327 m0 *1 747.6,388.3 PMOS
XM$1327 \$I4020 \$I4021 VDD VDD PMOS L=1u W=3.4u AS=10.88p AD=6.46p PS=13.2u
+ PD=7.2u
* device instance $1328 m0 *1 752.4,388.3 PMOS
XM$1328 VDD \$I4020 \$I4021 VDD PMOS L=1u W=3.4u AS=6.46p AD=10.88p PS=7.2u
+ PD=13.2u
* device instance $1329 m0 *1 742.8,408.7 NMOS
XM$1329 BL31 WL13 \$I4020 VSS NMOS L=1u W=3.4u AS=10.88p AD=6.46p PS=13.2u
+ PD=7.2u
* device instance $1330 m0 *1 747.6,408.7 NMOS
XM$1330 \$I4020 \$I4021 VSS VSS NMOS L=1u W=3.4u AS=6.46p AD=6.46p PS=7.2u
+ PD=7.2u
* device instance $1331 m0 *1 752.4,408.7 NMOS
XM$1331 VSS \$I4020 \$I4021 VSS NMOS L=1u W=3.4u AS=6.46p AD=6.46p PS=7.2u
+ PD=7.2u
* device instance $1332 m0 *1 757.2,408.7 NMOS
XM$1332 \$I4021 WL13 BLB31 VSS NMOS L=1u W=3.4u AS=6.46p AD=10.88p PS=7.2u
+ PD=13.2u
* device instance $1333 m0 *1 538.8,92.3 PMOS
XM$1333 \$I4022 \$I4023 VDD VDD PMOS L=1u W=3.4u AS=10.88p AD=6.46p PS=13.2u
+ PD=7.2u
* device instance $1334 m0 *1 543.6,92.3 PMOS
XM$1334 VDD \$I4022 \$I4023 VDD PMOS L=1u W=3.4u AS=6.46p AD=10.88p PS=7.2u
+ PD=13.2u
* device instance $1335 m0 *1 534,112.7 NMOS
XM$1335 BL22 WL3 \$I4022 VSS NMOS L=1u W=3.4u AS=10.88p AD=6.46p PS=13.2u
+ PD=7.2u
* device instance $1336 m0 *1 538.8,112.7 NMOS
XM$1336 \$I4022 \$I4023 VSS VSS NMOS L=1u W=3.4u AS=6.46p AD=6.46p PS=7.2u
+ PD=7.2u
* device instance $1337 m0 *1 543.6,112.7 NMOS
XM$1337 VSS \$I4022 \$I4023 VSS NMOS L=1u W=3.4u AS=6.46p AD=6.46p PS=7.2u
+ PD=7.2u
* device instance $1338 m0 *1 548.4,112.7 NMOS
XM$1338 \$I4023 WL3 BLB22 VSS NMOS L=1u W=3.4u AS=6.46p AD=10.88p PS=7.2u
+ PD=13.2u
* device instance $1339 m0 *1 701.2,388.3 PMOS
XM$1339 \$I4024 \$I4025 VDD VDD PMOS L=1u W=3.4u AS=10.88p AD=6.46p PS=13.2u
+ PD=7.2u
* device instance $1340 m0 *1 706,388.3 PMOS
XM$1340 VDD \$I4024 \$I4025 VDD PMOS L=1u W=3.4u AS=6.46p AD=10.88p PS=7.2u
+ PD=13.2u
* device instance $1341 m0 *1 696.4,408.7 NMOS
XM$1341 BL29 WL13 \$I4024 VSS NMOS L=1u W=3.4u AS=10.88p AD=6.46p PS=13.2u
+ PD=7.2u
* device instance $1342 m0 *1 701.2,408.7 NMOS
XM$1342 \$I4024 \$I4025 VSS VSS NMOS L=1u W=3.4u AS=6.46p AD=6.46p PS=7.2u
+ PD=7.2u
* device instance $1343 m0 *1 706,408.7 NMOS
XM$1343 VSS \$I4024 \$I4025 VSS NMOS L=1u W=3.4u AS=6.46p AD=6.46p PS=7.2u
+ PD=7.2u
* device instance $1344 m0 *1 710.8,408.7 NMOS
XM$1344 \$I4025 WL13 BLB29 VSS NMOS L=1u W=3.4u AS=6.46p AD=10.88p PS=7.2u
+ PD=13.2u
* device instance $1345 m0 *1 678,388.3 PMOS
XM$1345 \$I4026 \$I4027 VDD VDD PMOS L=1u W=3.4u AS=10.88p AD=6.46p PS=13.2u
+ PD=7.2u
* device instance $1346 m0 *1 682.8,388.3 PMOS
XM$1346 VDD \$I4026 \$I4027 VDD PMOS L=1u W=3.4u AS=6.46p AD=10.88p PS=7.2u
+ PD=13.2u
* device instance $1347 m0 *1 673.2,408.7 NMOS
XM$1347 BL28 WL13 \$I4026 VSS NMOS L=1u W=3.4u AS=10.88p AD=6.46p PS=13.2u
+ PD=7.2u
* device instance $1348 m0 *1 678,408.7 NMOS
XM$1348 \$I4026 \$I4027 VSS VSS NMOS L=1u W=3.4u AS=6.46p AD=6.46p PS=7.2u
+ PD=7.2u
* device instance $1349 m0 *1 682.8,408.7 NMOS
XM$1349 VSS \$I4026 \$I4027 VSS NMOS L=1u W=3.4u AS=6.46p AD=6.46p PS=7.2u
+ PD=7.2u
* device instance $1350 m0 *1 687.6,408.7 NMOS
XM$1350 \$I4027 WL13 BLB28 VSS NMOS L=1u W=3.4u AS=6.46p AD=10.88p PS=7.2u
+ PD=13.2u
* device instance $1351 m0 *1 654.8,388.3 PMOS
XM$1351 \$I4028 \$I4029 VDD VDD PMOS L=1u W=3.4u AS=10.88p AD=6.46p PS=13.2u
+ PD=7.2u
* device instance $1352 m0 *1 659.6,388.3 PMOS
XM$1352 VDD \$I4028 \$I4029 VDD PMOS L=1u W=3.4u AS=6.46p AD=10.88p PS=7.2u
+ PD=13.2u
* device instance $1353 m0 *1 650,408.7 NMOS
XM$1353 BL27 WL13 \$I4028 VSS NMOS L=1u W=3.4u AS=10.88p AD=6.46p PS=13.2u
+ PD=7.2u
* device instance $1354 m0 *1 654.8,408.7 NMOS
XM$1354 \$I4028 \$I4029 VSS VSS NMOS L=1u W=3.4u AS=6.46p AD=6.46p PS=7.2u
+ PD=7.2u
* device instance $1355 m0 *1 659.6,408.7 NMOS
XM$1355 VSS \$I4028 \$I4029 VSS NMOS L=1u W=3.4u AS=6.46p AD=6.46p PS=7.2u
+ PD=7.2u
* device instance $1356 m0 *1 664.4,408.7 NMOS
XM$1356 \$I4029 WL13 BLB27 VSS NMOS L=1u W=3.4u AS=6.46p AD=10.88p PS=7.2u
+ PD=13.2u
* device instance $1357 m0 *1 631.6,388.3 PMOS
XM$1357 \$I4030 \$I4031 VDD VDD PMOS L=1u W=3.4u AS=10.88p AD=6.46p PS=13.2u
+ PD=7.2u
* device instance $1358 m0 *1 636.4,388.3 PMOS
XM$1358 VDD \$I4030 \$I4031 VDD PMOS L=1u W=3.4u AS=6.46p AD=10.88p PS=7.2u
+ PD=13.2u
* device instance $1359 m0 *1 626.8,408.7 NMOS
XM$1359 BL26 WL13 \$I4030 VSS NMOS L=1u W=3.4u AS=10.88p AD=6.46p PS=13.2u
+ PD=7.2u
* device instance $1360 m0 *1 631.6,408.7 NMOS
XM$1360 \$I4030 \$I4031 VSS VSS NMOS L=1u W=3.4u AS=6.46p AD=6.46p PS=7.2u
+ PD=7.2u
* device instance $1361 m0 *1 636.4,408.7 NMOS
XM$1361 VSS \$I4030 \$I4031 VSS NMOS L=1u W=3.4u AS=6.46p AD=6.46p PS=7.2u
+ PD=7.2u
* device instance $1362 m0 *1 641.2,408.7 NMOS
XM$1362 \$I4031 WL13 BLB26 VSS NMOS L=1u W=3.4u AS=6.46p AD=10.88p PS=7.2u
+ PD=13.2u
* device instance $1363 m0 *1 562,329.1 PMOS
XM$1363 \$I4032 \$I4033 VDD VDD PMOS L=1u W=3.4u AS=10.88p AD=6.46p PS=13.2u
+ PD=7.2u
* device instance $1364 m0 *1 566.8,329.1 PMOS
XM$1364 VDD \$I4032 \$I4033 VDD PMOS L=1u W=3.4u AS=6.46p AD=10.88p PS=7.2u
+ PD=13.2u
* device instance $1365 m0 *1 557.2,349.5 NMOS
XM$1365 BL23 WL11 \$I4032 VSS NMOS L=1u W=3.4u AS=10.88p AD=6.46p PS=13.2u
+ PD=7.2u
* device instance $1366 m0 *1 562,349.5 NMOS
XM$1366 \$I4032 \$I4033 VSS VSS NMOS L=1u W=3.4u AS=6.46p AD=6.46p PS=7.2u
+ PD=7.2u
* device instance $1367 m0 *1 566.8,349.5 NMOS
XM$1367 VSS \$I4032 \$I4033 VSS NMOS L=1u W=3.4u AS=6.46p AD=6.46p PS=7.2u
+ PD=7.2u
* device instance $1368 m0 *1 571.6,349.5 NMOS
XM$1368 \$I4033 WL11 BLB23 VSS NMOS L=1u W=3.4u AS=6.46p AD=10.88p PS=7.2u
+ PD=13.2u
* device instance $1369 m0 *1 562,269.9 PMOS
XM$1369 \$I4034 \$I4035 VDD VDD PMOS L=1u W=3.4u AS=10.88p AD=6.46p PS=13.2u
+ PD=7.2u
* device instance $1370 m0 *1 566.8,269.9 PMOS
XM$1370 VDD \$I4034 \$I4035 VDD PMOS L=1u W=3.4u AS=6.46p AD=10.88p PS=7.2u
+ PD=13.2u
* device instance $1371 m0 *1 557.2,290.3 NMOS
XM$1371 BL23 WL9 \$I4034 VSS NMOS L=1u W=3.4u AS=10.88p AD=6.46p PS=13.2u
+ PD=7.2u
* device instance $1372 m0 *1 562,290.3 NMOS
XM$1372 \$I4034 \$I4035 VSS VSS NMOS L=1u W=3.4u AS=6.46p AD=6.46p PS=7.2u
+ PD=7.2u
* device instance $1373 m0 *1 566.8,290.3 NMOS
XM$1373 VSS \$I4034 \$I4035 VSS NMOS L=1u W=3.4u AS=6.46p AD=6.46p PS=7.2u
+ PD=7.2u
* device instance $1374 m0 *1 571.6,290.3 NMOS
XM$1374 \$I4035 WL9 BLB23 VSS NMOS L=1u W=3.4u AS=6.46p AD=10.88p PS=7.2u
+ PD=13.2u
* device instance $1375 m0 *1 562,447.5 PMOS
XM$1375 \$I4036 \$I4037 VDD VDD PMOS L=1u W=3.4u AS=10.88p AD=6.46p PS=13.2u
+ PD=7.2u
* device instance $1376 m0 *1 566.8,447.5 PMOS
XM$1376 VDD \$I4036 \$I4037 VDD PMOS L=1u W=3.4u AS=6.46p AD=10.88p PS=7.2u
+ PD=13.2u
* device instance $1377 m0 *1 557.2,467.9 NMOS
XM$1377 BL23 WL15 \$I4036 VSS NMOS L=1u W=3.4u AS=10.88p AD=6.46p PS=13.2u
+ PD=7.2u
* device instance $1378 m0 *1 562,467.9 NMOS
XM$1378 \$I4036 \$I4037 VSS VSS NMOS L=1u W=3.4u AS=6.46p AD=6.46p PS=7.2u
+ PD=7.2u
* device instance $1379 m0 *1 566.8,467.9 NMOS
XM$1379 VSS \$I4036 \$I4037 VSS NMOS L=1u W=3.4u AS=6.46p AD=6.46p PS=7.2u
+ PD=7.2u
* device instance $1380 m0 *1 571.6,467.9 NMOS
XM$1380 \$I4037 WL15 BLB23 VSS NMOS L=1u W=3.4u AS=6.46p AD=10.88p PS=7.2u
+ PD=13.2u
* device instance $1381 m0 *1 562,388.3 PMOS
XM$1381 \$I4038 \$I4039 VDD VDD PMOS L=1u W=3.4u AS=10.88p AD=6.46p PS=13.2u
+ PD=7.2u
* device instance $1382 m0 *1 566.8,388.3 PMOS
XM$1382 VDD \$I4038 \$I4039 VDD PMOS L=1u W=3.4u AS=6.46p AD=10.88p PS=7.2u
+ PD=13.2u
* device instance $1383 m0 *1 557.2,408.7 NMOS
XM$1383 BL23 WL13 \$I4038 VSS NMOS L=1u W=3.4u AS=10.88p AD=6.46p PS=13.2u
+ PD=7.2u
* device instance $1384 m0 *1 562,408.7 NMOS
XM$1384 \$I4038 \$I4039 VSS VSS NMOS L=1u W=3.4u AS=6.46p AD=6.46p PS=7.2u
+ PD=7.2u
* device instance $1385 m0 *1 566.8,408.7 NMOS
XM$1385 VSS \$I4038 \$I4039 VSS NMOS L=1u W=3.4u AS=6.46p AD=6.46p PS=7.2u
+ PD=7.2u
* device instance $1386 m0 *1 571.6,408.7 NMOS
XM$1386 \$I4039 WL13 BLB23 VSS NMOS L=1u W=3.4u AS=6.46p AD=10.88p PS=7.2u
+ PD=13.2u
* device instance $1387 m0 *1 724.4,388.3 PMOS
XM$1387 \$I4040 \$I4041 VDD VDD PMOS L=1u W=3.4u AS=10.88p AD=6.46p PS=13.2u
+ PD=7.2u
* device instance $1388 m0 *1 729.2,388.3 PMOS
XM$1388 VDD \$I4040 \$I4041 VDD PMOS L=1u W=3.4u AS=6.46p AD=10.88p PS=7.2u
+ PD=13.2u
* device instance $1389 m0 *1 719.6,408.7 NMOS
XM$1389 BL30 WL13 \$I4040 VSS NMOS L=1u W=3.4u AS=10.88p AD=6.46p PS=13.2u
+ PD=7.2u
* device instance $1390 m0 *1 724.4,408.7 NMOS
XM$1390 \$I4040 \$I4041 VSS VSS NMOS L=1u W=3.4u AS=6.46p AD=6.46p PS=7.2u
+ PD=7.2u
* device instance $1391 m0 *1 729.2,408.7 NMOS
XM$1391 VSS \$I4040 \$I4041 VSS NMOS L=1u W=3.4u AS=6.46p AD=6.46p PS=7.2u
+ PD=7.2u
* device instance $1392 m0 *1 734,408.7 NMOS
XM$1392 \$I4041 WL13 BLB30 VSS NMOS L=1u W=3.4u AS=6.46p AD=10.88p PS=7.2u
+ PD=13.2u
* device instance $1393 m0 *1 469.2,33.1 PMOS
XM$1393 \$I4042 \$I4043 VDD VDD PMOS L=1u W=3.4u AS=10.88p AD=6.46p PS=13.2u
+ PD=7.2u
* device instance $1394 m0 *1 474,33.1 PMOS
XM$1394 VDD \$I4042 \$I4043 VDD PMOS L=1u W=3.4u AS=6.46p AD=10.88p PS=7.2u
+ PD=13.2u
* device instance $1395 m0 *1 464.4,53.5 NMOS
XM$1395 BL19 WL1 \$I4042 VSS NMOS L=1u W=3.4u AS=10.88p AD=6.46p PS=13.2u
+ PD=7.2u
* device instance $1396 m0 *1 469.2,53.5 NMOS
XM$1396 \$I4042 \$I4043 VSS VSS NMOS L=1u W=3.4u AS=6.46p AD=6.46p PS=7.2u
+ PD=7.2u
* device instance $1397 m0 *1 474,53.5 NMOS
XM$1397 VSS \$I4042 \$I4043 VSS NMOS L=1u W=3.4u AS=6.46p AD=6.46p PS=7.2u
+ PD=7.2u
* device instance $1398 m0 *1 478.8,53.5 NMOS
XM$1398 \$I4043 WL1 BLB19 VSS NMOS L=1u W=3.4u AS=6.46p AD=10.88p PS=7.2u
+ PD=13.2u
* device instance $1399 m0 *1 492.4,33.1 PMOS
XM$1399 \$I4044 \$I4045 VDD VDD PMOS L=1u W=3.4u AS=10.88p AD=6.46p PS=13.2u
+ PD=7.2u
* device instance $1400 m0 *1 497.2,33.1 PMOS
XM$1400 VDD \$I4044 \$I4045 VDD PMOS L=1u W=3.4u AS=6.46p AD=10.88p PS=7.2u
+ PD=13.2u
* device instance $1401 m0 *1 487.6,53.5 NMOS
XM$1401 BL20 WL1 \$I4044 VSS NMOS L=1u W=3.4u AS=10.88p AD=6.46p PS=13.2u
+ PD=7.2u
* device instance $1402 m0 *1 492.4,53.5 NMOS
XM$1402 \$I4044 \$I4045 VSS VSS NMOS L=1u W=3.4u AS=6.46p AD=6.46p PS=7.2u
+ PD=7.2u
* device instance $1403 m0 *1 497.2,53.5 NMOS
XM$1403 VSS \$I4044 \$I4045 VSS NMOS L=1u W=3.4u AS=6.46p AD=6.46p PS=7.2u
+ PD=7.2u
* device instance $1404 m0 *1 502,53.5 NMOS
XM$1404 \$I4045 WL1 BLB20 VSS NMOS L=1u W=3.4u AS=6.46p AD=10.88p PS=7.2u
+ PD=13.2u
* device instance $1405 m0 *1 515.6,33.1 PMOS
XM$1405 \$I4046 \$I4047 VDD VDD PMOS L=1u W=3.4u AS=10.88p AD=6.46p PS=13.2u
+ PD=7.2u
* device instance $1406 m0 *1 520.4,33.1 PMOS
XM$1406 VDD \$I4046 \$I4047 VDD PMOS L=1u W=3.4u AS=6.46p AD=10.88p PS=7.2u
+ PD=13.2u
* device instance $1407 m0 *1 510.8,53.5 NMOS
XM$1407 BL21 WL1 \$I4046 VSS NMOS L=1u W=3.4u AS=10.88p AD=6.46p PS=13.2u
+ PD=7.2u
* device instance $1408 m0 *1 515.6,53.5 NMOS
XM$1408 \$I4046 \$I4047 VSS VSS NMOS L=1u W=3.4u AS=6.46p AD=6.46p PS=7.2u
+ PD=7.2u
* device instance $1409 m0 *1 520.4,53.5 NMOS
XM$1409 VSS \$I4046 \$I4047 VSS NMOS L=1u W=3.4u AS=6.46p AD=6.46p PS=7.2u
+ PD=7.2u
* device instance $1410 m0 *1 525.2,53.5 NMOS
XM$1410 \$I4047 WL1 BLB21 VSS NMOS L=1u W=3.4u AS=6.46p AD=10.88p PS=7.2u
+ PD=13.2u
* device instance $1411 m0 *1 538.8,33.1 PMOS
XM$1411 \$I4048 \$I4049 VDD VDD PMOS L=1u W=3.4u AS=10.88p AD=6.46p PS=13.2u
+ PD=7.2u
* device instance $1412 m0 *1 543.6,33.1 PMOS
XM$1412 VDD \$I4048 \$I4049 VDD PMOS L=1u W=3.4u AS=6.46p AD=10.88p PS=7.2u
+ PD=13.2u
* device instance $1413 m0 *1 534,53.5 NMOS
XM$1413 BL22 WL1 \$I4048 VSS NMOS L=1u W=3.4u AS=10.88p AD=6.46p PS=13.2u
+ PD=7.2u
* device instance $1414 m0 *1 538.8,53.5 NMOS
XM$1414 \$I4048 \$I4049 VSS VSS NMOS L=1u W=3.4u AS=6.46p AD=6.46p PS=7.2u
+ PD=7.2u
* device instance $1415 m0 *1 543.6,53.5 NMOS
XM$1415 VSS \$I4048 \$I4049 VSS NMOS L=1u W=3.4u AS=6.46p AD=6.46p PS=7.2u
+ PD=7.2u
* device instance $1416 m0 *1 548.4,53.5 NMOS
XM$1416 \$I4049 WL1 BLB22 VSS NMOS L=1u W=3.4u AS=6.46p AD=10.88p PS=7.2u
+ PD=13.2u
* device instance $1417 m0 *1 701.2,447.5 PMOS
XM$1417 \$I4050 \$I4051 VDD VDD PMOS L=1u W=3.4u AS=10.88p AD=6.46p PS=13.2u
+ PD=7.2u
* device instance $1418 m0 *1 706,447.5 PMOS
XM$1418 VDD \$I4050 \$I4051 VDD PMOS L=1u W=3.4u AS=6.46p AD=10.88p PS=7.2u
+ PD=13.2u
* device instance $1419 m0 *1 696.4,467.9 NMOS
XM$1419 BL29 WL15 \$I4050 VSS NMOS L=1u W=3.4u AS=10.88p AD=6.46p PS=13.2u
+ PD=7.2u
* device instance $1420 m0 *1 701.2,467.9 NMOS
XM$1420 \$I4050 \$I4051 VSS VSS NMOS L=1u W=3.4u AS=6.46p AD=6.46p PS=7.2u
+ PD=7.2u
* device instance $1421 m0 *1 706,467.9 NMOS
XM$1421 VSS \$I4050 \$I4051 VSS NMOS L=1u W=3.4u AS=6.46p AD=6.46p PS=7.2u
+ PD=7.2u
* device instance $1422 m0 *1 710.8,467.9 NMOS
XM$1422 \$I4051 WL15 BLB29 VSS NMOS L=1u W=3.4u AS=6.46p AD=10.88p PS=7.2u
+ PD=13.2u
* device instance $1423 m0 *1 678,447.5 PMOS
XM$1423 \$I4052 \$I4053 VDD VDD PMOS L=1u W=3.4u AS=10.88p AD=6.46p PS=13.2u
+ PD=7.2u
* device instance $1424 m0 *1 682.8,447.5 PMOS
XM$1424 VDD \$I4052 \$I4053 VDD PMOS L=1u W=3.4u AS=6.46p AD=10.88p PS=7.2u
+ PD=13.2u
* device instance $1425 m0 *1 673.2,467.9 NMOS
XM$1425 BL28 WL15 \$I4052 VSS NMOS L=1u W=3.4u AS=10.88p AD=6.46p PS=13.2u
+ PD=7.2u
* device instance $1426 m0 *1 678,467.9 NMOS
XM$1426 \$I4052 \$I4053 VSS VSS NMOS L=1u W=3.4u AS=6.46p AD=6.46p PS=7.2u
+ PD=7.2u
* device instance $1427 m0 *1 682.8,467.9 NMOS
XM$1427 VSS \$I4052 \$I4053 VSS NMOS L=1u W=3.4u AS=6.46p AD=6.46p PS=7.2u
+ PD=7.2u
* device instance $1428 m0 *1 687.6,467.9 NMOS
XM$1428 \$I4053 WL15 BLB28 VSS NMOS L=1u W=3.4u AS=6.46p AD=10.88p PS=7.2u
+ PD=13.2u
* device instance $1429 m0 *1 654.8,447.5 PMOS
XM$1429 \$I4054 \$I4055 VDD VDD PMOS L=1u W=3.4u AS=10.88p AD=6.46p PS=13.2u
+ PD=7.2u
* device instance $1430 m0 *1 659.6,447.5 PMOS
XM$1430 VDD \$I4054 \$I4055 VDD PMOS L=1u W=3.4u AS=6.46p AD=10.88p PS=7.2u
+ PD=13.2u
* device instance $1431 m0 *1 650,467.9 NMOS
XM$1431 BL27 WL15 \$I4054 VSS NMOS L=1u W=3.4u AS=10.88p AD=6.46p PS=13.2u
+ PD=7.2u
* device instance $1432 m0 *1 654.8,467.9 NMOS
XM$1432 \$I4054 \$I4055 VSS VSS NMOS L=1u W=3.4u AS=6.46p AD=6.46p PS=7.2u
+ PD=7.2u
* device instance $1433 m0 *1 659.6,467.9 NMOS
XM$1433 VSS \$I4054 \$I4055 VSS NMOS L=1u W=3.4u AS=6.46p AD=6.46p PS=7.2u
+ PD=7.2u
* device instance $1434 m0 *1 664.4,467.9 NMOS
XM$1434 \$I4055 WL15 BLB27 VSS NMOS L=1u W=3.4u AS=6.46p AD=10.88p PS=7.2u
+ PD=13.2u
* device instance $1435 m0 *1 631.6,447.5 PMOS
XM$1435 \$I4056 \$I4057 VDD VDD PMOS L=1u W=3.4u AS=10.88p AD=6.46p PS=13.2u
+ PD=7.2u
* device instance $1436 m0 *1 636.4,447.5 PMOS
XM$1436 VDD \$I4056 \$I4057 VDD PMOS L=1u W=3.4u AS=6.46p AD=10.88p PS=7.2u
+ PD=13.2u
* device instance $1437 m0 *1 626.8,467.9 NMOS
XM$1437 BL26 WL15 \$I4056 VSS NMOS L=1u W=3.4u AS=10.88p AD=6.46p PS=13.2u
+ PD=7.2u
* device instance $1438 m0 *1 631.6,467.9 NMOS
XM$1438 \$I4056 \$I4057 VSS VSS NMOS L=1u W=3.4u AS=6.46p AD=6.46p PS=7.2u
+ PD=7.2u
* device instance $1439 m0 *1 636.4,467.9 NMOS
XM$1439 VSS \$I4056 \$I4057 VSS NMOS L=1u W=3.4u AS=6.46p AD=6.46p PS=7.2u
+ PD=7.2u
* device instance $1440 m0 *1 641.2,467.9 NMOS
XM$1440 \$I4057 WL15 BLB26 VSS NMOS L=1u W=3.4u AS=6.46p AD=10.88p PS=7.2u
+ PD=13.2u
* device instance $1441 m0 *1 585.2,92.3 PMOS
XM$1441 \$I4058 \$I4059 VDD VDD PMOS L=1u W=3.4u AS=10.88p AD=6.46p PS=13.2u
+ PD=7.2u
* device instance $1442 m0 *1 590,92.3 PMOS
XM$1442 VDD \$I4058 \$I4059 VDD PMOS L=1u W=3.4u AS=6.46p AD=10.88p PS=7.2u
+ PD=13.2u
* device instance $1443 m0 *1 580.4,112.7 NMOS
XM$1443 BL24 WL3 \$I4058 VSS NMOS L=1u W=3.4u AS=10.88p AD=6.46p PS=13.2u
+ PD=7.2u
* device instance $1444 m0 *1 585.2,112.7 NMOS
XM$1444 \$I4058 \$I4059 VSS VSS NMOS L=1u W=3.4u AS=6.46p AD=6.46p PS=7.2u
+ PD=7.2u
* device instance $1445 m0 *1 590,112.7 NMOS
XM$1445 VSS \$I4058 \$I4059 VSS NMOS L=1u W=3.4u AS=6.46p AD=6.46p PS=7.2u
+ PD=7.2u
* device instance $1446 m0 *1 594.8,112.7 NMOS
XM$1446 \$I4059 WL3 BLB24 VSS NMOS L=1u W=3.4u AS=6.46p AD=10.88p PS=7.2u
+ PD=13.2u
* device instance $1447 m0 *1 585.2,447.5 PMOS
XM$1447 \$I4060 \$I4061 VDD VDD PMOS L=1u W=3.4u AS=10.88p AD=6.46p PS=13.2u
+ PD=7.2u
* device instance $1448 m0 *1 590,447.5 PMOS
XM$1448 VDD \$I4060 \$I4061 VDD PMOS L=1u W=3.4u AS=6.46p AD=10.88p PS=7.2u
+ PD=13.2u
* device instance $1449 m0 *1 580.4,467.9 NMOS
XM$1449 BL24 WL15 \$I4060 VSS NMOS L=1u W=3.4u AS=10.88p AD=6.46p PS=13.2u
+ PD=7.2u
* device instance $1450 m0 *1 585.2,467.9 NMOS
XM$1450 \$I4060 \$I4061 VSS VSS NMOS L=1u W=3.4u AS=6.46p AD=6.46p PS=7.2u
+ PD=7.2u
* device instance $1451 m0 *1 590,467.9 NMOS
XM$1451 VSS \$I4060 \$I4061 VSS NMOS L=1u W=3.4u AS=6.46p AD=6.46p PS=7.2u
+ PD=7.2u
* device instance $1452 m0 *1 594.8,467.9 NMOS
XM$1452 \$I4061 WL15 BLB24 VSS NMOS L=1u W=3.4u AS=6.46p AD=10.88p PS=7.2u
+ PD=13.2u
* device instance $1453 m0 *1 585.2,33.1 PMOS
XM$1453 \$I4062 \$I4063 VDD VDD PMOS L=1u W=3.4u AS=10.88p AD=6.46p PS=13.2u
+ PD=7.2u
* device instance $1454 m0 *1 590,33.1 PMOS
XM$1454 VDD \$I4062 \$I4063 VDD PMOS L=1u W=3.4u AS=6.46p AD=10.88p PS=7.2u
+ PD=13.2u
* device instance $1455 m0 *1 580.4,53.5 NMOS
XM$1455 BL24 WL1 \$I4062 VSS NMOS L=1u W=3.4u AS=10.88p AD=6.46p PS=13.2u
+ PD=7.2u
* device instance $1456 m0 *1 585.2,53.5 NMOS
XM$1456 \$I4062 \$I4063 VSS VSS NMOS L=1u W=3.4u AS=6.46p AD=6.46p PS=7.2u
+ PD=7.2u
* device instance $1457 m0 *1 590,53.5 NMOS
XM$1457 VSS \$I4062 \$I4063 VSS NMOS L=1u W=3.4u AS=6.46p AD=6.46p PS=7.2u
+ PD=7.2u
* device instance $1458 m0 *1 594.8,53.5 NMOS
XM$1458 \$I4063 WL1 BLB24 VSS NMOS L=1u W=3.4u AS=6.46p AD=10.88p PS=7.2u
+ PD=13.2u
* device instance $1459 m0 *1 608.4,33.1 PMOS
XM$1459 \$I4064 \$I4065 VDD VDD PMOS L=1u W=3.4u AS=10.88p AD=6.46p PS=13.2u
+ PD=7.2u
* device instance $1460 m0 *1 613.2,33.1 PMOS
XM$1460 VDD \$I4064 \$I4065 VDD PMOS L=1u W=3.4u AS=6.46p AD=10.88p PS=7.2u
+ PD=13.2u
* device instance $1461 m0 *1 603.6,53.5 NMOS
XM$1461 BL25 WL1 \$I4064 VSS NMOS L=1u W=3.4u AS=10.88p AD=6.46p PS=13.2u
+ PD=7.2u
* device instance $1462 m0 *1 608.4,53.5 NMOS
XM$1462 \$I4064 \$I4065 VSS VSS NMOS L=1u W=3.4u AS=6.46p AD=6.46p PS=7.2u
+ PD=7.2u
* device instance $1463 m0 *1 613.2,53.5 NMOS
XM$1463 VSS \$I4064 \$I4065 VSS NMOS L=1u W=3.4u AS=6.46p AD=6.46p PS=7.2u
+ PD=7.2u
* device instance $1464 m0 *1 618,53.5 NMOS
XM$1464 \$I4065 WL1 BLB25 VSS NMOS L=1u W=3.4u AS=6.46p AD=10.88p PS=7.2u
+ PD=13.2u
* device instance $1465 m0 *1 631.6,33.1 PMOS
XM$1465 \$I4066 \$I4067 VDD VDD PMOS L=1u W=3.4u AS=10.88p AD=6.46p PS=13.2u
+ PD=7.2u
* device instance $1466 m0 *1 636.4,33.1 PMOS
XM$1466 VDD \$I4066 \$I4067 VDD PMOS L=1u W=3.4u AS=6.46p AD=10.88p PS=7.2u
+ PD=13.2u
* device instance $1467 m0 *1 626.8,53.5 NMOS
XM$1467 BL26 WL1 \$I4066 VSS NMOS L=1u W=3.4u AS=10.88p AD=6.46p PS=13.2u
+ PD=7.2u
* device instance $1468 m0 *1 631.6,53.5 NMOS
XM$1468 \$I4066 \$I4067 VSS VSS NMOS L=1u W=3.4u AS=6.46p AD=6.46p PS=7.2u
+ PD=7.2u
* device instance $1469 m0 *1 636.4,53.5 NMOS
XM$1469 VSS \$I4066 \$I4067 VSS NMOS L=1u W=3.4u AS=6.46p AD=6.46p PS=7.2u
+ PD=7.2u
* device instance $1470 m0 *1 641.2,53.5 NMOS
XM$1470 \$I4067 WL1 BLB26 VSS NMOS L=1u W=3.4u AS=6.46p AD=10.88p PS=7.2u
+ PD=13.2u
* device instance $1471 m0 *1 654.8,33.1 PMOS
XM$1471 \$I4068 \$I4069 VDD VDD PMOS L=1u W=3.4u AS=10.88p AD=6.46p PS=13.2u
+ PD=7.2u
* device instance $1472 m0 *1 659.6,33.1 PMOS
XM$1472 VDD \$I4068 \$I4069 VDD PMOS L=1u W=3.4u AS=6.46p AD=10.88p PS=7.2u
+ PD=13.2u
* device instance $1473 m0 *1 650,53.5 NMOS
XM$1473 BL27 WL1 \$I4068 VSS NMOS L=1u W=3.4u AS=10.88p AD=6.46p PS=13.2u
+ PD=7.2u
* device instance $1474 m0 *1 654.8,53.5 NMOS
XM$1474 \$I4068 \$I4069 VSS VSS NMOS L=1u W=3.4u AS=6.46p AD=6.46p PS=7.2u
+ PD=7.2u
* device instance $1475 m0 *1 659.6,53.5 NMOS
XM$1475 VSS \$I4068 \$I4069 VSS NMOS L=1u W=3.4u AS=6.46p AD=6.46p PS=7.2u
+ PD=7.2u
* device instance $1476 m0 *1 664.4,53.5 NMOS
XM$1476 \$I4069 WL1 BLB27 VSS NMOS L=1u W=3.4u AS=6.46p AD=10.88p PS=7.2u
+ PD=13.2u
* device instance $1477 m0 *1 678,33.1 PMOS
XM$1477 \$I4070 \$I4071 VDD VDD PMOS L=1u W=3.4u AS=10.88p AD=6.46p PS=13.2u
+ PD=7.2u
* device instance $1478 m0 *1 682.8,33.1 PMOS
XM$1478 VDD \$I4070 \$I4071 VDD PMOS L=1u W=3.4u AS=6.46p AD=10.88p PS=7.2u
+ PD=13.2u
* device instance $1479 m0 *1 673.2,53.5 NMOS
XM$1479 BL28 WL1 \$I4070 VSS NMOS L=1u W=3.4u AS=10.88p AD=6.46p PS=13.2u
+ PD=7.2u
* device instance $1480 m0 *1 678,53.5 NMOS
XM$1480 \$I4070 \$I4071 VSS VSS NMOS L=1u W=3.4u AS=6.46p AD=6.46p PS=7.2u
+ PD=7.2u
* device instance $1481 m0 *1 682.8,53.5 NMOS
XM$1481 VSS \$I4070 \$I4071 VSS NMOS L=1u W=3.4u AS=6.46p AD=6.46p PS=7.2u
+ PD=7.2u
* device instance $1482 m0 *1 687.6,53.5 NMOS
XM$1482 \$I4071 WL1 BLB28 VSS NMOS L=1u W=3.4u AS=6.46p AD=10.88p PS=7.2u
+ PD=13.2u
* device instance $1483 m0 *1 701.2,33.1 PMOS
XM$1483 \$I4072 \$I4073 VDD VDD PMOS L=1u W=3.4u AS=10.88p AD=6.46p PS=13.2u
+ PD=7.2u
* device instance $1484 m0 *1 706,33.1 PMOS
XM$1484 VDD \$I4072 \$I4073 VDD PMOS L=1u W=3.4u AS=6.46p AD=10.88p PS=7.2u
+ PD=13.2u
* device instance $1485 m0 *1 696.4,53.5 NMOS
XM$1485 BL29 WL1 \$I4072 VSS NMOS L=1u W=3.4u AS=10.88p AD=6.46p PS=13.2u
+ PD=7.2u
* device instance $1486 m0 *1 701.2,53.5 NMOS
XM$1486 \$I4072 \$I4073 VSS VSS NMOS L=1u W=3.4u AS=6.46p AD=6.46p PS=7.2u
+ PD=7.2u
* device instance $1487 m0 *1 706,53.5 NMOS
XM$1487 VSS \$I4072 \$I4073 VSS NMOS L=1u W=3.4u AS=6.46p AD=6.46p PS=7.2u
+ PD=7.2u
* device instance $1488 m0 *1 710.8,53.5 NMOS
XM$1488 \$I4073 WL1 BLB29 VSS NMOS L=1u W=3.4u AS=6.46p AD=10.88p PS=7.2u
+ PD=13.2u
* device instance $1489 m0 *1 724.4,33.1 PMOS
XM$1489 \$I4074 \$I4075 VDD VDD PMOS L=1u W=3.4u AS=10.88p AD=6.46p PS=13.2u
+ PD=7.2u
* device instance $1490 m0 *1 729.2,33.1 PMOS
XM$1490 VDD \$I4074 \$I4075 VDD PMOS L=1u W=3.4u AS=6.46p AD=10.88p PS=7.2u
+ PD=13.2u
* device instance $1491 m0 *1 719.6,53.5 NMOS
XM$1491 BL30 WL1 \$I4074 VSS NMOS L=1u W=3.4u AS=10.88p AD=6.46p PS=13.2u
+ PD=7.2u
* device instance $1492 m0 *1 724.4,53.5 NMOS
XM$1492 \$I4074 \$I4075 VSS VSS NMOS L=1u W=3.4u AS=6.46p AD=6.46p PS=7.2u
+ PD=7.2u
* device instance $1493 m0 *1 729.2,53.5 NMOS
XM$1493 VSS \$I4074 \$I4075 VSS NMOS L=1u W=3.4u AS=6.46p AD=6.46p PS=7.2u
+ PD=7.2u
* device instance $1494 m0 *1 734,53.5 NMOS
XM$1494 \$I4075 WL1 BLB30 VSS NMOS L=1u W=3.4u AS=6.46p AD=10.88p PS=7.2u
+ PD=13.2u
* device instance $1495 m0 *1 747.6,33.1 PMOS
XM$1495 \$I4076 \$I4077 VDD VDD PMOS L=1u W=3.4u AS=10.88p AD=6.46p PS=13.2u
+ PD=7.2u
* device instance $1496 m0 *1 752.4,33.1 PMOS
XM$1496 VDD \$I4076 \$I4077 VDD PMOS L=1u W=3.4u AS=6.46p AD=10.88p PS=7.2u
+ PD=13.2u
* device instance $1497 m0 *1 742.8,53.5 NMOS
XM$1497 BL31 WL1 \$I4076 VSS NMOS L=1u W=3.4u AS=10.88p AD=6.46p PS=13.2u
+ PD=7.2u
* device instance $1498 m0 *1 747.6,53.5 NMOS
XM$1498 \$I4076 \$I4077 VSS VSS NMOS L=1u W=3.4u AS=6.46p AD=6.46p PS=7.2u
+ PD=7.2u
* device instance $1499 m0 *1 752.4,53.5 NMOS
XM$1499 VSS \$I4076 \$I4077 VSS NMOS L=1u W=3.4u AS=6.46p AD=6.46p PS=7.2u
+ PD=7.2u
* device instance $1500 m0 *1 757.2,53.5 NMOS
XM$1500 \$I4077 WL1 BLB31 VSS NMOS L=1u W=3.4u AS=6.46p AD=10.88p PS=7.2u
+ PD=13.2u
* device instance $1501 m0 *1 608.4,447.5 PMOS
XM$1501 \$I4078 \$I4079 VDD VDD PMOS L=1u W=3.4u AS=10.88p AD=6.46p PS=13.2u
+ PD=7.2u
* device instance $1502 m0 *1 613.2,447.5 PMOS
XM$1502 VDD \$I4078 \$I4079 VDD PMOS L=1u W=3.4u AS=6.46p AD=10.88p PS=7.2u
+ PD=13.2u
* device instance $1503 m0 *1 603.6,467.9 NMOS
XM$1503 BL25 WL15 \$I4078 VSS NMOS L=1u W=3.4u AS=10.88p AD=6.46p PS=13.2u
+ PD=7.2u
* device instance $1504 m0 *1 608.4,467.9 NMOS
XM$1504 \$I4078 \$I4079 VSS VSS NMOS L=1u W=3.4u AS=6.46p AD=6.46p PS=7.2u
+ PD=7.2u
* device instance $1505 m0 *1 613.2,467.9 NMOS
XM$1505 VSS \$I4078 \$I4079 VSS NMOS L=1u W=3.4u AS=6.46p AD=6.46p PS=7.2u
+ PD=7.2u
* device instance $1506 m0 *1 618,467.9 NMOS
XM$1506 \$I4079 WL15 BLB25 VSS NMOS L=1u W=3.4u AS=6.46p AD=10.88p PS=7.2u
+ PD=13.2u
* device instance $1507 m0 *1 492.4,447.5 PMOS
XM$1507 \$I4080 \$I4081 VDD VDD PMOS L=1u W=3.4u AS=10.88p AD=6.46p PS=13.2u
+ PD=7.2u
* device instance $1508 m0 *1 497.2,447.5 PMOS
XM$1508 VDD \$I4080 \$I4081 VDD PMOS L=1u W=3.4u AS=6.46p AD=10.88p PS=7.2u
+ PD=13.2u
* device instance $1509 m0 *1 487.6,467.9 NMOS
XM$1509 BL20 WL15 \$I4080 VSS NMOS L=1u W=3.4u AS=10.88p AD=6.46p PS=13.2u
+ PD=7.2u
* device instance $1510 m0 *1 492.4,467.9 NMOS
XM$1510 \$I4080 \$I4081 VSS VSS NMOS L=1u W=3.4u AS=6.46p AD=6.46p PS=7.2u
+ PD=7.2u
* device instance $1511 m0 *1 497.2,467.9 NMOS
XM$1511 VSS \$I4080 \$I4081 VSS NMOS L=1u W=3.4u AS=6.46p AD=6.46p PS=7.2u
+ PD=7.2u
* device instance $1512 m0 *1 502,467.9 NMOS
XM$1512 \$I4081 WL15 BLB20 VSS NMOS L=1u W=3.4u AS=6.46p AD=10.88p PS=7.2u
+ PD=13.2u
* device instance $1513 m0 *1 515.6,447.5 PMOS
XM$1513 \$I4082 \$I4083 VDD VDD PMOS L=1u W=3.4u AS=10.88p AD=6.46p PS=13.2u
+ PD=7.2u
* device instance $1514 m0 *1 520.4,447.5 PMOS
XM$1514 VDD \$I4082 \$I4083 VDD PMOS L=1u W=3.4u AS=6.46p AD=10.88p PS=7.2u
+ PD=13.2u
* device instance $1515 m0 *1 510.8,467.9 NMOS
XM$1515 BL21 WL15 \$I4082 VSS NMOS L=1u W=3.4u AS=10.88p AD=6.46p PS=13.2u
+ PD=7.2u
* device instance $1516 m0 *1 515.6,467.9 NMOS
XM$1516 \$I4082 \$I4083 VSS VSS NMOS L=1u W=3.4u AS=6.46p AD=6.46p PS=7.2u
+ PD=7.2u
* device instance $1517 m0 *1 520.4,467.9 NMOS
XM$1517 VSS \$I4082 \$I4083 VSS NMOS L=1u W=3.4u AS=6.46p AD=6.46p PS=7.2u
+ PD=7.2u
* device instance $1518 m0 *1 525.2,467.9 NMOS
XM$1518 \$I4083 WL15 BLB21 VSS NMOS L=1u W=3.4u AS=6.46p AD=10.88p PS=7.2u
+ PD=13.2u
* device instance $1519 m0 *1 538.8,447.5 PMOS
XM$1519 \$I4084 \$I4085 VDD VDD PMOS L=1u W=3.4u AS=10.88p AD=6.46p PS=13.2u
+ PD=7.2u
* device instance $1520 m0 *1 543.6,447.5 PMOS
XM$1520 VDD \$I4084 \$I4085 VDD PMOS L=1u W=3.4u AS=6.46p AD=10.88p PS=7.2u
+ PD=13.2u
* device instance $1521 m0 *1 534,467.9 NMOS
XM$1521 BL22 WL15 \$I4084 VSS NMOS L=1u W=3.4u AS=10.88p AD=6.46p PS=13.2u
+ PD=7.2u
* device instance $1522 m0 *1 538.8,467.9 NMOS
XM$1522 \$I4084 \$I4085 VSS VSS NMOS L=1u W=3.4u AS=6.46p AD=6.46p PS=7.2u
+ PD=7.2u
* device instance $1523 m0 *1 543.6,467.9 NMOS
XM$1523 VSS \$I4084 \$I4085 VSS NMOS L=1u W=3.4u AS=6.46p AD=6.46p PS=7.2u
+ PD=7.2u
* device instance $1524 m0 *1 548.4,467.9 NMOS
XM$1524 \$I4085 WL15 BLB22 VSS NMOS L=1u W=3.4u AS=6.46p AD=10.88p PS=7.2u
+ PD=13.2u
* device instance $1525 m0 *1 262.4,92.3 PMOS
XM$1525 \$I4086 \$I4087 VDD VDD PMOS L=1u W=3.4u AS=10.88p AD=6.46p PS=13.2u
+ PD=7.2u
* device instance $1526 m0 *1 267.2,92.3 PMOS
XM$1526 VDD \$I4086 \$I4087 VDD PMOS L=1u W=3.4u AS=6.46p AD=10.88p PS=7.2u
+ PD=13.2u
* device instance $1527 m0 *1 257.6,112.7 NMOS
XM$1527 BL11 WL3 \$I4086 VSS NMOS L=1u W=3.4u AS=10.88p AD=6.46p PS=13.2u
+ PD=7.2u
* device instance $1528 m0 *1 262.4,112.7 NMOS
XM$1528 \$I4086 \$I4087 VSS VSS NMOS L=1u W=3.4u AS=6.46p AD=6.46p PS=7.2u
+ PD=7.2u
* device instance $1529 m0 *1 267.2,112.7 NMOS
XM$1529 VSS \$I4086 \$I4087 VSS NMOS L=1u W=3.4u AS=6.46p AD=6.46p PS=7.2u
+ PD=7.2u
* device instance $1530 m0 *1 272,112.7 NMOS
XM$1530 \$I4087 WL3 BLB11 VSS NMOS L=1u W=3.4u AS=6.46p AD=10.88p PS=7.2u
+ PD=13.2u
* device instance $1531 m0 *1 538.8,269.9 PMOS
XM$1531 \$I4088 \$I4089 VDD VDD PMOS L=1u W=3.4u AS=10.88p AD=6.46p PS=13.2u
+ PD=7.2u
* device instance $1532 m0 *1 543.6,269.9 PMOS
XM$1532 VDD \$I4088 \$I4089 VDD PMOS L=1u W=3.4u AS=6.46p AD=10.88p PS=7.2u
+ PD=13.2u
* device instance $1533 m0 *1 534,290.3 NMOS
XM$1533 BL22 WL9 \$I4088 VSS NMOS L=1u W=3.4u AS=10.88p AD=6.46p PS=13.2u
+ PD=7.2u
* device instance $1534 m0 *1 538.8,290.3 NMOS
XM$1534 \$I4088 \$I4089 VSS VSS NMOS L=1u W=3.4u AS=6.46p AD=6.46p PS=7.2u
+ PD=7.2u
* device instance $1535 m0 *1 543.6,290.3 NMOS
XM$1535 VSS \$I4088 \$I4089 VSS NMOS L=1u W=3.4u AS=6.46p AD=6.46p PS=7.2u
+ PD=7.2u
* device instance $1536 m0 *1 548.4,290.3 NMOS
XM$1536 \$I4089 WL9 BLB22 VSS NMOS L=1u W=3.4u AS=6.46p AD=10.88p PS=7.2u
+ PD=13.2u
* device instance $1537 m0 *1 747.6,151.5 PMOS
XM$1537 \$I4090 \$I4091 VDD VDD PMOS L=1u W=3.4u AS=10.88p AD=6.46p PS=13.2u
+ PD=7.2u
* device instance $1538 m0 *1 752.4,151.5 PMOS
XM$1538 VDD \$I4090 \$I4091 VDD PMOS L=1u W=3.4u AS=6.46p AD=10.88p PS=7.2u
+ PD=13.2u
* device instance $1539 m0 *1 742.8,171.9 NMOS
XM$1539 BL31 WL5 \$I4090 VSS NMOS L=1u W=3.4u AS=10.88p AD=6.46p PS=13.2u
+ PD=7.2u
* device instance $1540 m0 *1 747.6,171.9 NMOS
XM$1540 \$I4090 \$I4091 VSS VSS NMOS L=1u W=3.4u AS=6.46p AD=6.46p PS=7.2u
+ PD=7.2u
* device instance $1541 m0 *1 752.4,171.9 NMOS
XM$1541 VSS \$I4090 \$I4091 VSS NMOS L=1u W=3.4u AS=6.46p AD=6.46p PS=7.2u
+ PD=7.2u
* device instance $1542 m0 *1 757.2,171.9 NMOS
XM$1542 \$I4091 WL5 BLB31 VSS NMOS L=1u W=3.4u AS=6.46p AD=10.88p PS=7.2u
+ PD=13.2u
* device instance $1543 m0 *1 355.2,92.3 PMOS
XM$1543 \$I4092 \$I4093 VDD VDD PMOS L=1u W=3.4u AS=10.88p AD=6.46p PS=13.2u
+ PD=7.2u
* device instance $1544 m0 *1 360,92.3 PMOS
XM$1544 VDD \$I4092 \$I4093 VDD PMOS L=1u W=3.4u AS=6.46p AD=10.88p PS=7.2u
+ PD=13.2u
* device instance $1545 m0 *1 350.4,112.7 NMOS
XM$1545 BL15 WL3 \$I4092 VSS NMOS L=1u W=3.4u AS=10.88p AD=6.46p PS=13.2u
+ PD=7.2u
* device instance $1546 m0 *1 355.2,112.7 NMOS
XM$1546 \$I4092 \$I4093 VSS VSS NMOS L=1u W=3.4u AS=6.46p AD=6.46p PS=7.2u
+ PD=7.2u
* device instance $1547 m0 *1 360,112.7 NMOS
XM$1547 VSS \$I4092 \$I4093 VSS NMOS L=1u W=3.4u AS=6.46p AD=6.46p PS=7.2u
+ PD=7.2u
* device instance $1548 m0 *1 364.8,112.7 NMOS
XM$1548 \$I4093 WL3 BLB15 VSS NMOS L=1u W=3.4u AS=6.46p AD=10.88p PS=7.2u
+ PD=13.2u
* device instance $1549 m0 *1 469.2,210.7 PMOS
XM$1549 \$I4094 \$I4095 VDD VDD PMOS L=1u W=3.4u AS=10.88p AD=6.46p PS=13.2u
+ PD=7.2u
* device instance $1550 m0 *1 474,210.7 PMOS
XM$1550 VDD \$I4094 \$I4095 VDD PMOS L=1u W=3.4u AS=6.46p AD=10.88p PS=7.2u
+ PD=13.2u
* device instance $1551 m0 *1 464.4,231.1 NMOS
XM$1551 BL19 WL7 \$I4094 VSS NMOS L=1u W=3.4u AS=10.88p AD=6.46p PS=13.2u
+ PD=7.2u
* device instance $1552 m0 *1 469.2,231.1 NMOS
XM$1552 \$I4094 \$I4095 VSS VSS NMOS L=1u W=3.4u AS=6.46p AD=6.46p PS=7.2u
+ PD=7.2u
* device instance $1553 m0 *1 474,231.1 NMOS
XM$1553 VSS \$I4094 \$I4095 VSS NMOS L=1u W=3.4u AS=6.46p AD=6.46p PS=7.2u
+ PD=7.2u
* device instance $1554 m0 *1 478.8,231.1 NMOS
XM$1554 \$I4095 WL7 BLB19 VSS NMOS L=1u W=3.4u AS=6.46p AD=10.88p PS=7.2u
+ PD=13.2u
* device instance $1555 m0 *1 285.6,92.3 PMOS
XM$1555 \$I4096 \$I4097 VDD VDD PMOS L=1u W=3.4u AS=10.88p AD=6.46p PS=13.2u
+ PD=7.2u
* device instance $1556 m0 *1 290.4,92.3 PMOS
XM$1556 VDD \$I4096 \$I4097 VDD PMOS L=1u W=3.4u AS=6.46p AD=10.88p PS=7.2u
+ PD=13.2u
* device instance $1557 m0 *1 280.8,112.7 NMOS
XM$1557 BL12 WL3 \$I4096 VSS NMOS L=1u W=3.4u AS=10.88p AD=6.46p PS=13.2u
+ PD=7.2u
* device instance $1558 m0 *1 285.6,112.7 NMOS
XM$1558 \$I4096 \$I4097 VSS VSS NMOS L=1u W=3.4u AS=6.46p AD=6.46p PS=7.2u
+ PD=7.2u
* device instance $1559 m0 *1 290.4,112.7 NMOS
XM$1559 VSS \$I4096 \$I4097 VSS NMOS L=1u W=3.4u AS=6.46p AD=6.46p PS=7.2u
+ PD=7.2u
* device instance $1560 m0 *1 295.2,112.7 NMOS
XM$1560 \$I4097 WL3 BLB12 VSS NMOS L=1u W=3.4u AS=6.46p AD=10.88p PS=7.2u
+ PD=13.2u
* device instance $1561 m0 *1 562,210.7 PMOS
XM$1561 \$I4098 \$I4099 VDD VDD PMOS L=1u W=3.4u AS=10.88p AD=6.46p PS=13.2u
+ PD=7.2u
* device instance $1562 m0 *1 566.8,210.7 PMOS
XM$1562 VDD \$I4098 \$I4099 VDD PMOS L=1u W=3.4u AS=6.46p AD=10.88p PS=7.2u
+ PD=13.2u
* device instance $1563 m0 *1 557.2,231.1 NMOS
XM$1563 BL23 WL7 \$I4098 VSS NMOS L=1u W=3.4u AS=10.88p AD=6.46p PS=13.2u
+ PD=7.2u
* device instance $1564 m0 *1 562,231.1 NMOS
XM$1564 \$I4098 \$I4099 VSS VSS NMOS L=1u W=3.4u AS=6.46p AD=6.46p PS=7.2u
+ PD=7.2u
* device instance $1565 m0 *1 566.8,231.1 NMOS
XM$1565 VSS \$I4098 \$I4099 VSS NMOS L=1u W=3.4u AS=6.46p AD=6.46p PS=7.2u
+ PD=7.2u
* device instance $1566 m0 *1 571.6,231.1 NMOS
XM$1566 \$I4099 WL7 BLB23 VSS NMOS L=1u W=3.4u AS=6.46p AD=10.88p PS=7.2u
+ PD=13.2u
* device instance $1567 m0 *1 562,33.1 PMOS
XM$1567 \$I4100 \$I4101 VDD VDD PMOS L=1u W=3.4u AS=10.88p AD=6.46p PS=13.2u
+ PD=7.2u
* device instance $1568 m0 *1 566.8,33.1 PMOS
XM$1568 VDD \$I4100 \$I4101 VDD PMOS L=1u W=3.4u AS=6.46p AD=10.88p PS=7.2u
+ PD=13.2u
* device instance $1569 m0 *1 557.2,53.5 NMOS
XM$1569 BL23 WL1 \$I4100 VSS NMOS L=1u W=3.4u AS=10.88p AD=6.46p PS=13.2u
+ PD=7.2u
* device instance $1570 m0 *1 562,53.5 NMOS
XM$1570 \$I4100 \$I4101 VSS VSS NMOS L=1u W=3.4u AS=6.46p AD=6.46p PS=7.2u
+ PD=7.2u
* device instance $1571 m0 *1 566.8,53.5 NMOS
XM$1571 VSS \$I4100 \$I4101 VSS NMOS L=1u W=3.4u AS=6.46p AD=6.46p PS=7.2u
+ PD=7.2u
* device instance $1572 m0 *1 571.6,53.5 NMOS
XM$1572 \$I4101 WL1 BLB23 VSS NMOS L=1u W=3.4u AS=6.46p AD=10.88p PS=7.2u
+ PD=13.2u
* device instance $1573 m0 *1 332,92.3 PMOS
XM$1573 \$I4102 \$I4103 VDD VDD PMOS L=1u W=3.4u AS=10.88p AD=6.46p PS=13.2u
+ PD=7.2u
* device instance $1574 m0 *1 336.8,92.3 PMOS
XM$1574 VDD \$I4102 \$I4103 VDD PMOS L=1u W=3.4u AS=6.46p AD=10.88p PS=7.2u
+ PD=13.2u
* device instance $1575 m0 *1 327.2,112.7 NMOS
XM$1575 BL14 WL3 \$I4102 VSS NMOS L=1u W=3.4u AS=10.88p AD=6.46p PS=13.2u
+ PD=7.2u
* device instance $1576 m0 *1 332,112.7 NMOS
XM$1576 \$I4102 \$I4103 VSS VSS NMOS L=1u W=3.4u AS=6.46p AD=6.46p PS=7.2u
+ PD=7.2u
* device instance $1577 m0 *1 336.8,112.7 NMOS
XM$1577 VSS \$I4102 \$I4103 VSS NMOS L=1u W=3.4u AS=6.46p AD=6.46p PS=7.2u
+ PD=7.2u
* device instance $1578 m0 *1 341.6,112.7 NMOS
XM$1578 \$I4103 WL3 BLB14 VSS NMOS L=1u W=3.4u AS=6.46p AD=10.88p PS=7.2u
+ PD=13.2u
* device instance $1579 m0 *1 562,92.3 PMOS
XM$1579 \$I4104 \$I4105 VDD VDD PMOS L=1u W=3.4u AS=10.88p AD=6.46p PS=13.2u
+ PD=7.2u
* device instance $1580 m0 *1 566.8,92.3 PMOS
XM$1580 VDD \$I4104 \$I4105 VDD PMOS L=1u W=3.4u AS=6.46p AD=10.88p PS=7.2u
+ PD=13.2u
* device instance $1581 m0 *1 557.2,112.7 NMOS
XM$1581 BL23 WL3 \$I4104 VSS NMOS L=1u W=3.4u AS=10.88p AD=6.46p PS=13.2u
+ PD=7.2u
* device instance $1582 m0 *1 562,112.7 NMOS
XM$1582 \$I4104 \$I4105 VSS VSS NMOS L=1u W=3.4u AS=6.46p AD=6.46p PS=7.2u
+ PD=7.2u
* device instance $1583 m0 *1 566.8,112.7 NMOS
XM$1583 VSS \$I4104 \$I4105 VSS NMOS L=1u W=3.4u AS=6.46p AD=6.46p PS=7.2u
+ PD=7.2u
* device instance $1584 m0 *1 571.6,112.7 NMOS
XM$1584 \$I4105 WL3 BLB23 VSS NMOS L=1u W=3.4u AS=6.46p AD=10.88p PS=7.2u
+ PD=13.2u
* device instance $1585 m0 *1 308.8,92.3 PMOS
XM$1585 \$I4106 \$I4107 VDD VDD PMOS L=1u W=3.4u AS=10.88p AD=6.46p PS=13.2u
+ PD=7.2u
* device instance $1586 m0 *1 313.6,92.3 PMOS
XM$1586 VDD \$I4106 \$I4107 VDD PMOS L=1u W=3.4u AS=6.46p AD=10.88p PS=7.2u
+ PD=13.2u
* device instance $1587 m0 *1 304,112.7 NMOS
XM$1587 BL13 WL3 \$I4106 VSS NMOS L=1u W=3.4u AS=10.88p AD=6.46p PS=13.2u
+ PD=7.2u
* device instance $1588 m0 *1 308.8,112.7 NMOS
XM$1588 \$I4106 \$I4107 VSS VSS NMOS L=1u W=3.4u AS=6.46p AD=6.46p PS=7.2u
+ PD=7.2u
* device instance $1589 m0 *1 313.6,112.7 NMOS
XM$1589 VSS \$I4106 \$I4107 VSS NMOS L=1u W=3.4u AS=6.46p AD=6.46p PS=7.2u
+ PD=7.2u
* device instance $1590 m0 *1 318.4,112.7 NMOS
XM$1590 \$I4107 WL3 BLB13 VSS NMOS L=1u W=3.4u AS=6.46p AD=10.88p PS=7.2u
+ PD=13.2u
* device instance $1591 m0 *1 678,151.5 PMOS
XM$1591 \$I4108 \$I4109 VDD VDD PMOS L=1u W=3.4u AS=10.88p AD=6.46p PS=13.2u
+ PD=7.2u
* device instance $1592 m0 *1 682.8,151.5 PMOS
XM$1592 VDD \$I4108 \$I4109 VDD PMOS L=1u W=3.4u AS=6.46p AD=10.88p PS=7.2u
+ PD=13.2u
* device instance $1593 m0 *1 673.2,171.9 NMOS
XM$1593 BL28 WL5 \$I4108 VSS NMOS L=1u W=3.4u AS=10.88p AD=6.46p PS=13.2u
+ PD=7.2u
* device instance $1594 m0 *1 678,171.9 NMOS
XM$1594 \$I4108 \$I4109 VSS VSS NMOS L=1u W=3.4u AS=6.46p AD=6.46p PS=7.2u
+ PD=7.2u
* device instance $1595 m0 *1 682.8,171.9 NMOS
XM$1595 VSS \$I4108 \$I4109 VSS NMOS L=1u W=3.4u AS=6.46p AD=6.46p PS=7.2u
+ PD=7.2u
* device instance $1596 m0 *1 687.6,171.9 NMOS
XM$1596 \$I4109 WL5 BLB28 VSS NMOS L=1u W=3.4u AS=6.46p AD=10.88p PS=7.2u
+ PD=13.2u
* device instance $1597 m0 *1 701.2,151.5 PMOS
XM$1597 \$I4110 \$I4111 VDD VDD PMOS L=1u W=3.4u AS=10.88p AD=6.46p PS=13.2u
+ PD=7.2u
* device instance $1598 m0 *1 706,151.5 PMOS
XM$1598 VDD \$I4110 \$I4111 VDD PMOS L=1u W=3.4u AS=6.46p AD=10.88p PS=7.2u
+ PD=13.2u
* device instance $1599 m0 *1 696.4,171.9 NMOS
XM$1599 BL29 WL5 \$I4110 VSS NMOS L=1u W=3.4u AS=10.88p AD=6.46p PS=13.2u
+ PD=7.2u
* device instance $1600 m0 *1 701.2,171.9 NMOS
XM$1600 \$I4110 \$I4111 VSS VSS NMOS L=1u W=3.4u AS=6.46p AD=6.46p PS=7.2u
+ PD=7.2u
* device instance $1601 m0 *1 706,171.9 NMOS
XM$1601 VSS \$I4110 \$I4111 VSS NMOS L=1u W=3.4u AS=6.46p AD=6.46p PS=7.2u
+ PD=7.2u
* device instance $1602 m0 *1 710.8,171.9 NMOS
XM$1602 \$I4111 WL5 BLB29 VSS NMOS L=1u W=3.4u AS=6.46p AD=10.88p PS=7.2u
+ PD=13.2u
* device instance $1603 m0 *1 724.4,151.5 PMOS
XM$1603 \$I4112 \$I4113 VDD VDD PMOS L=1u W=3.4u AS=10.88p AD=6.46p PS=13.2u
+ PD=7.2u
* device instance $1604 m0 *1 729.2,151.5 PMOS
XM$1604 VDD \$I4112 \$I4113 VDD PMOS L=1u W=3.4u AS=6.46p AD=10.88p PS=7.2u
+ PD=13.2u
* device instance $1605 m0 *1 719.6,171.9 NMOS
XM$1605 BL30 WL5 \$I4112 VSS NMOS L=1u W=3.4u AS=10.88p AD=6.46p PS=13.2u
+ PD=7.2u
* device instance $1606 m0 *1 724.4,171.9 NMOS
XM$1606 \$I4112 \$I4113 VSS VSS NMOS L=1u W=3.4u AS=6.46p AD=6.46p PS=7.2u
+ PD=7.2u
* device instance $1607 m0 *1 729.2,171.9 NMOS
XM$1607 VSS \$I4112 \$I4113 VSS NMOS L=1u W=3.4u AS=6.46p AD=6.46p PS=7.2u
+ PD=7.2u
* device instance $1608 m0 *1 734,171.9 NMOS
XM$1608 \$I4113 WL5 BLB30 VSS NMOS L=1u W=3.4u AS=6.46p AD=10.88p PS=7.2u
+ PD=13.2u
* device instance $1609 m0 *1 562,151.5 PMOS
XM$1609 \$I4114 \$I4115 VDD VDD PMOS L=1u W=3.4u AS=10.88p AD=6.46p PS=13.2u
+ PD=7.2u
* device instance $1610 m0 *1 566.8,151.5 PMOS
XM$1610 VDD \$I4114 \$I4115 VDD PMOS L=1u W=3.4u AS=6.46p AD=10.88p PS=7.2u
+ PD=13.2u
* device instance $1611 m0 *1 557.2,171.9 NMOS
XM$1611 BL23 WL5 \$I4114 VSS NMOS L=1u W=3.4u AS=10.88p AD=6.46p PS=13.2u
+ PD=7.2u
* device instance $1612 m0 *1 562,171.9 NMOS
XM$1612 \$I4114 \$I4115 VSS VSS NMOS L=1u W=3.4u AS=6.46p AD=6.46p PS=7.2u
+ PD=7.2u
* device instance $1613 m0 *1 566.8,171.9 NMOS
XM$1613 VSS \$I4114 \$I4115 VSS NMOS L=1u W=3.4u AS=6.46p AD=6.46p PS=7.2u
+ PD=7.2u
* device instance $1614 m0 *1 571.6,171.9 NMOS
XM$1614 \$I4115 WL5 BLB23 VSS NMOS L=1u W=3.4u AS=6.46p AD=10.88p PS=7.2u
+ PD=13.2u
* device instance $1615 m0 *1 422.8,388.3 PMOS
XM$1615 \$I4116 \$I4117 VDD VDD PMOS L=1u W=3.4u AS=10.88p AD=6.46p PS=13.2u
+ PD=7.2u
* device instance $1616 m0 *1 427.6,388.3 PMOS
XM$1616 VDD \$I4116 \$I4117 VDD PMOS L=1u W=3.4u AS=6.46p AD=10.88p PS=7.2u
+ PD=13.2u
* device instance $1617 m0 *1 418,408.7 NMOS
XM$1617 BL17 WL13 \$I4116 VSS NMOS L=1u W=3.4u AS=10.88p AD=6.46p PS=13.2u
+ PD=7.2u
* device instance $1618 m0 *1 422.8,408.7 NMOS
XM$1618 \$I4116 \$I4117 VSS VSS NMOS L=1u W=3.4u AS=6.46p AD=6.46p PS=7.2u
+ PD=7.2u
* device instance $1619 m0 *1 427.6,408.7 NMOS
XM$1619 VSS \$I4116 \$I4117 VSS NMOS L=1u W=3.4u AS=6.46p AD=6.46p PS=7.2u
+ PD=7.2u
* device instance $1620 m0 *1 432.4,408.7 NMOS
XM$1620 \$I4117 WL13 BLB17 VSS NMOS L=1u W=3.4u AS=6.46p AD=10.88p PS=7.2u
+ PD=13.2u
* device instance $1621 m0 *1 399.6,388.3 PMOS
XM$1621 \$I4118 \$I4119 VDD VDD PMOS L=1u W=3.4u AS=10.88p AD=6.46p PS=13.2u
+ PD=7.2u
* device instance $1622 m0 *1 404.4,388.3 PMOS
XM$1622 VDD \$I4118 \$I4119 VDD PMOS L=1u W=3.4u AS=6.46p AD=10.88p PS=7.2u
+ PD=13.2u
* device instance $1623 m0 *1 394.8,408.7 NMOS
XM$1623 BL16 WL13 \$I4118 VSS NMOS L=1u W=3.4u AS=10.88p AD=6.46p PS=13.2u
+ PD=7.2u
* device instance $1624 m0 *1 399.6,408.7 NMOS
XM$1624 \$I4118 \$I4119 VSS VSS NMOS L=1u W=3.4u AS=6.46p AD=6.46p PS=7.2u
+ PD=7.2u
* device instance $1625 m0 *1 404.4,408.7 NMOS
XM$1625 VSS \$I4118 \$I4119 VSS NMOS L=1u W=3.4u AS=6.46p AD=6.46p PS=7.2u
+ PD=7.2u
* device instance $1626 m0 *1 409.2,408.7 NMOS
XM$1626 \$I4119 WL13 BLB16 VSS NMOS L=1u W=3.4u AS=6.46p AD=10.88p PS=7.2u
+ PD=13.2u
* device instance $1627 m0 *1 446,388.3 PMOS
XM$1627 \$I4120 \$I4121 VDD VDD PMOS L=1u W=3.4u AS=10.88p AD=6.46p PS=13.2u
+ PD=7.2u
* device instance $1628 m0 *1 450.8,388.3 PMOS
XM$1628 VDD \$I4120 \$I4121 VDD PMOS L=1u W=3.4u AS=6.46p AD=10.88p PS=7.2u
+ PD=13.2u
* device instance $1629 m0 *1 441.2,408.7 NMOS
XM$1629 BL18 WL13 \$I4120 VSS NMOS L=1u W=3.4u AS=10.88p AD=6.46p PS=13.2u
+ PD=7.2u
* device instance $1630 m0 *1 446,408.7 NMOS
XM$1630 \$I4120 \$I4121 VSS VSS NMOS L=1u W=3.4u AS=6.46p AD=6.46p PS=7.2u
+ PD=7.2u
* device instance $1631 m0 *1 450.8,408.7 NMOS
XM$1631 VSS \$I4120 \$I4121 VSS NMOS L=1u W=3.4u AS=6.46p AD=6.46p PS=7.2u
+ PD=7.2u
* device instance $1632 m0 *1 455.6,408.7 NMOS
XM$1632 \$I4121 WL13 BLB18 VSS NMOS L=1u W=3.4u AS=6.46p AD=10.88p PS=7.2u
+ PD=13.2u
* device instance $1633 m0 *1 239.2,33.1 PMOS
XM$1633 \$I4122 \$I4123 VDD VDD PMOS L=1u W=3.4u AS=10.88p AD=6.46p PS=13.2u
+ PD=7.2u
* device instance $1634 m0 *1 244,33.1 PMOS
XM$1634 VDD \$I4122 \$I4123 VDD PMOS L=1u W=3.4u AS=6.46p AD=10.88p PS=7.2u
+ PD=13.2u
* device instance $1635 m0 *1 234.4,53.5 NMOS
XM$1635 BL10 WL1 \$I4122 VSS NMOS L=1u W=3.4u AS=10.88p AD=6.46p PS=13.2u
+ PD=7.2u
* device instance $1636 m0 *1 239.2,53.5 NMOS
XM$1636 \$I4122 \$I4123 VSS VSS NMOS L=1u W=3.4u AS=6.46p AD=6.46p PS=7.2u
+ PD=7.2u
* device instance $1637 m0 *1 244,53.5 NMOS
XM$1637 VSS \$I4122 \$I4123 VSS NMOS L=1u W=3.4u AS=6.46p AD=6.46p PS=7.2u
+ PD=7.2u
* device instance $1638 m0 *1 248.8,53.5 NMOS
XM$1638 \$I4123 WL1 BLB10 VSS NMOS L=1u W=3.4u AS=6.46p AD=10.88p PS=7.2u
+ PD=13.2u
* device instance $1639 m0 *1 216,33.1 PMOS
XM$1639 \$I4124 \$I4125 VDD VDD PMOS L=1u W=3.4u AS=10.88p AD=6.46p PS=13.2u
+ PD=7.2u
* device instance $1640 m0 *1 220.8,33.1 PMOS
XM$1640 VDD \$I4124 \$I4125 VDD PMOS L=1u W=3.4u AS=6.46p AD=10.88p PS=7.2u
+ PD=13.2u
* device instance $1641 m0 *1 211.2,53.5 NMOS
XM$1641 BL9 WL1 \$I4124 VSS NMOS L=1u W=3.4u AS=10.88p AD=6.46p PS=13.2u PD=7.2u
* device instance $1642 m0 *1 216,53.5 NMOS
XM$1642 \$I4124 \$I4125 VSS VSS NMOS L=1u W=3.4u AS=6.46p AD=6.46p PS=7.2u
+ PD=7.2u
* device instance $1643 m0 *1 220.8,53.5 NMOS
XM$1643 VSS \$I4124 \$I4125 VSS NMOS L=1u W=3.4u AS=6.46p AD=6.46p PS=7.2u
+ PD=7.2u
* device instance $1644 m0 *1 225.6,53.5 NMOS
XM$1644 \$I4125 WL1 BLB9 VSS NMOS L=1u W=3.4u AS=6.46p AD=10.88p PS=7.2u
+ PD=13.2u
* device instance $1645 m0 *1 492.4,269.9 PMOS
XM$1645 \$I4126 \$I4127 VDD VDD PMOS L=1u W=3.4u AS=10.88p AD=6.46p PS=13.2u
+ PD=7.2u
* device instance $1646 m0 *1 497.2,269.9 PMOS
XM$1646 VDD \$I4126 \$I4127 VDD PMOS L=1u W=3.4u AS=6.46p AD=10.88p PS=7.2u
+ PD=13.2u
* device instance $1647 m0 *1 487.6,290.3 NMOS
XM$1647 BL20 WL9 \$I4126 VSS NMOS L=1u W=3.4u AS=10.88p AD=6.46p PS=13.2u
+ PD=7.2u
* device instance $1648 m0 *1 492.4,290.3 NMOS
XM$1648 \$I4126 \$I4127 VSS VSS NMOS L=1u W=3.4u AS=6.46p AD=6.46p PS=7.2u
+ PD=7.2u
* device instance $1649 m0 *1 497.2,290.3 NMOS
XM$1649 VSS \$I4126 \$I4127 VSS NMOS L=1u W=3.4u AS=6.46p AD=6.46p PS=7.2u
+ PD=7.2u
* device instance $1650 m0 *1 502,290.3 NMOS
XM$1650 \$I4127 WL9 BLB20 VSS NMOS L=1u W=3.4u AS=6.46p AD=10.88p PS=7.2u
+ PD=13.2u
* device instance $1651 m0 *1 515.6,269.9 PMOS
XM$1651 \$I4128 \$I4129 VDD VDD PMOS L=1u W=3.4u AS=10.88p AD=6.46p PS=13.2u
+ PD=7.2u
* device instance $1652 m0 *1 520.4,269.9 PMOS
XM$1652 VDD \$I4128 \$I4129 VDD PMOS L=1u W=3.4u AS=6.46p AD=10.88p PS=7.2u
+ PD=13.2u
* device instance $1653 m0 *1 510.8,290.3 NMOS
XM$1653 BL21 WL9 \$I4128 VSS NMOS L=1u W=3.4u AS=10.88p AD=6.46p PS=13.2u
+ PD=7.2u
* device instance $1654 m0 *1 515.6,290.3 NMOS
XM$1654 \$I4128 \$I4129 VSS VSS NMOS L=1u W=3.4u AS=6.46p AD=6.46p PS=7.2u
+ PD=7.2u
* device instance $1655 m0 *1 520.4,290.3 NMOS
XM$1655 VSS \$I4128 \$I4129 VSS NMOS L=1u W=3.4u AS=6.46p AD=6.46p PS=7.2u
+ PD=7.2u
* device instance $1656 m0 *1 525.2,290.3 NMOS
XM$1656 \$I4129 WL9 BLB21 VSS NMOS L=1u W=3.4u AS=6.46p AD=10.88p PS=7.2u
+ PD=13.2u
* device instance $1657 m0 *1 216,92.3 PMOS
XM$1657 \$I4130 \$I4131 VDD VDD PMOS L=1u W=3.4u AS=10.88p AD=6.46p PS=13.2u
+ PD=7.2u
* device instance $1658 m0 *1 220.8,92.3 PMOS
XM$1658 VDD \$I4130 \$I4131 VDD PMOS L=1u W=3.4u AS=6.46p AD=10.88p PS=7.2u
+ PD=13.2u
* device instance $1659 m0 *1 211.2,112.7 NMOS
XM$1659 BL9 WL3 \$I4130 VSS NMOS L=1u W=3.4u AS=10.88p AD=6.46p PS=13.2u PD=7.2u
* device instance $1660 m0 *1 216,112.7 NMOS
XM$1660 \$I4130 \$I4131 VSS VSS NMOS L=1u W=3.4u AS=6.46p AD=6.46p PS=7.2u
+ PD=7.2u
* device instance $1661 m0 *1 220.8,112.7 NMOS
XM$1661 VSS \$I4130 \$I4131 VSS NMOS L=1u W=3.4u AS=6.46p AD=6.46p PS=7.2u
+ PD=7.2u
* device instance $1662 m0 *1 225.6,112.7 NMOS
XM$1662 \$I4131 WL3 BLB9 VSS NMOS L=1u W=3.4u AS=6.46p AD=10.88p PS=7.2u
+ PD=13.2u
* device instance $1663 m0 *1 469.2,447.5 PMOS
XM$1663 \$I4132 \$I4133 VDD VDD PMOS L=1u W=3.4u AS=10.88p AD=6.46p PS=13.2u
+ PD=7.2u
* device instance $1664 m0 *1 474,447.5 PMOS
XM$1664 VDD \$I4132 \$I4133 VDD PMOS L=1u W=3.4u AS=6.46p AD=10.88p PS=7.2u
+ PD=13.2u
* device instance $1665 m0 *1 464.4,467.9 NMOS
XM$1665 BL19 WL15 \$I4132 VSS NMOS L=1u W=3.4u AS=10.88p AD=6.46p PS=13.2u
+ PD=7.2u
* device instance $1666 m0 *1 469.2,467.9 NMOS
XM$1666 \$I4132 \$I4133 VSS VSS NMOS L=1u W=3.4u AS=6.46p AD=6.46p PS=7.2u
+ PD=7.2u
* device instance $1667 m0 *1 474,467.9 NMOS
XM$1667 VSS \$I4132 \$I4133 VSS NMOS L=1u W=3.4u AS=6.46p AD=6.46p PS=7.2u
+ PD=7.2u
* device instance $1668 m0 *1 478.8,467.9 NMOS
XM$1668 \$I4133 WL15 BLB19 VSS NMOS L=1u W=3.4u AS=6.46p AD=10.88p PS=7.2u
+ PD=13.2u
* device instance $1669 m0 *1 701.2,210.7 PMOS
XM$1669 \$I4134 \$I4135 VDD VDD PMOS L=1u W=3.4u AS=10.88p AD=6.46p PS=13.2u
+ PD=7.2u
* device instance $1670 m0 *1 706,210.7 PMOS
XM$1670 VDD \$I4134 \$I4135 VDD PMOS L=1u W=3.4u AS=6.46p AD=10.88p PS=7.2u
+ PD=13.2u
* device instance $1671 m0 *1 696.4,231.1 NMOS
XM$1671 BL29 WL7 \$I4134 VSS NMOS L=1u W=3.4u AS=10.88p AD=6.46p PS=13.2u
+ PD=7.2u
* device instance $1672 m0 *1 701.2,231.1 NMOS
XM$1672 \$I4134 \$I4135 VSS VSS NMOS L=1u W=3.4u AS=6.46p AD=6.46p PS=7.2u
+ PD=7.2u
* device instance $1673 m0 *1 706,231.1 NMOS
XM$1673 VSS \$I4134 \$I4135 VSS NMOS L=1u W=3.4u AS=6.46p AD=6.46p PS=7.2u
+ PD=7.2u
* device instance $1674 m0 *1 710.8,231.1 NMOS
XM$1674 \$I4135 WL7 BLB29 VSS NMOS L=1u W=3.4u AS=6.46p AD=10.88p PS=7.2u
+ PD=13.2u
* device instance $1675 m0 *1 678,210.7 PMOS
XM$1675 \$I4136 \$I4137 VDD VDD PMOS L=1u W=3.4u AS=10.88p AD=6.46p PS=13.2u
+ PD=7.2u
* device instance $1676 m0 *1 682.8,210.7 PMOS
XM$1676 VDD \$I4136 \$I4137 VDD PMOS L=1u W=3.4u AS=6.46p AD=10.88p PS=7.2u
+ PD=13.2u
* device instance $1677 m0 *1 673.2,231.1 NMOS
XM$1677 BL28 WL7 \$I4136 VSS NMOS L=1u W=3.4u AS=10.88p AD=6.46p PS=13.2u
+ PD=7.2u
* device instance $1678 m0 *1 678,231.1 NMOS
XM$1678 \$I4136 \$I4137 VSS VSS NMOS L=1u W=3.4u AS=6.46p AD=6.46p PS=7.2u
+ PD=7.2u
* device instance $1679 m0 *1 682.8,231.1 NMOS
XM$1679 VSS \$I4136 \$I4137 VSS NMOS L=1u W=3.4u AS=6.46p AD=6.46p PS=7.2u
+ PD=7.2u
* device instance $1680 m0 *1 687.6,231.1 NMOS
XM$1680 \$I4137 WL7 BLB28 VSS NMOS L=1u W=3.4u AS=6.46p AD=10.88p PS=7.2u
+ PD=13.2u
* device instance $1681 m0 *1 654.8,210.7 PMOS
XM$1681 \$I4138 \$I4139 VDD VDD PMOS L=1u W=3.4u AS=10.88p AD=6.46p PS=13.2u
+ PD=7.2u
* device instance $1682 m0 *1 659.6,210.7 PMOS
XM$1682 VDD \$I4138 \$I4139 VDD PMOS L=1u W=3.4u AS=6.46p AD=10.88p PS=7.2u
+ PD=13.2u
* device instance $1683 m0 *1 650,231.1 NMOS
XM$1683 BL27 WL7 \$I4138 VSS NMOS L=1u W=3.4u AS=10.88p AD=6.46p PS=13.2u
+ PD=7.2u
* device instance $1684 m0 *1 654.8,231.1 NMOS
XM$1684 \$I4138 \$I4139 VSS VSS NMOS L=1u W=3.4u AS=6.46p AD=6.46p PS=7.2u
+ PD=7.2u
* device instance $1685 m0 *1 659.6,231.1 NMOS
XM$1685 VSS \$I4138 \$I4139 VSS NMOS L=1u W=3.4u AS=6.46p AD=6.46p PS=7.2u
+ PD=7.2u
* device instance $1686 m0 *1 664.4,231.1 NMOS
XM$1686 \$I4139 WL7 BLB27 VSS NMOS L=1u W=3.4u AS=6.46p AD=10.88p PS=7.2u
+ PD=13.2u
* device instance $1687 m0 *1 631.6,210.7 PMOS
XM$1687 \$I4140 \$I4141 VDD VDD PMOS L=1u W=3.4u AS=10.88p AD=6.46p PS=13.2u
+ PD=7.2u
* device instance $1688 m0 *1 636.4,210.7 PMOS
XM$1688 VDD \$I4140 \$I4141 VDD PMOS L=1u W=3.4u AS=6.46p AD=10.88p PS=7.2u
+ PD=13.2u
* device instance $1689 m0 *1 626.8,231.1 NMOS
XM$1689 BL26 WL7 \$I4140 VSS NMOS L=1u W=3.4u AS=10.88p AD=6.46p PS=13.2u
+ PD=7.2u
* device instance $1690 m0 *1 631.6,231.1 NMOS
XM$1690 \$I4140 \$I4141 VSS VSS NMOS L=1u W=3.4u AS=6.46p AD=6.46p PS=7.2u
+ PD=7.2u
* device instance $1691 m0 *1 636.4,231.1 NMOS
XM$1691 VSS \$I4140 \$I4141 VSS NMOS L=1u W=3.4u AS=6.46p AD=6.46p PS=7.2u
+ PD=7.2u
* device instance $1692 m0 *1 641.2,231.1 NMOS
XM$1692 \$I4141 WL7 BLB26 VSS NMOS L=1u W=3.4u AS=6.46p AD=10.88p PS=7.2u
+ PD=13.2u
* device instance $1693 m0 *1 239.2,92.3 PMOS
XM$1693 \$I4142 \$I4143 VDD VDD PMOS L=1u W=3.4u AS=10.88p AD=6.46p PS=13.2u
+ PD=7.2u
* device instance $1694 m0 *1 244,92.3 PMOS
XM$1694 VDD \$I4142 \$I4143 VDD PMOS L=1u W=3.4u AS=6.46p AD=10.88p PS=7.2u
+ PD=13.2u
* device instance $1695 m0 *1 234.4,112.7 NMOS
XM$1695 BL10 WL3 \$I4142 VSS NMOS L=1u W=3.4u AS=10.88p AD=6.46p PS=13.2u
+ PD=7.2u
* device instance $1696 m0 *1 239.2,112.7 NMOS
XM$1696 \$I4142 \$I4143 VSS VSS NMOS L=1u W=3.4u AS=6.46p AD=6.46p PS=7.2u
+ PD=7.2u
* device instance $1697 m0 *1 244,112.7 NMOS
XM$1697 VSS \$I4142 \$I4143 VSS NMOS L=1u W=3.4u AS=6.46p AD=6.46p PS=7.2u
+ PD=7.2u
* device instance $1698 m0 *1 248.8,112.7 NMOS
XM$1698 \$I4143 WL3 BLB10 VSS NMOS L=1u W=3.4u AS=6.46p AD=10.88p PS=7.2u
+ PD=13.2u
* device instance $1699 m0 *1 608.4,210.7 PMOS
XM$1699 \$I4144 \$I4145 VDD VDD PMOS L=1u W=3.4u AS=10.88p AD=6.46p PS=13.2u
+ PD=7.2u
* device instance $1700 m0 *1 613.2,210.7 PMOS
XM$1700 VDD \$I4144 \$I4145 VDD PMOS L=1u W=3.4u AS=6.46p AD=10.88p PS=7.2u
+ PD=13.2u
* device instance $1701 m0 *1 603.6,231.1 NMOS
XM$1701 BL25 WL7 \$I4144 VSS NMOS L=1u W=3.4u AS=10.88p AD=6.46p PS=13.2u
+ PD=7.2u
* device instance $1702 m0 *1 608.4,231.1 NMOS
XM$1702 \$I4144 \$I4145 VSS VSS NMOS L=1u W=3.4u AS=6.46p AD=6.46p PS=7.2u
+ PD=7.2u
* device instance $1703 m0 *1 613.2,231.1 NMOS
XM$1703 VSS \$I4144 \$I4145 VSS NMOS L=1u W=3.4u AS=6.46p AD=6.46p PS=7.2u
+ PD=7.2u
* device instance $1704 m0 *1 618,231.1 NMOS
XM$1704 \$I4145 WL7 BLB25 VSS NMOS L=1u W=3.4u AS=6.46p AD=10.88p PS=7.2u
+ PD=13.2u
* device instance $1705 m0 *1 585.2,210.7 PMOS
XM$1705 \$I4146 \$I4147 VDD VDD PMOS L=1u W=3.4u AS=10.88p AD=6.46p PS=13.2u
+ PD=7.2u
* device instance $1706 m0 *1 590,210.7 PMOS
XM$1706 VDD \$I4146 \$I4147 VDD PMOS L=1u W=3.4u AS=6.46p AD=10.88p PS=7.2u
+ PD=13.2u
* device instance $1707 m0 *1 580.4,231.1 NMOS
XM$1707 BL24 WL7 \$I4146 VSS NMOS L=1u W=3.4u AS=10.88p AD=6.46p PS=13.2u
+ PD=7.2u
* device instance $1708 m0 *1 585.2,231.1 NMOS
XM$1708 \$I4146 \$I4147 VSS VSS NMOS L=1u W=3.4u AS=6.46p AD=6.46p PS=7.2u
+ PD=7.2u
* device instance $1709 m0 *1 590,231.1 NMOS
XM$1709 VSS \$I4146 \$I4147 VSS NMOS L=1u W=3.4u AS=6.46p AD=6.46p PS=7.2u
+ PD=7.2u
* device instance $1710 m0 *1 594.8,231.1 NMOS
XM$1710 \$I4147 WL7 BLB24 VSS NMOS L=1u W=3.4u AS=6.46p AD=10.88p PS=7.2u
+ PD=13.2u
* device instance $1711 m0 *1 422.8,447.5 PMOS
XM$1711 \$I4148 \$I4149 VDD VDD PMOS L=1u W=3.4u AS=10.88p AD=6.46p PS=13.2u
+ PD=7.2u
* device instance $1712 m0 *1 427.6,447.5 PMOS
XM$1712 VDD \$I4148 \$I4149 VDD PMOS L=1u W=3.4u AS=6.46p AD=10.88p PS=7.2u
+ PD=13.2u
* device instance $1713 m0 *1 418,467.9 NMOS
XM$1713 BL17 WL15 \$I4148 VSS NMOS L=1u W=3.4u AS=10.88p AD=6.46p PS=13.2u
+ PD=7.2u
* device instance $1714 m0 *1 422.8,467.9 NMOS
XM$1714 \$I4148 \$I4149 VSS VSS NMOS L=1u W=3.4u AS=6.46p AD=6.46p PS=7.2u
+ PD=7.2u
* device instance $1715 m0 *1 427.6,467.9 NMOS
XM$1715 VSS \$I4148 \$I4149 VSS NMOS L=1u W=3.4u AS=6.46p AD=6.46p PS=7.2u
+ PD=7.2u
* device instance $1716 m0 *1 432.4,467.9 NMOS
XM$1716 \$I4149 WL15 BLB17 VSS NMOS L=1u W=3.4u AS=6.46p AD=10.88p PS=7.2u
+ PD=13.2u
* device instance $1717 m0 *1 446,447.5 PMOS
XM$1717 \$I4150 \$I4151 VDD VDD PMOS L=1u W=3.4u AS=10.88p AD=6.46p PS=13.2u
+ PD=7.2u
* device instance $1718 m0 *1 450.8,447.5 PMOS
XM$1718 VDD \$I4150 \$I4151 VDD PMOS L=1u W=3.4u AS=6.46p AD=10.88p PS=7.2u
+ PD=13.2u
* device instance $1719 m0 *1 441.2,467.9 NMOS
XM$1719 BL18 WL15 \$I4150 VSS NMOS L=1u W=3.4u AS=10.88p AD=6.46p PS=13.2u
+ PD=7.2u
* device instance $1720 m0 *1 446,467.9 NMOS
XM$1720 \$I4150 \$I4151 VSS VSS NMOS L=1u W=3.4u AS=6.46p AD=6.46p PS=7.2u
+ PD=7.2u
* device instance $1721 m0 *1 450.8,467.9 NMOS
XM$1721 VSS \$I4150 \$I4151 VSS NMOS L=1u W=3.4u AS=6.46p AD=6.46p PS=7.2u
+ PD=7.2u
* device instance $1722 m0 *1 455.6,467.9 NMOS
XM$1722 \$I4151 WL15 BLB18 VSS NMOS L=1u W=3.4u AS=6.46p AD=10.88p PS=7.2u
+ PD=13.2u
* device instance $1723 m0 *1 724.4,210.7 PMOS
XM$1723 \$I4152 \$I4153 VDD VDD PMOS L=1u W=3.4u AS=10.88p AD=6.46p PS=13.2u
+ PD=7.2u
* device instance $1724 m0 *1 729.2,210.7 PMOS
XM$1724 VDD \$I4152 \$I4153 VDD PMOS L=1u W=3.4u AS=6.46p AD=10.88p PS=7.2u
+ PD=13.2u
* device instance $1725 m0 *1 719.6,231.1 NMOS
XM$1725 BL30 WL7 \$I4152 VSS NMOS L=1u W=3.4u AS=10.88p AD=6.46p PS=13.2u
+ PD=7.2u
* device instance $1726 m0 *1 724.4,231.1 NMOS
XM$1726 \$I4152 \$I4153 VSS VSS NMOS L=1u W=3.4u AS=6.46p AD=6.46p PS=7.2u
+ PD=7.2u
* device instance $1727 m0 *1 729.2,231.1 NMOS
XM$1727 VSS \$I4152 \$I4153 VSS NMOS L=1u W=3.4u AS=6.46p AD=6.46p PS=7.2u
+ PD=7.2u
* device instance $1728 m0 *1 734,231.1 NMOS
XM$1728 \$I4153 WL7 BLB30 VSS NMOS L=1u W=3.4u AS=6.46p AD=10.88p PS=7.2u
+ PD=13.2u
* device instance $1729 r0 *1 515.6,440.5 PMOS
XM$1729 \$I4154 \$I4155 VDD VDD PMOS L=1u W=3.4u AS=10.88p AD=6.46p PS=13.2u
+ PD=7.2u
* device instance $1730 r0 *1 520.4,440.5 PMOS
XM$1730 VDD \$I4154 \$I4155 VDD PMOS L=1u W=3.4u AS=6.46p AD=10.88p PS=7.2u
+ PD=13.2u
* device instance $1731 r0 *1 510.8,420.1 NMOS
XM$1731 BL21 WL14 \$I4154 VSS NMOS L=1u W=3.4u AS=10.88p AD=6.46p PS=13.2u
+ PD=7.2u
* device instance $1732 r0 *1 515.6,420.1 NMOS
XM$1732 \$I4154 \$I4155 VSS VSS NMOS L=1u W=3.4u AS=6.46p AD=6.46p PS=7.2u
+ PD=7.2u
* device instance $1733 r0 *1 520.4,420.1 NMOS
XM$1733 VSS \$I4154 \$I4155 VSS NMOS L=1u W=3.4u AS=6.46p AD=6.46p PS=7.2u
+ PD=7.2u
* device instance $1734 r0 *1 525.2,420.1 NMOS
XM$1734 \$I4155 WL14 BLB21 VSS NMOS L=1u W=3.4u AS=6.46p AD=10.88p PS=7.2u
+ PD=13.2u
* device instance $1735 r0 *1 492.4,440.5 PMOS
XM$1735 \$I4156 \$I4157 VDD VDD PMOS L=1u W=3.4u AS=10.88p AD=6.46p PS=13.2u
+ PD=7.2u
* device instance $1736 r0 *1 497.2,440.5 PMOS
XM$1736 VDD \$I4156 \$I4157 VDD PMOS L=1u W=3.4u AS=6.46p AD=10.88p PS=7.2u
+ PD=13.2u
* device instance $1737 r0 *1 487.6,420.1 NMOS
XM$1737 BL20 WL14 \$I4156 VSS NMOS L=1u W=3.4u AS=10.88p AD=6.46p PS=13.2u
+ PD=7.2u
* device instance $1738 r0 *1 492.4,420.1 NMOS
XM$1738 \$I4156 \$I4157 VSS VSS NMOS L=1u W=3.4u AS=6.46p AD=6.46p PS=7.2u
+ PD=7.2u
* device instance $1739 r0 *1 497.2,420.1 NMOS
XM$1739 VSS \$I4156 \$I4157 VSS NMOS L=1u W=3.4u AS=6.46p AD=6.46p PS=7.2u
+ PD=7.2u
* device instance $1740 r0 *1 502,420.1 NMOS
XM$1740 \$I4157 WL14 BLB20 VSS NMOS L=1u W=3.4u AS=6.46p AD=10.88p PS=7.2u
+ PD=13.2u
* device instance $1741 r0 *1 631.6,440.5 PMOS
XM$1741 \$I4158 \$I4159 VDD VDD PMOS L=1u W=3.4u AS=10.88p AD=6.46p PS=13.2u
+ PD=7.2u
* device instance $1742 r0 *1 636.4,440.5 PMOS
XM$1742 VDD \$I4158 \$I4159 VDD PMOS L=1u W=3.4u AS=6.46p AD=10.88p PS=7.2u
+ PD=13.2u
* device instance $1743 r0 *1 626.8,420.1 NMOS
XM$1743 BL26 WL14 \$I4158 VSS NMOS L=1u W=3.4u AS=10.88p AD=6.46p PS=13.2u
+ PD=7.2u
* device instance $1744 r0 *1 631.6,420.1 NMOS
XM$1744 \$I4158 \$I4159 VSS VSS NMOS L=1u W=3.4u AS=6.46p AD=6.46p PS=7.2u
+ PD=7.2u
* device instance $1745 r0 *1 636.4,420.1 NMOS
XM$1745 VSS \$I4158 \$I4159 VSS NMOS L=1u W=3.4u AS=6.46p AD=6.46p PS=7.2u
+ PD=7.2u
* device instance $1746 r0 *1 641.2,420.1 NMOS
XM$1746 \$I4159 WL14 BLB26 VSS NMOS L=1u W=3.4u AS=6.46p AD=10.88p PS=7.2u
+ PD=13.2u
* device instance $1747 r0 *1 332,381.3 PMOS
XM$1747 \$I4160 \$I4161 VDD VDD PMOS L=1u W=3.4u AS=10.88p AD=6.46p PS=13.2u
+ PD=7.2u
* device instance $1748 r0 *1 336.8,381.3 PMOS
XM$1748 VDD \$I4160 \$I4161 VDD PMOS L=1u W=3.4u AS=6.46p AD=10.88p PS=7.2u
+ PD=13.2u
* device instance $1749 r0 *1 327.2,360.9 NMOS
XM$1749 BL14 WL12 \$I4160 VSS NMOS L=1u W=3.4u AS=10.88p AD=6.46p PS=13.2u
+ PD=7.2u
* device instance $1750 r0 *1 332,360.9 NMOS
XM$1750 \$I4160 \$I4161 VSS VSS NMOS L=1u W=3.4u AS=6.46p AD=6.46p PS=7.2u
+ PD=7.2u
* device instance $1751 r0 *1 336.8,360.9 NMOS
XM$1751 VSS \$I4160 \$I4161 VSS NMOS L=1u W=3.4u AS=6.46p AD=6.46p PS=7.2u
+ PD=7.2u
* device instance $1752 r0 *1 341.6,360.9 NMOS
XM$1752 \$I4161 WL12 BLB14 VSS NMOS L=1u W=3.4u AS=6.46p AD=10.88p PS=7.2u
+ PD=13.2u
* device instance $1753 r0 *1 678,440.5 PMOS
XM$1753 \$I4162 \$I4163 VDD VDD PMOS L=1u W=3.4u AS=10.88p AD=6.46p PS=13.2u
+ PD=7.2u
* device instance $1754 r0 *1 682.8,440.5 PMOS
XM$1754 VDD \$I4162 \$I4163 VDD PMOS L=1u W=3.4u AS=6.46p AD=10.88p PS=7.2u
+ PD=13.2u
* device instance $1755 r0 *1 673.2,420.1 NMOS
XM$1755 BL28 WL14 \$I4162 VSS NMOS L=1u W=3.4u AS=10.88p AD=6.46p PS=13.2u
+ PD=7.2u
* device instance $1756 r0 *1 678,420.1 NMOS
XM$1756 \$I4162 \$I4163 VSS VSS NMOS L=1u W=3.4u AS=6.46p AD=6.46p PS=7.2u
+ PD=7.2u
* device instance $1757 r0 *1 682.8,420.1 NMOS
XM$1757 VSS \$I4162 \$I4163 VSS NMOS L=1u W=3.4u AS=6.46p AD=6.46p PS=7.2u
+ PD=7.2u
* device instance $1758 r0 *1 687.6,420.1 NMOS
XM$1758 \$I4163 WL14 BLB28 VSS NMOS L=1u W=3.4u AS=6.46p AD=10.88p PS=7.2u
+ PD=13.2u
* device instance $1759 r0 *1 308.8,381.3 PMOS
XM$1759 \$I4164 \$I4165 VDD VDD PMOS L=1u W=3.4u AS=10.88p AD=6.46p PS=13.2u
+ PD=7.2u
* device instance $1760 r0 *1 313.6,381.3 PMOS
XM$1760 VDD \$I4164 \$I4165 VDD PMOS L=1u W=3.4u AS=6.46p AD=10.88p PS=7.2u
+ PD=13.2u
* device instance $1761 r0 *1 304,360.9 NMOS
XM$1761 BL13 WL12 \$I4164 VSS NMOS L=1u W=3.4u AS=10.88p AD=6.46p PS=13.2u
+ PD=7.2u
* device instance $1762 r0 *1 308.8,360.9 NMOS
XM$1762 \$I4164 \$I4165 VSS VSS NMOS L=1u W=3.4u AS=6.46p AD=6.46p PS=7.2u
+ PD=7.2u
* device instance $1763 r0 *1 313.6,360.9 NMOS
XM$1763 VSS \$I4164 \$I4165 VSS NMOS L=1u W=3.4u AS=6.46p AD=6.46p PS=7.2u
+ PD=7.2u
* device instance $1764 r0 *1 318.4,360.9 NMOS
XM$1764 \$I4165 WL12 BLB13 VSS NMOS L=1u W=3.4u AS=6.46p AD=10.88p PS=7.2u
+ PD=13.2u
* device instance $1765 r0 *1 355.2,440.5 PMOS
XM$1765 \$I4166 \$I4167 VDD VDD PMOS L=1u W=3.4u AS=10.88p AD=6.46p PS=13.2u
+ PD=7.2u
* device instance $1766 r0 *1 360,440.5 PMOS
XM$1766 VDD \$I4166 \$I4167 VDD PMOS L=1u W=3.4u AS=6.46p AD=10.88p PS=7.2u
+ PD=13.2u
* device instance $1767 r0 *1 350.4,420.1 NMOS
XM$1767 BL15 WL14 \$I4166 VSS NMOS L=1u W=3.4u AS=10.88p AD=6.46p PS=13.2u
+ PD=7.2u
* device instance $1768 r0 *1 355.2,420.1 NMOS
XM$1768 \$I4166 \$I4167 VSS VSS NMOS L=1u W=3.4u AS=6.46p AD=6.46p PS=7.2u
+ PD=7.2u
* device instance $1769 r0 *1 360,420.1 NMOS
XM$1769 VSS \$I4166 \$I4167 VSS NMOS L=1u W=3.4u AS=6.46p AD=6.46p PS=7.2u
+ PD=7.2u
* device instance $1770 r0 *1 364.8,420.1 NMOS
XM$1770 \$I4167 WL14 BLB15 VSS NMOS L=1u W=3.4u AS=6.46p AD=10.88p PS=7.2u
+ PD=13.2u
* device instance $1771 r0 *1 332,440.5 PMOS
XM$1771 \$I4168 \$I4169 VDD VDD PMOS L=1u W=3.4u AS=10.88p AD=6.46p PS=13.2u
+ PD=7.2u
* device instance $1772 r0 *1 336.8,440.5 PMOS
XM$1772 VDD \$I4168 \$I4169 VDD PMOS L=1u W=3.4u AS=6.46p AD=10.88p PS=7.2u
+ PD=13.2u
* device instance $1773 r0 *1 327.2,420.1 NMOS
XM$1773 BL14 WL14 \$I4168 VSS NMOS L=1u W=3.4u AS=10.88p AD=6.46p PS=13.2u
+ PD=7.2u
* device instance $1774 r0 *1 332,420.1 NMOS
XM$1774 \$I4168 \$I4169 VSS VSS NMOS L=1u W=3.4u AS=6.46p AD=6.46p PS=7.2u
+ PD=7.2u
* device instance $1775 r0 *1 336.8,420.1 NMOS
XM$1775 VSS \$I4168 \$I4169 VSS NMOS L=1u W=3.4u AS=6.46p AD=6.46p PS=7.2u
+ PD=7.2u
* device instance $1776 r0 *1 341.6,420.1 NMOS
XM$1776 \$I4169 WL14 BLB14 VSS NMOS L=1u W=3.4u AS=6.46p AD=10.88p PS=7.2u
+ PD=13.2u
* device instance $1777 r0 *1 308.8,440.5 PMOS
XM$1777 \$I4170 \$I4171 VDD VDD PMOS L=1u W=3.4u AS=10.88p AD=6.46p PS=13.2u
+ PD=7.2u
* device instance $1778 r0 *1 313.6,440.5 PMOS
XM$1778 VDD \$I4170 \$I4171 VDD PMOS L=1u W=3.4u AS=6.46p AD=10.88p PS=7.2u
+ PD=13.2u
* device instance $1779 r0 *1 304,420.1 NMOS
XM$1779 BL13 WL14 \$I4170 VSS NMOS L=1u W=3.4u AS=10.88p AD=6.46p PS=13.2u
+ PD=7.2u
* device instance $1780 r0 *1 308.8,420.1 NMOS
XM$1780 \$I4170 \$I4171 VSS VSS NMOS L=1u W=3.4u AS=6.46p AD=6.46p PS=7.2u
+ PD=7.2u
* device instance $1781 r0 *1 313.6,420.1 NMOS
XM$1781 VSS \$I4170 \$I4171 VSS NMOS L=1u W=3.4u AS=6.46p AD=6.46p PS=7.2u
+ PD=7.2u
* device instance $1782 r0 *1 318.4,420.1 NMOS
XM$1782 \$I4171 WL14 BLB13 VSS NMOS L=1u W=3.4u AS=6.46p AD=10.88p PS=7.2u
+ PD=13.2u
* device instance $1783 r0 *1 285.6,440.5 PMOS
XM$1783 \$I4172 \$I4173 VDD VDD PMOS L=1u W=3.4u AS=10.88p AD=6.46p PS=13.2u
+ PD=7.2u
* device instance $1784 r0 *1 290.4,440.5 PMOS
XM$1784 VDD \$I4172 \$I4173 VDD PMOS L=1u W=3.4u AS=6.46p AD=10.88p PS=7.2u
+ PD=13.2u
* device instance $1785 r0 *1 280.8,420.1 NMOS
XM$1785 BL12 WL14 \$I4172 VSS NMOS L=1u W=3.4u AS=10.88p AD=6.46p PS=13.2u
+ PD=7.2u
* device instance $1786 r0 *1 285.6,420.1 NMOS
XM$1786 \$I4172 \$I4173 VSS VSS NMOS L=1u W=3.4u AS=6.46p AD=6.46p PS=7.2u
+ PD=7.2u
* device instance $1787 r0 *1 290.4,420.1 NMOS
XM$1787 VSS \$I4172 \$I4173 VSS NMOS L=1u W=3.4u AS=6.46p AD=6.46p PS=7.2u
+ PD=7.2u
* device instance $1788 r0 *1 295.2,420.1 NMOS
XM$1788 \$I4173 WL14 BLB12 VSS NMOS L=1u W=3.4u AS=6.46p AD=10.88p PS=7.2u
+ PD=13.2u
* device instance $1789 r0 *1 262.4,440.5 PMOS
XM$1789 \$I4174 \$I4175 VDD VDD PMOS L=1u W=3.4u AS=10.88p AD=6.46p PS=13.2u
+ PD=7.2u
* device instance $1790 r0 *1 267.2,440.5 PMOS
XM$1790 VDD \$I4174 \$I4175 VDD PMOS L=1u W=3.4u AS=6.46p AD=10.88p PS=7.2u
+ PD=13.2u
* device instance $1791 r0 *1 257.6,420.1 NMOS
XM$1791 BL11 WL14 \$I4174 VSS NMOS L=1u W=3.4u AS=10.88p AD=6.46p PS=13.2u
+ PD=7.2u
* device instance $1792 r0 *1 262.4,420.1 NMOS
XM$1792 \$I4174 \$I4175 VSS VSS NMOS L=1u W=3.4u AS=6.46p AD=6.46p PS=7.2u
+ PD=7.2u
* device instance $1793 r0 *1 267.2,420.1 NMOS
XM$1793 VSS \$I4174 \$I4175 VSS NMOS L=1u W=3.4u AS=6.46p AD=6.46p PS=7.2u
+ PD=7.2u
* device instance $1794 r0 *1 272,420.1 NMOS
XM$1794 \$I4175 WL14 BLB11 VSS NMOS L=1u W=3.4u AS=6.46p AD=10.88p PS=7.2u
+ PD=13.2u
* device instance $1795 r0 *1 654.8,440.5 PMOS
XM$1795 \$I4176 \$I4177 VDD VDD PMOS L=1u W=3.4u AS=10.88p AD=6.46p PS=13.2u
+ PD=7.2u
* device instance $1796 r0 *1 659.6,440.5 PMOS
XM$1796 VDD \$I4176 \$I4177 VDD PMOS L=1u W=3.4u AS=6.46p AD=10.88p PS=7.2u
+ PD=13.2u
* device instance $1797 r0 *1 650,420.1 NMOS
XM$1797 BL27 WL14 \$I4176 VSS NMOS L=1u W=3.4u AS=10.88p AD=6.46p PS=13.2u
+ PD=7.2u
* device instance $1798 r0 *1 654.8,420.1 NMOS
XM$1798 \$I4176 \$I4177 VSS VSS NMOS L=1u W=3.4u AS=6.46p AD=6.46p PS=7.2u
+ PD=7.2u
* device instance $1799 r0 *1 659.6,420.1 NMOS
XM$1799 VSS \$I4176 \$I4177 VSS NMOS L=1u W=3.4u AS=6.46p AD=6.46p PS=7.2u
+ PD=7.2u
* device instance $1800 r0 *1 664.4,420.1 NMOS
XM$1800 \$I4177 WL14 BLB27 VSS NMOS L=1u W=3.4u AS=6.46p AD=10.88p PS=7.2u
+ PD=13.2u
* device instance $1801 r0 *1 422.8,322.1 PMOS
XM$1801 \$I4178 \$I4179 VDD VDD PMOS L=1u W=3.4u AS=10.88p AD=6.46p PS=13.2u
+ PD=7.2u
* device instance $1802 r0 *1 427.6,322.1 PMOS
XM$1802 VDD \$I4178 \$I4179 VDD PMOS L=1u W=3.4u AS=6.46p AD=10.88p PS=7.2u
+ PD=13.2u
* device instance $1803 r0 *1 418,301.7 NMOS
XM$1803 BL17 WL10 \$I4178 VSS NMOS L=1u W=3.4u AS=10.88p AD=6.46p PS=13.2u
+ PD=7.2u
* device instance $1804 r0 *1 422.8,301.7 NMOS
XM$1804 \$I4178 \$I4179 VSS VSS NMOS L=1u W=3.4u AS=6.46p AD=6.46p PS=7.2u
+ PD=7.2u
* device instance $1805 r0 *1 427.6,301.7 NMOS
XM$1805 VSS \$I4178 \$I4179 VSS NMOS L=1u W=3.4u AS=6.46p AD=6.46p PS=7.2u
+ PD=7.2u
* device instance $1806 r0 *1 432.4,301.7 NMOS
XM$1806 \$I4179 WL10 BLB17 VSS NMOS L=1u W=3.4u AS=6.46p AD=10.88p PS=7.2u
+ PD=13.2u
* device instance $1807 r0 *1 562,440.5 PMOS
XM$1807 \$I4180 \$I4181 VDD VDD PMOS L=1u W=3.4u AS=10.88p AD=6.46p PS=13.2u
+ PD=7.2u
* device instance $1808 r0 *1 566.8,440.5 PMOS
XM$1808 VDD \$I4180 \$I4181 VDD PMOS L=1u W=3.4u AS=6.46p AD=10.88p PS=7.2u
+ PD=13.2u
* device instance $1809 r0 *1 557.2,420.1 NMOS
XM$1809 BL23 WL14 \$I4180 VSS NMOS L=1u W=3.4u AS=10.88p AD=6.46p PS=13.2u
+ PD=7.2u
* device instance $1810 r0 *1 562,420.1 NMOS
XM$1810 \$I4180 \$I4181 VSS VSS NMOS L=1u W=3.4u AS=6.46p AD=6.46p PS=7.2u
+ PD=7.2u
* device instance $1811 r0 *1 566.8,420.1 NMOS
XM$1811 VSS \$I4180 \$I4181 VSS NMOS L=1u W=3.4u AS=6.46p AD=6.46p PS=7.2u
+ PD=7.2u
* device instance $1812 r0 *1 571.6,420.1 NMOS
XM$1812 \$I4181 WL14 BLB23 VSS NMOS L=1u W=3.4u AS=6.46p AD=10.88p PS=7.2u
+ PD=13.2u
* device instance $1813 r0 *1 446,322.1 PMOS
XM$1813 \$I4182 \$I4183 VDD VDD PMOS L=1u W=3.4u AS=10.88p AD=6.46p PS=13.2u
+ PD=7.2u
* device instance $1814 r0 *1 450.8,322.1 PMOS
XM$1814 VDD \$I4182 \$I4183 VDD PMOS L=1u W=3.4u AS=6.46p AD=10.88p PS=7.2u
+ PD=13.2u
* device instance $1815 r0 *1 441.2,301.7 NMOS
XM$1815 BL18 WL10 \$I4182 VSS NMOS L=1u W=3.4u AS=10.88p AD=6.46p PS=13.2u
+ PD=7.2u
* device instance $1816 r0 *1 446,301.7 NMOS
XM$1816 \$I4182 \$I4183 VSS VSS NMOS L=1u W=3.4u AS=6.46p AD=6.46p PS=7.2u
+ PD=7.2u
* device instance $1817 r0 *1 450.8,301.7 NMOS
XM$1817 VSS \$I4182 \$I4183 VSS NMOS L=1u W=3.4u AS=6.46p AD=6.46p PS=7.2u
+ PD=7.2u
* device instance $1818 r0 *1 455.6,301.7 NMOS
XM$1818 \$I4183 WL10 BLB18 VSS NMOS L=1u W=3.4u AS=6.46p AD=10.88p PS=7.2u
+ PD=13.2u
* device instance $1819 r0 *1 562,262.9 PMOS
XM$1819 \$I4184 \$I4185 VDD VDD PMOS L=1u W=3.4u AS=10.88p AD=6.46p PS=13.2u
+ PD=7.2u
* device instance $1820 r0 *1 566.8,262.9 PMOS
XM$1820 VDD \$I4184 \$I4185 VDD PMOS L=1u W=3.4u AS=6.46p AD=10.88p PS=7.2u
+ PD=13.2u
* device instance $1821 r0 *1 557.2,242.5 NMOS
XM$1821 BL23 WL8 \$I4184 VSS NMOS L=1u W=3.4u AS=10.88p AD=6.46p PS=13.2u
+ PD=7.2u
* device instance $1822 r0 *1 562,242.5 NMOS
XM$1822 \$I4184 \$I4185 VSS VSS NMOS L=1u W=3.4u AS=6.46p AD=6.46p PS=7.2u
+ PD=7.2u
* device instance $1823 r0 *1 566.8,242.5 NMOS
XM$1823 VSS \$I4184 \$I4185 VSS NMOS L=1u W=3.4u AS=6.46p AD=6.46p PS=7.2u
+ PD=7.2u
* device instance $1824 r0 *1 571.6,242.5 NMOS
XM$1824 \$I4185 WL8 BLB23 VSS NMOS L=1u W=3.4u AS=6.46p AD=10.88p PS=7.2u
+ PD=13.2u
* device instance $1825 r0 *1 399.6,322.1 PMOS
XM$1825 \$I4186 \$I4187 VDD VDD PMOS L=1u W=3.4u AS=10.88p AD=6.46p PS=13.2u
+ PD=7.2u
* device instance $1826 r0 *1 404.4,322.1 PMOS
XM$1826 VDD \$I4186 \$I4187 VDD PMOS L=1u W=3.4u AS=6.46p AD=10.88p PS=7.2u
+ PD=13.2u
* device instance $1827 r0 *1 394.8,301.7 NMOS
XM$1827 BL16 WL10 \$I4186 VSS NMOS L=1u W=3.4u AS=10.88p AD=6.46p PS=13.2u
+ PD=7.2u
* device instance $1828 r0 *1 399.6,301.7 NMOS
XM$1828 \$I4186 \$I4187 VSS VSS NMOS L=1u W=3.4u AS=6.46p AD=6.46p PS=7.2u
+ PD=7.2u
* device instance $1829 r0 *1 404.4,301.7 NMOS
XM$1829 VSS \$I4186 \$I4187 VSS NMOS L=1u W=3.4u AS=6.46p AD=6.46p PS=7.2u
+ PD=7.2u
* device instance $1830 r0 *1 409.2,301.7 NMOS
XM$1830 \$I4187 WL10 BLB16 VSS NMOS L=1u W=3.4u AS=6.46p AD=10.88p PS=7.2u
+ PD=13.2u
* device instance $1831 r0 *1 562,322.1 PMOS
XM$1831 \$I4188 \$I4189 VDD VDD PMOS L=1u W=3.4u AS=10.88p AD=6.46p PS=13.2u
+ PD=7.2u
* device instance $1832 r0 *1 566.8,322.1 PMOS
XM$1832 VDD \$I4188 \$I4189 VDD PMOS L=1u W=3.4u AS=6.46p AD=10.88p PS=7.2u
+ PD=13.2u
* device instance $1833 r0 *1 557.2,301.7 NMOS
XM$1833 BL23 WL10 \$I4188 VSS NMOS L=1u W=3.4u AS=10.88p AD=6.46p PS=13.2u
+ PD=7.2u
* device instance $1834 r0 *1 562,301.7 NMOS
XM$1834 \$I4188 \$I4189 VSS VSS NMOS L=1u W=3.4u AS=6.46p AD=6.46p PS=7.2u
+ PD=7.2u
* device instance $1835 r0 *1 566.8,301.7 NMOS
XM$1835 VSS \$I4188 \$I4189 VSS NMOS L=1u W=3.4u AS=6.46p AD=6.46p PS=7.2u
+ PD=7.2u
* device instance $1836 r0 *1 571.6,301.7 NMOS
XM$1836 \$I4189 WL10 BLB23 VSS NMOS L=1u W=3.4u AS=6.46p AD=10.88p PS=7.2u
+ PD=13.2u
* device instance $1837 r0 *1 422.8,262.9 PMOS
XM$1837 \$I4190 \$I4191 VDD VDD PMOS L=1u W=3.4u AS=10.88p AD=6.46p PS=13.2u
+ PD=7.2u
* device instance $1838 r0 *1 427.6,262.9 PMOS
XM$1838 VDD \$I4190 \$I4191 VDD PMOS L=1u W=3.4u AS=6.46p AD=10.88p PS=7.2u
+ PD=13.2u
* device instance $1839 r0 *1 418,242.5 NMOS
XM$1839 BL17 WL8 \$I4190 VSS NMOS L=1u W=3.4u AS=10.88p AD=6.46p PS=13.2u
+ PD=7.2u
* device instance $1840 r0 *1 422.8,242.5 NMOS
XM$1840 \$I4190 \$I4191 VSS VSS NMOS L=1u W=3.4u AS=6.46p AD=6.46p PS=7.2u
+ PD=7.2u
* device instance $1841 r0 *1 427.6,242.5 NMOS
XM$1841 VSS \$I4190 \$I4191 VSS NMOS L=1u W=3.4u AS=6.46p AD=6.46p PS=7.2u
+ PD=7.2u
* device instance $1842 r0 *1 432.4,242.5 NMOS
XM$1842 \$I4191 WL8 BLB17 VSS NMOS L=1u W=3.4u AS=6.46p AD=10.88p PS=7.2u
+ PD=13.2u
* device instance $1843 r0 *1 469.2,322.1 PMOS
XM$1843 \$I4192 \$I4193 VDD VDD PMOS L=1u W=3.4u AS=10.88p AD=6.46p PS=13.2u
+ PD=7.2u
* device instance $1844 r0 *1 474,322.1 PMOS
XM$1844 VDD \$I4192 \$I4193 VDD PMOS L=1u W=3.4u AS=6.46p AD=10.88p PS=7.2u
+ PD=13.2u
* device instance $1845 r0 *1 464.4,301.7 NMOS
XM$1845 BL19 WL10 \$I4192 VSS NMOS L=1u W=3.4u AS=10.88p AD=6.46p PS=13.2u
+ PD=7.2u
* device instance $1846 r0 *1 469.2,301.7 NMOS
XM$1846 \$I4192 \$I4193 VSS VSS NMOS L=1u W=3.4u AS=6.46p AD=6.46p PS=7.2u
+ PD=7.2u
* device instance $1847 r0 *1 474,301.7 NMOS
XM$1847 VSS \$I4192 \$I4193 VSS NMOS L=1u W=3.4u AS=6.46p AD=6.46p PS=7.2u
+ PD=7.2u
* device instance $1848 r0 *1 478.8,301.7 NMOS
XM$1848 \$I4193 WL10 BLB19 VSS NMOS L=1u W=3.4u AS=6.46p AD=10.88p PS=7.2u
+ PD=13.2u
* device instance $1849 r0 *1 492.4,322.1 PMOS
XM$1849 \$I4194 \$I4195 VDD VDD PMOS L=1u W=3.4u AS=10.88p AD=6.46p PS=13.2u
+ PD=7.2u
* device instance $1850 r0 *1 497.2,322.1 PMOS
XM$1850 VDD \$I4194 \$I4195 VDD PMOS L=1u W=3.4u AS=6.46p AD=10.88p PS=7.2u
+ PD=13.2u
* device instance $1851 r0 *1 487.6,301.7 NMOS
XM$1851 BL20 WL10 \$I4194 VSS NMOS L=1u W=3.4u AS=10.88p AD=6.46p PS=13.2u
+ PD=7.2u
* device instance $1852 r0 *1 492.4,301.7 NMOS
XM$1852 \$I4194 \$I4195 VSS VSS NMOS L=1u W=3.4u AS=6.46p AD=6.46p PS=7.2u
+ PD=7.2u
* device instance $1853 r0 *1 497.2,301.7 NMOS
XM$1853 VSS \$I4194 \$I4195 VSS NMOS L=1u W=3.4u AS=6.46p AD=6.46p PS=7.2u
+ PD=7.2u
* device instance $1854 r0 *1 502,301.7 NMOS
XM$1854 \$I4195 WL10 BLB20 VSS NMOS L=1u W=3.4u AS=6.46p AD=10.88p PS=7.2u
+ PD=13.2u
* device instance $1855 r0 *1 515.6,322.1 PMOS
XM$1855 \$I4196 \$I4197 VDD VDD PMOS L=1u W=3.4u AS=10.88p AD=6.46p PS=13.2u
+ PD=7.2u
* device instance $1856 r0 *1 520.4,322.1 PMOS
XM$1856 VDD \$I4196 \$I4197 VDD PMOS L=1u W=3.4u AS=6.46p AD=10.88p PS=7.2u
+ PD=13.2u
* device instance $1857 r0 *1 510.8,301.7 NMOS
XM$1857 BL21 WL10 \$I4196 VSS NMOS L=1u W=3.4u AS=10.88p AD=6.46p PS=13.2u
+ PD=7.2u
* device instance $1858 r0 *1 515.6,301.7 NMOS
XM$1858 \$I4196 \$I4197 VSS VSS NMOS L=1u W=3.4u AS=6.46p AD=6.46p PS=7.2u
+ PD=7.2u
* device instance $1859 r0 *1 520.4,301.7 NMOS
XM$1859 VSS \$I4196 \$I4197 VSS NMOS L=1u W=3.4u AS=6.46p AD=6.46p PS=7.2u
+ PD=7.2u
* device instance $1860 r0 *1 525.2,301.7 NMOS
XM$1860 \$I4197 WL10 BLB21 VSS NMOS L=1u W=3.4u AS=6.46p AD=10.88p PS=7.2u
+ PD=13.2u
* device instance $1861 r0 *1 446,262.9 PMOS
XM$1861 \$I4198 \$I4199 VDD VDD PMOS L=1u W=3.4u AS=10.88p AD=6.46p PS=13.2u
+ PD=7.2u
* device instance $1862 r0 *1 450.8,262.9 PMOS
XM$1862 VDD \$I4198 \$I4199 VDD PMOS L=1u W=3.4u AS=6.46p AD=10.88p PS=7.2u
+ PD=13.2u
* device instance $1863 r0 *1 441.2,242.5 NMOS
XM$1863 BL18 WL8 \$I4198 VSS NMOS L=1u W=3.4u AS=10.88p AD=6.46p PS=13.2u
+ PD=7.2u
* device instance $1864 r0 *1 446,242.5 NMOS
XM$1864 \$I4198 \$I4199 VSS VSS NMOS L=1u W=3.4u AS=6.46p AD=6.46p PS=7.2u
+ PD=7.2u
* device instance $1865 r0 *1 450.8,242.5 NMOS
XM$1865 VSS \$I4198 \$I4199 VSS NMOS L=1u W=3.4u AS=6.46p AD=6.46p PS=7.2u
+ PD=7.2u
* device instance $1866 r0 *1 455.6,242.5 NMOS
XM$1866 \$I4199 WL8 BLB18 VSS NMOS L=1u W=3.4u AS=6.46p AD=10.88p PS=7.2u
+ PD=13.2u
* device instance $1867 r0 *1 169.6,440.5 PMOS
XM$1867 \$I4200 \$I4201 VDD VDD PMOS L=1u W=3.4u AS=10.88p AD=6.46p PS=13.2u
+ PD=7.2u
* device instance $1868 r0 *1 174.4,440.5 PMOS
XM$1868 VDD \$I4200 \$I4201 VDD PMOS L=1u W=3.4u AS=6.46p AD=10.88p PS=7.2u
+ PD=13.2u
* device instance $1869 r0 *1 164.8,420.1 NMOS
XM$1869 BL7 WL14 \$I4200 VSS NMOS L=1u W=3.4u AS=10.88p AD=6.46p PS=13.2u
+ PD=7.2u
* device instance $1870 r0 *1 169.6,420.1 NMOS
XM$1870 \$I4200 \$I4201 VSS VSS NMOS L=1u W=3.4u AS=6.46p AD=6.46p PS=7.2u
+ PD=7.2u
* device instance $1871 r0 *1 174.4,420.1 NMOS
XM$1871 VSS \$I4200 \$I4201 VSS NMOS L=1u W=3.4u AS=6.46p AD=6.46p PS=7.2u
+ PD=7.2u
* device instance $1872 r0 *1 179.2,420.1 NMOS
XM$1872 \$I4201 WL14 BLB7 VSS NMOS L=1u W=3.4u AS=6.46p AD=10.88p PS=7.2u
+ PD=13.2u
* device instance $1873 r0 *1 585.2,440.5 PMOS
XM$1873 \$I4202 \$I4203 VDD VDD PMOS L=1u W=3.4u AS=10.88p AD=6.46p PS=13.2u
+ PD=7.2u
* device instance $1874 r0 *1 590,440.5 PMOS
XM$1874 VDD \$I4202 \$I4203 VDD PMOS L=1u W=3.4u AS=6.46p AD=10.88p PS=7.2u
+ PD=13.2u
* device instance $1875 r0 *1 580.4,420.1 NMOS
XM$1875 BL24 WL14 \$I4202 VSS NMOS L=1u W=3.4u AS=10.88p AD=6.46p PS=13.2u
+ PD=7.2u
* device instance $1876 r0 *1 585.2,420.1 NMOS
XM$1876 \$I4202 \$I4203 VSS VSS NMOS L=1u W=3.4u AS=6.46p AD=6.46p PS=7.2u
+ PD=7.2u
* device instance $1877 r0 *1 590,420.1 NMOS
XM$1877 VSS \$I4202 \$I4203 VSS NMOS L=1u W=3.4u AS=6.46p AD=6.46p PS=7.2u
+ PD=7.2u
* device instance $1878 r0 *1 594.8,420.1 NMOS
XM$1878 \$I4203 WL14 BLB24 VSS NMOS L=1u W=3.4u AS=6.46p AD=10.88p PS=7.2u
+ PD=13.2u
* device instance $1879 r0 *1 146.4,440.5 PMOS
XM$1879 \$I4204 \$I4205 VDD VDD PMOS L=1u W=3.4u AS=10.88p AD=6.46p PS=13.2u
+ PD=7.2u
* device instance $1880 r0 *1 151.2,440.5 PMOS
XM$1880 VDD \$I4204 \$I4205 VDD PMOS L=1u W=3.4u AS=6.46p AD=10.88p PS=7.2u
+ PD=13.2u
* device instance $1881 r0 *1 141.6,420.1 NMOS
XM$1881 BL6 WL14 \$I4204 VSS NMOS L=1u W=3.4u AS=10.88p AD=6.46p PS=13.2u
+ PD=7.2u
* device instance $1882 r0 *1 146.4,420.1 NMOS
XM$1882 \$I4204 \$I4205 VSS VSS NMOS L=1u W=3.4u AS=6.46p AD=6.46p PS=7.2u
+ PD=7.2u
* device instance $1883 r0 *1 151.2,420.1 NMOS
XM$1883 VSS \$I4204 \$I4205 VSS NMOS L=1u W=3.4u AS=6.46p AD=6.46p PS=7.2u
+ PD=7.2u
* device instance $1884 r0 *1 156,420.1 NMOS
XM$1884 \$I4205 WL14 BLB6 VSS NMOS L=1u W=3.4u AS=6.46p AD=10.88p PS=7.2u
+ PD=13.2u
* device instance $1885 r0 *1 608.4,440.5 PMOS
XM$1885 \$I4206 \$I4207 VDD VDD PMOS L=1u W=3.4u AS=10.88p AD=6.46p PS=13.2u
+ PD=7.2u
* device instance $1886 r0 *1 613.2,440.5 PMOS
XM$1886 VDD \$I4206 \$I4207 VDD PMOS L=1u W=3.4u AS=6.46p AD=10.88p PS=7.2u
+ PD=13.2u
* device instance $1887 r0 *1 603.6,420.1 NMOS
XM$1887 BL25 WL14 \$I4206 VSS NMOS L=1u W=3.4u AS=10.88p AD=6.46p PS=13.2u
+ PD=7.2u
* device instance $1888 r0 *1 608.4,420.1 NMOS
XM$1888 \$I4206 \$I4207 VSS VSS NMOS L=1u W=3.4u AS=6.46p AD=6.46p PS=7.2u
+ PD=7.2u
* device instance $1889 r0 *1 613.2,420.1 NMOS
XM$1889 VSS \$I4206 \$I4207 VSS NMOS L=1u W=3.4u AS=6.46p AD=6.46p PS=7.2u
+ PD=7.2u
* device instance $1890 r0 *1 618,420.1 NMOS
XM$1890 \$I4207 WL14 BLB25 VSS NMOS L=1u W=3.4u AS=6.46p AD=10.88p PS=7.2u
+ PD=13.2u
* device instance $1891 r0 *1 538.8,322.1 PMOS
XM$1891 \$I4208 \$I4209 VDD VDD PMOS L=1u W=3.4u AS=10.88p AD=6.46p PS=13.2u
+ PD=7.2u
* device instance $1892 r0 *1 543.6,322.1 PMOS
XM$1892 VDD \$I4208 \$I4209 VDD PMOS L=1u W=3.4u AS=6.46p AD=10.88p PS=7.2u
+ PD=13.2u
* device instance $1893 r0 *1 534,301.7 NMOS
XM$1893 BL22 WL10 \$I4208 VSS NMOS L=1u W=3.4u AS=10.88p AD=6.46p PS=13.2u
+ PD=7.2u
* device instance $1894 r0 *1 538.8,301.7 NMOS
XM$1894 \$I4208 \$I4209 VSS VSS NMOS L=1u W=3.4u AS=6.46p AD=6.46p PS=7.2u
+ PD=7.2u
* device instance $1895 r0 *1 543.6,301.7 NMOS
XM$1895 VSS \$I4208 \$I4209 VSS NMOS L=1u W=3.4u AS=6.46p AD=6.46p PS=7.2u
+ PD=7.2u
* device instance $1896 r0 *1 548.4,301.7 NMOS
XM$1896 \$I4209 WL10 BLB22 VSS NMOS L=1u W=3.4u AS=6.46p AD=10.88p PS=7.2u
+ PD=13.2u
* device instance $1897 r0 *1 239.2,381.3 PMOS
XM$1897 \$I4210 \$I4211 VDD VDD PMOS L=1u W=3.4u AS=10.88p AD=6.46p PS=13.2u
+ PD=7.2u
* device instance $1898 r0 *1 244,381.3 PMOS
XM$1898 VDD \$I4210 \$I4211 VDD PMOS L=1u W=3.4u AS=6.46p AD=10.88p PS=7.2u
+ PD=13.2u
* device instance $1899 r0 *1 234.4,360.9 NMOS
XM$1899 BL10 WL12 \$I4210 VSS NMOS L=1u W=3.4u AS=10.88p AD=6.46p PS=13.2u
+ PD=7.2u
* device instance $1900 r0 *1 239.2,360.9 NMOS
XM$1900 \$I4210 \$I4211 VSS VSS NMOS L=1u W=3.4u AS=6.46p AD=6.46p PS=7.2u
+ PD=7.2u
* device instance $1901 r0 *1 244,360.9 NMOS
XM$1901 VSS \$I4210 \$I4211 VSS NMOS L=1u W=3.4u AS=6.46p AD=6.46p PS=7.2u
+ PD=7.2u
* device instance $1902 r0 *1 248.8,360.9 NMOS
XM$1902 \$I4211 WL12 BLB10 VSS NMOS L=1u W=3.4u AS=6.46p AD=10.88p PS=7.2u
+ PD=13.2u
* device instance $1903 r0 *1 216,381.3 PMOS
XM$1903 \$I4212 \$I4213 VDD VDD PMOS L=1u W=3.4u AS=10.88p AD=6.46p PS=13.2u
+ PD=7.2u
* device instance $1904 r0 *1 220.8,381.3 PMOS
XM$1904 VDD \$I4212 \$I4213 VDD PMOS L=1u W=3.4u AS=6.46p AD=10.88p PS=7.2u
+ PD=13.2u
* device instance $1905 r0 *1 211.2,360.9 NMOS
XM$1905 BL9 WL12 \$I4212 VSS NMOS L=1u W=3.4u AS=10.88p AD=6.46p PS=13.2u
+ PD=7.2u
* device instance $1906 r0 *1 216,360.9 NMOS
XM$1906 \$I4212 \$I4213 VSS VSS NMOS L=1u W=3.4u AS=6.46p AD=6.46p PS=7.2u
+ PD=7.2u
* device instance $1907 r0 *1 220.8,360.9 NMOS
XM$1907 VSS \$I4212 \$I4213 VSS NMOS L=1u W=3.4u AS=6.46p AD=6.46p PS=7.2u
+ PD=7.2u
* device instance $1908 r0 *1 225.6,360.9 NMOS
XM$1908 \$I4213 WL12 BLB9 VSS NMOS L=1u W=3.4u AS=6.46p AD=10.88p PS=7.2u
+ PD=13.2u
* device instance $1909 r0 *1 355.2,381.3 PMOS
XM$1909 \$I4214 \$I4215 VDD VDD PMOS L=1u W=3.4u AS=10.88p AD=6.46p PS=13.2u
+ PD=7.2u
* device instance $1910 r0 *1 360,381.3 PMOS
XM$1910 VDD \$I4214 \$I4215 VDD PMOS L=1u W=3.4u AS=6.46p AD=10.88p PS=7.2u
+ PD=13.2u
* device instance $1911 r0 *1 350.4,360.9 NMOS
XM$1911 BL15 WL12 \$I4214 VSS NMOS L=1u W=3.4u AS=10.88p AD=6.46p PS=13.2u
+ PD=7.2u
* device instance $1912 r0 *1 355.2,360.9 NMOS
XM$1912 \$I4214 \$I4215 VSS VSS NMOS L=1u W=3.4u AS=6.46p AD=6.46p PS=7.2u
+ PD=7.2u
* device instance $1913 r0 *1 360,360.9 NMOS
XM$1913 VSS \$I4214 \$I4215 VSS NMOS L=1u W=3.4u AS=6.46p AD=6.46p PS=7.2u
+ PD=7.2u
* device instance $1914 r0 *1 364.8,360.9 NMOS
XM$1914 \$I4215 WL12 BLB15 VSS NMOS L=1u W=3.4u AS=6.46p AD=10.88p PS=7.2u
+ PD=13.2u
* device instance $1915 r0 *1 239.2,440.5 PMOS
XM$1915 \$I4216 \$I4217 VDD VDD PMOS L=1u W=3.4u AS=10.88p AD=6.46p PS=13.2u
+ PD=7.2u
* device instance $1916 r0 *1 244,440.5 PMOS
XM$1916 VDD \$I4216 \$I4217 VDD PMOS L=1u W=3.4u AS=6.46p AD=10.88p PS=7.2u
+ PD=13.2u
* device instance $1917 r0 *1 234.4,420.1 NMOS
XM$1917 BL10 WL14 \$I4216 VSS NMOS L=1u W=3.4u AS=10.88p AD=6.46p PS=13.2u
+ PD=7.2u
* device instance $1918 r0 *1 239.2,420.1 NMOS
XM$1918 \$I4216 \$I4217 VSS VSS NMOS L=1u W=3.4u AS=6.46p AD=6.46p PS=7.2u
+ PD=7.2u
* device instance $1919 r0 *1 244,420.1 NMOS
XM$1919 VSS \$I4216 \$I4217 VSS NMOS L=1u W=3.4u AS=6.46p AD=6.46p PS=7.2u
+ PD=7.2u
* device instance $1920 r0 *1 248.8,420.1 NMOS
XM$1920 \$I4217 WL14 BLB10 VSS NMOS L=1u W=3.4u AS=6.46p AD=10.88p PS=7.2u
+ PD=13.2u
* device instance $1921 r0 *1 538.8,440.5 PMOS
XM$1921 \$I4218 \$I4219 VDD VDD PMOS L=1u W=3.4u AS=10.88p AD=6.46p PS=13.2u
+ PD=7.2u
* device instance $1922 r0 *1 543.6,440.5 PMOS
XM$1922 VDD \$I4218 \$I4219 VDD PMOS L=1u W=3.4u AS=6.46p AD=10.88p PS=7.2u
+ PD=13.2u
* device instance $1923 r0 *1 534,420.1 NMOS
XM$1923 BL22 WL14 \$I4218 VSS NMOS L=1u W=3.4u AS=10.88p AD=6.46p PS=13.2u
+ PD=7.2u
* device instance $1924 r0 *1 538.8,420.1 NMOS
XM$1924 \$I4218 \$I4219 VSS VSS NMOS L=1u W=3.4u AS=6.46p AD=6.46p PS=7.2u
+ PD=7.2u
* device instance $1925 r0 *1 543.6,420.1 NMOS
XM$1925 VSS \$I4218 \$I4219 VSS NMOS L=1u W=3.4u AS=6.46p AD=6.46p PS=7.2u
+ PD=7.2u
* device instance $1926 r0 *1 548.4,420.1 NMOS
XM$1926 \$I4219 WL14 BLB22 VSS NMOS L=1u W=3.4u AS=6.46p AD=10.88p PS=7.2u
+ PD=13.2u
* device instance $1927 r0 *1 608.4,381.3 PMOS
XM$1927 \$I4220 \$I4221 VDD VDD PMOS L=1u W=3.4u AS=10.88p AD=6.46p PS=13.2u
+ PD=7.2u
* device instance $1928 r0 *1 613.2,381.3 PMOS
XM$1928 VDD \$I4220 \$I4221 VDD PMOS L=1u W=3.4u AS=6.46p AD=10.88p PS=7.2u
+ PD=13.2u
* device instance $1929 r0 *1 603.6,360.9 NMOS
XM$1929 BL25 WL12 \$I4220 VSS NMOS L=1u W=3.4u AS=10.88p AD=6.46p PS=13.2u
+ PD=7.2u
* device instance $1930 r0 *1 608.4,360.9 NMOS
XM$1930 \$I4220 \$I4221 VSS VSS NMOS L=1u W=3.4u AS=6.46p AD=6.46p PS=7.2u
+ PD=7.2u
* device instance $1931 r0 *1 613.2,360.9 NMOS
XM$1931 VSS \$I4220 \$I4221 VSS NMOS L=1u W=3.4u AS=6.46p AD=6.46p PS=7.2u
+ PD=7.2u
* device instance $1932 r0 *1 618,360.9 NMOS
XM$1932 \$I4221 WL12 BLB25 VSS NMOS L=1u W=3.4u AS=6.46p AD=10.88p PS=7.2u
+ PD=13.2u
* device instance $1933 r0 *1 654.8,381.3 PMOS
XM$1933 \$I4222 \$I4223 VDD VDD PMOS L=1u W=3.4u AS=10.88p AD=6.46p PS=13.2u
+ PD=7.2u
* device instance $1934 r0 *1 659.6,381.3 PMOS
XM$1934 VDD \$I4222 \$I4223 VDD PMOS L=1u W=3.4u AS=6.46p AD=10.88p PS=7.2u
+ PD=13.2u
* device instance $1935 r0 *1 650,360.9 NMOS
XM$1935 BL27 WL12 \$I4222 VSS NMOS L=1u W=3.4u AS=10.88p AD=6.46p PS=13.2u
+ PD=7.2u
* device instance $1936 r0 *1 654.8,360.9 NMOS
XM$1936 \$I4222 \$I4223 VSS VSS NMOS L=1u W=3.4u AS=6.46p AD=6.46p PS=7.2u
+ PD=7.2u
* device instance $1937 r0 *1 659.6,360.9 NMOS
XM$1937 VSS \$I4222 \$I4223 VSS NMOS L=1u W=3.4u AS=6.46p AD=6.46p PS=7.2u
+ PD=7.2u
* device instance $1938 r0 *1 664.4,360.9 NMOS
XM$1938 \$I4223 WL12 BLB27 VSS NMOS L=1u W=3.4u AS=6.46p AD=10.88p PS=7.2u
+ PD=13.2u
* device instance $1939 r0 *1 678,381.3 PMOS
XM$1939 \$I4224 \$I4225 VDD VDD PMOS L=1u W=3.4u AS=10.88p AD=6.46p PS=13.2u
+ PD=7.2u
* device instance $1940 r0 *1 682.8,381.3 PMOS
XM$1940 VDD \$I4224 \$I4225 VDD PMOS L=1u W=3.4u AS=6.46p AD=10.88p PS=7.2u
+ PD=13.2u
* device instance $1941 r0 *1 673.2,360.9 NMOS
XM$1941 BL28 WL12 \$I4224 VSS NMOS L=1u W=3.4u AS=10.88p AD=6.46p PS=13.2u
+ PD=7.2u
* device instance $1942 r0 *1 678,360.9 NMOS
XM$1942 \$I4224 \$I4225 VSS VSS NMOS L=1u W=3.4u AS=6.46p AD=6.46p PS=7.2u
+ PD=7.2u
* device instance $1943 r0 *1 682.8,360.9 NMOS
XM$1943 VSS \$I4224 \$I4225 VSS NMOS L=1u W=3.4u AS=6.46p AD=6.46p PS=7.2u
+ PD=7.2u
* device instance $1944 r0 *1 687.6,360.9 NMOS
XM$1944 \$I4225 WL12 BLB28 VSS NMOS L=1u W=3.4u AS=6.46p AD=10.88p PS=7.2u
+ PD=13.2u
* device instance $1945 r0 *1 701.2,381.3 PMOS
XM$1945 \$I4226 \$I4227 VDD VDD PMOS L=1u W=3.4u AS=10.88p AD=6.46p PS=13.2u
+ PD=7.2u
* device instance $1946 r0 *1 706,381.3 PMOS
XM$1946 VDD \$I4226 \$I4227 VDD PMOS L=1u W=3.4u AS=6.46p AD=10.88p PS=7.2u
+ PD=13.2u
* device instance $1947 r0 *1 696.4,360.9 NMOS
XM$1947 BL29 WL12 \$I4226 VSS NMOS L=1u W=3.4u AS=10.88p AD=6.46p PS=13.2u
+ PD=7.2u
* device instance $1948 r0 *1 701.2,360.9 NMOS
XM$1948 \$I4226 \$I4227 VSS VSS NMOS L=1u W=3.4u AS=6.46p AD=6.46p PS=7.2u
+ PD=7.2u
* device instance $1949 r0 *1 706,360.9 NMOS
XM$1949 VSS \$I4226 \$I4227 VSS NMOS L=1u W=3.4u AS=6.46p AD=6.46p PS=7.2u
+ PD=7.2u
* device instance $1950 r0 *1 710.8,360.9 NMOS
XM$1950 \$I4227 WL12 BLB29 VSS NMOS L=1u W=3.4u AS=6.46p AD=10.88p PS=7.2u
+ PD=13.2u
* device instance $1951 r0 *1 724.4,381.3 PMOS
XM$1951 \$I4228 \$I4229 VDD VDD PMOS L=1u W=3.4u AS=10.88p AD=6.46p PS=13.2u
+ PD=7.2u
* device instance $1952 r0 *1 729.2,381.3 PMOS
XM$1952 VDD \$I4228 \$I4229 VDD PMOS L=1u W=3.4u AS=6.46p AD=10.88p PS=7.2u
+ PD=13.2u
* device instance $1953 r0 *1 719.6,360.9 NMOS
XM$1953 BL30 WL12 \$I4228 VSS NMOS L=1u W=3.4u AS=10.88p AD=6.46p PS=13.2u
+ PD=7.2u
* device instance $1954 r0 *1 724.4,360.9 NMOS
XM$1954 \$I4228 \$I4229 VSS VSS NMOS L=1u W=3.4u AS=6.46p AD=6.46p PS=7.2u
+ PD=7.2u
* device instance $1955 r0 *1 729.2,360.9 NMOS
XM$1955 VSS \$I4228 \$I4229 VSS NMOS L=1u W=3.4u AS=6.46p AD=6.46p PS=7.2u
+ PD=7.2u
* device instance $1956 r0 *1 734,360.9 NMOS
XM$1956 \$I4229 WL12 BLB30 VSS NMOS L=1u W=3.4u AS=6.46p AD=10.88p PS=7.2u
+ PD=13.2u
* device instance $1957 r0 *1 747.6,381.3 PMOS
XM$1957 \$I4230 \$I4231 VDD VDD PMOS L=1u W=3.4u AS=10.88p AD=6.46p PS=13.2u
+ PD=7.2u
* device instance $1958 r0 *1 752.4,381.3 PMOS
XM$1958 VDD \$I4230 \$I4231 VDD PMOS L=1u W=3.4u AS=6.46p AD=10.88p PS=7.2u
+ PD=13.2u
* device instance $1959 r0 *1 742.8,360.9 NMOS
XM$1959 BL31 WL12 \$I4230 VSS NMOS L=1u W=3.4u AS=10.88p AD=6.46p PS=13.2u
+ PD=7.2u
* device instance $1960 r0 *1 747.6,360.9 NMOS
XM$1960 \$I4230 \$I4231 VSS VSS NMOS L=1u W=3.4u AS=6.46p AD=6.46p PS=7.2u
+ PD=7.2u
* device instance $1961 r0 *1 752.4,360.9 NMOS
XM$1961 VSS \$I4230 \$I4231 VSS NMOS L=1u W=3.4u AS=6.46p AD=6.46p PS=7.2u
+ PD=7.2u
* device instance $1962 r0 *1 757.2,360.9 NMOS
XM$1962 \$I4231 WL12 BLB31 VSS NMOS L=1u W=3.4u AS=6.46p AD=10.88p PS=7.2u
+ PD=13.2u
* device instance $1963 r0 *1 585.2,381.3 PMOS
XM$1963 \$I4232 \$I4233 VDD VDD PMOS L=1u W=3.4u AS=10.88p AD=6.46p PS=13.2u
+ PD=7.2u
* device instance $1964 r0 *1 590,381.3 PMOS
XM$1964 VDD \$I4232 \$I4233 VDD PMOS L=1u W=3.4u AS=6.46p AD=10.88p PS=7.2u
+ PD=13.2u
* device instance $1965 r0 *1 580.4,360.9 NMOS
XM$1965 BL24 WL12 \$I4232 VSS NMOS L=1u W=3.4u AS=10.88p AD=6.46p PS=13.2u
+ PD=7.2u
* device instance $1966 r0 *1 585.2,360.9 NMOS
XM$1966 \$I4232 \$I4233 VSS VSS NMOS L=1u W=3.4u AS=6.46p AD=6.46p PS=7.2u
+ PD=7.2u
* device instance $1967 r0 *1 590,360.9 NMOS
XM$1967 VSS \$I4232 \$I4233 VSS NMOS L=1u W=3.4u AS=6.46p AD=6.46p PS=7.2u
+ PD=7.2u
* device instance $1968 r0 *1 594.8,360.9 NMOS
XM$1968 \$I4233 WL12 BLB24 VSS NMOS L=1u W=3.4u AS=6.46p AD=10.88p PS=7.2u
+ PD=13.2u
* device instance $1969 r0 *1 724.4,262.9 PMOS
XM$1969 \$I4234 \$I4235 VDD VDD PMOS L=1u W=3.4u AS=10.88p AD=6.46p PS=13.2u
+ PD=7.2u
* device instance $1970 r0 *1 729.2,262.9 PMOS
XM$1970 VDD \$I4234 \$I4235 VDD PMOS L=1u W=3.4u AS=6.46p AD=10.88p PS=7.2u
+ PD=13.2u
* device instance $1971 r0 *1 719.6,242.5 NMOS
XM$1971 BL30 WL8 \$I4234 VSS NMOS L=1u W=3.4u AS=10.88p AD=6.46p PS=13.2u
+ PD=7.2u
* device instance $1972 r0 *1 724.4,242.5 NMOS
XM$1972 \$I4234 \$I4235 VSS VSS NMOS L=1u W=3.4u AS=6.46p AD=6.46p PS=7.2u
+ PD=7.2u
* device instance $1973 r0 *1 729.2,242.5 NMOS
XM$1973 VSS \$I4234 \$I4235 VSS NMOS L=1u W=3.4u AS=6.46p AD=6.46p PS=7.2u
+ PD=7.2u
* device instance $1974 r0 *1 734,242.5 NMOS
XM$1974 \$I4235 WL8 BLB30 VSS NMOS L=1u W=3.4u AS=6.46p AD=10.88p PS=7.2u
+ PD=13.2u
* device instance $1975 r0 *1 747.6,262.9 PMOS
XM$1975 \$I4236 \$I4237 VDD VDD PMOS L=1u W=3.4u AS=10.88p AD=6.46p PS=13.2u
+ PD=7.2u
* device instance $1976 r0 *1 752.4,262.9 PMOS
XM$1976 VDD \$I4236 \$I4237 VDD PMOS L=1u W=3.4u AS=6.46p AD=10.88p PS=7.2u
+ PD=13.2u
* device instance $1977 r0 *1 742.8,242.5 NMOS
XM$1977 BL31 WL8 \$I4236 VSS NMOS L=1u W=3.4u AS=10.88p AD=6.46p PS=13.2u
+ PD=7.2u
* device instance $1978 r0 *1 747.6,242.5 NMOS
XM$1978 \$I4236 \$I4237 VSS VSS NMOS L=1u W=3.4u AS=6.46p AD=6.46p PS=7.2u
+ PD=7.2u
* device instance $1979 r0 *1 752.4,242.5 NMOS
XM$1979 VSS \$I4236 \$I4237 VSS NMOS L=1u W=3.4u AS=6.46p AD=6.46p PS=7.2u
+ PD=7.2u
* device instance $1980 r0 *1 757.2,242.5 NMOS
XM$1980 \$I4237 WL8 BLB31 VSS NMOS L=1u W=3.4u AS=6.46p AD=10.88p PS=7.2u
+ PD=13.2u
* device instance $1981 r0 *1 585.2,322.1 PMOS
XM$1981 \$I4238 \$I4239 VDD VDD PMOS L=1u W=3.4u AS=10.88p AD=6.46p PS=13.2u
+ PD=7.2u
* device instance $1982 r0 *1 590,322.1 PMOS
XM$1982 VDD \$I4238 \$I4239 VDD PMOS L=1u W=3.4u AS=6.46p AD=10.88p PS=7.2u
+ PD=13.2u
* device instance $1983 r0 *1 580.4,301.7 NMOS
XM$1983 BL24 WL10 \$I4238 VSS NMOS L=1u W=3.4u AS=10.88p AD=6.46p PS=13.2u
+ PD=7.2u
* device instance $1984 r0 *1 585.2,301.7 NMOS
XM$1984 \$I4238 \$I4239 VSS VSS NMOS L=1u W=3.4u AS=6.46p AD=6.46p PS=7.2u
+ PD=7.2u
* device instance $1985 r0 *1 590,301.7 NMOS
XM$1985 VSS \$I4238 \$I4239 VSS NMOS L=1u W=3.4u AS=6.46p AD=6.46p PS=7.2u
+ PD=7.2u
* device instance $1986 r0 *1 594.8,301.7 NMOS
XM$1986 \$I4239 WL10 BLB24 VSS NMOS L=1u W=3.4u AS=6.46p AD=10.88p PS=7.2u
+ PD=13.2u
* device instance $1987 r0 *1 608.4,322.1 PMOS
XM$1987 \$I4240 \$I4241 VDD VDD PMOS L=1u W=3.4u AS=10.88p AD=6.46p PS=13.2u
+ PD=7.2u
* device instance $1988 r0 *1 613.2,322.1 PMOS
XM$1988 VDD \$I4240 \$I4241 VDD PMOS L=1u W=3.4u AS=6.46p AD=10.88p PS=7.2u
+ PD=13.2u
* device instance $1989 r0 *1 603.6,301.7 NMOS
XM$1989 BL25 WL10 \$I4240 VSS NMOS L=1u W=3.4u AS=10.88p AD=6.46p PS=13.2u
+ PD=7.2u
* device instance $1990 r0 *1 608.4,301.7 NMOS
XM$1990 \$I4240 \$I4241 VSS VSS NMOS L=1u W=3.4u AS=6.46p AD=6.46p PS=7.2u
+ PD=7.2u
* device instance $1991 r0 *1 613.2,301.7 NMOS
XM$1991 VSS \$I4240 \$I4241 VSS NMOS L=1u W=3.4u AS=6.46p AD=6.46p PS=7.2u
+ PD=7.2u
* device instance $1992 r0 *1 618,301.7 NMOS
XM$1992 \$I4241 WL10 BLB25 VSS NMOS L=1u W=3.4u AS=6.46p AD=10.88p PS=7.2u
+ PD=13.2u
* device instance $1993 r0 *1 631.6,322.1 PMOS
XM$1993 \$I4242 \$I4243 VDD VDD PMOS L=1u W=3.4u AS=10.88p AD=6.46p PS=13.2u
+ PD=7.2u
* device instance $1994 r0 *1 636.4,322.1 PMOS
XM$1994 VDD \$I4242 \$I4243 VDD PMOS L=1u W=3.4u AS=6.46p AD=10.88p PS=7.2u
+ PD=13.2u
* device instance $1995 r0 *1 626.8,301.7 NMOS
XM$1995 BL26 WL10 \$I4242 VSS NMOS L=1u W=3.4u AS=10.88p AD=6.46p PS=13.2u
+ PD=7.2u
* device instance $1996 r0 *1 631.6,301.7 NMOS
XM$1996 \$I4242 \$I4243 VSS VSS NMOS L=1u W=3.4u AS=6.46p AD=6.46p PS=7.2u
+ PD=7.2u
* device instance $1997 r0 *1 636.4,301.7 NMOS
XM$1997 VSS \$I4242 \$I4243 VSS NMOS L=1u W=3.4u AS=6.46p AD=6.46p PS=7.2u
+ PD=7.2u
* device instance $1998 r0 *1 641.2,301.7 NMOS
XM$1998 \$I4243 WL10 BLB26 VSS NMOS L=1u W=3.4u AS=6.46p AD=10.88p PS=7.2u
+ PD=13.2u
* device instance $1999 r0 *1 538.8,262.9 PMOS
XM$1999 \$I4244 \$I4245 VDD VDD PMOS L=1u W=3.4u AS=10.88p AD=6.46p PS=13.2u
+ PD=7.2u
* device instance $2000 r0 *1 543.6,262.9 PMOS
XM$2000 VDD \$I4244 \$I4245 VDD PMOS L=1u W=3.4u AS=6.46p AD=10.88p PS=7.2u
+ PD=13.2u
* device instance $2001 r0 *1 534,242.5 NMOS
XM$2001 BL22 WL8 \$I4244 VSS NMOS L=1u W=3.4u AS=10.88p AD=6.46p PS=13.2u
+ PD=7.2u
* device instance $2002 r0 *1 538.8,242.5 NMOS
XM$2002 \$I4244 \$I4245 VSS VSS NMOS L=1u W=3.4u AS=6.46p AD=6.46p PS=7.2u
+ PD=7.2u
* device instance $2003 r0 *1 543.6,242.5 NMOS
XM$2003 VSS \$I4244 \$I4245 VSS NMOS L=1u W=3.4u AS=6.46p AD=6.46p PS=7.2u
+ PD=7.2u
* device instance $2004 r0 *1 548.4,242.5 NMOS
XM$2004 \$I4245 WL8 BLB22 VSS NMOS L=1u W=3.4u AS=6.46p AD=10.88p PS=7.2u
+ PD=13.2u
* device instance $2005 r0 *1 399.6,381.3 PMOS
XM$2005 \$I4246 \$I4247 VDD VDD PMOS L=1u W=3.4u AS=10.88p AD=6.46p PS=13.2u
+ PD=7.2u
* device instance $2006 r0 *1 404.4,381.3 PMOS
XM$2006 VDD \$I4246 \$I4247 VDD PMOS L=1u W=3.4u AS=6.46p AD=10.88p PS=7.2u
+ PD=13.2u
* device instance $2007 r0 *1 394.8,360.9 NMOS
XM$2007 BL16 WL12 \$I4246 VSS NMOS L=1u W=3.4u AS=10.88p AD=6.46p PS=13.2u
+ PD=7.2u
* device instance $2008 r0 *1 399.6,360.9 NMOS
XM$2008 \$I4246 \$I4247 VSS VSS NMOS L=1u W=3.4u AS=6.46p AD=6.46p PS=7.2u
+ PD=7.2u
* device instance $2009 r0 *1 404.4,360.9 NMOS
XM$2009 VSS \$I4246 \$I4247 VSS NMOS L=1u W=3.4u AS=6.46p AD=6.46p PS=7.2u
+ PD=7.2u
* device instance $2010 r0 *1 409.2,360.9 NMOS
XM$2010 \$I4247 WL12 BLB16 VSS NMOS L=1u W=3.4u AS=6.46p AD=10.88p PS=7.2u
+ PD=13.2u
* device instance $2011 r0 *1 538.8,381.3 PMOS
XM$2011 \$I4248 \$I4249 VDD VDD PMOS L=1u W=3.4u AS=10.88p AD=6.46p PS=13.2u
+ PD=7.2u
* device instance $2012 r0 *1 543.6,381.3 PMOS
XM$2012 VDD \$I4248 \$I4249 VDD PMOS L=1u W=3.4u AS=6.46p AD=10.88p PS=7.2u
+ PD=13.2u
* device instance $2013 r0 *1 534,360.9 NMOS
XM$2013 BL22 WL12 \$I4248 VSS NMOS L=1u W=3.4u AS=10.88p AD=6.46p PS=13.2u
+ PD=7.2u
* device instance $2014 r0 *1 538.8,360.9 NMOS
XM$2014 \$I4248 \$I4249 VSS VSS NMOS L=1u W=3.4u AS=6.46p AD=6.46p PS=7.2u
+ PD=7.2u
* device instance $2015 r0 *1 543.6,360.9 NMOS
XM$2015 VSS \$I4248 \$I4249 VSS NMOS L=1u W=3.4u AS=6.46p AD=6.46p PS=7.2u
+ PD=7.2u
* device instance $2016 r0 *1 548.4,360.9 NMOS
XM$2016 \$I4249 WL12 BLB22 VSS NMOS L=1u W=3.4u AS=6.46p AD=10.88p PS=7.2u
+ PD=13.2u
* device instance $2017 r0 *1 446,381.3 PMOS
XM$2017 \$I4250 \$I4251 VDD VDD PMOS L=1u W=3.4u AS=10.88p AD=6.46p PS=13.2u
+ PD=7.2u
* device instance $2018 r0 *1 450.8,381.3 PMOS
XM$2018 VDD \$I4250 \$I4251 VDD PMOS L=1u W=3.4u AS=6.46p AD=10.88p PS=7.2u
+ PD=13.2u
* device instance $2019 r0 *1 441.2,360.9 NMOS
XM$2019 BL18 WL12 \$I4250 VSS NMOS L=1u W=3.4u AS=10.88p AD=6.46p PS=13.2u
+ PD=7.2u
* device instance $2020 r0 *1 446,360.9 NMOS
XM$2020 \$I4250 \$I4251 VSS VSS NMOS L=1u W=3.4u AS=6.46p AD=6.46p PS=7.2u
+ PD=7.2u
* device instance $2021 r0 *1 450.8,360.9 NMOS
XM$2021 VSS \$I4250 \$I4251 VSS NMOS L=1u W=3.4u AS=6.46p AD=6.46p PS=7.2u
+ PD=7.2u
* device instance $2022 r0 *1 455.6,360.9 NMOS
XM$2022 \$I4251 WL12 BLB18 VSS NMOS L=1u W=3.4u AS=6.46p AD=10.88p PS=7.2u
+ PD=13.2u
* device instance $2023 r0 *1 654.8,322.1 PMOS
XM$2023 \$I4252 \$I4253 VDD VDD PMOS L=1u W=3.4u AS=10.88p AD=6.46p PS=13.2u
+ PD=7.2u
* device instance $2024 r0 *1 659.6,322.1 PMOS
XM$2024 VDD \$I4252 \$I4253 VDD PMOS L=1u W=3.4u AS=6.46p AD=10.88p PS=7.2u
+ PD=13.2u
* device instance $2025 r0 *1 650,301.7 NMOS
XM$2025 BL27 WL10 \$I4252 VSS NMOS L=1u W=3.4u AS=10.88p AD=6.46p PS=13.2u
+ PD=7.2u
* device instance $2026 r0 *1 654.8,301.7 NMOS
XM$2026 \$I4252 \$I4253 VSS VSS NMOS L=1u W=3.4u AS=6.46p AD=6.46p PS=7.2u
+ PD=7.2u
* device instance $2027 r0 *1 659.6,301.7 NMOS
XM$2027 VSS \$I4252 \$I4253 VSS NMOS L=1u W=3.4u AS=6.46p AD=6.46p PS=7.2u
+ PD=7.2u
* device instance $2028 r0 *1 664.4,301.7 NMOS
XM$2028 \$I4253 WL10 BLB27 VSS NMOS L=1u W=3.4u AS=6.46p AD=10.88p PS=7.2u
+ PD=13.2u
* device instance $2029 r0 *1 469.2,381.3 PMOS
XM$2029 \$I4254 \$I4255 VDD VDD PMOS L=1u W=3.4u AS=10.88p AD=6.46p PS=13.2u
+ PD=7.2u
* device instance $2030 r0 *1 474,381.3 PMOS
XM$2030 VDD \$I4254 \$I4255 VDD PMOS L=1u W=3.4u AS=6.46p AD=10.88p PS=7.2u
+ PD=13.2u
* device instance $2031 r0 *1 464.4,360.9 NMOS
XM$2031 BL19 WL12 \$I4254 VSS NMOS L=1u W=3.4u AS=10.88p AD=6.46p PS=13.2u
+ PD=7.2u
* device instance $2032 r0 *1 469.2,360.9 NMOS
XM$2032 \$I4254 \$I4255 VSS VSS NMOS L=1u W=3.4u AS=6.46p AD=6.46p PS=7.2u
+ PD=7.2u
* device instance $2033 r0 *1 474,360.9 NMOS
XM$2033 VSS \$I4254 \$I4255 VSS NMOS L=1u W=3.4u AS=6.46p AD=6.46p PS=7.2u
+ PD=7.2u
* device instance $2034 r0 *1 478.8,360.9 NMOS
XM$2034 \$I4255 WL12 BLB19 VSS NMOS L=1u W=3.4u AS=6.46p AD=10.88p PS=7.2u
+ PD=13.2u
* device instance $2035 r0 *1 492.4,381.3 PMOS
XM$2035 \$I4256 \$I4257 VDD VDD PMOS L=1u W=3.4u AS=10.88p AD=6.46p PS=13.2u
+ PD=7.2u
* device instance $2036 r0 *1 497.2,381.3 PMOS
XM$2036 VDD \$I4256 \$I4257 VDD PMOS L=1u W=3.4u AS=6.46p AD=10.88p PS=7.2u
+ PD=13.2u
* device instance $2037 r0 *1 487.6,360.9 NMOS
XM$2037 BL20 WL12 \$I4256 VSS NMOS L=1u W=3.4u AS=10.88p AD=6.46p PS=13.2u
+ PD=7.2u
* device instance $2038 r0 *1 492.4,360.9 NMOS
XM$2038 \$I4256 \$I4257 VSS VSS NMOS L=1u W=3.4u AS=6.46p AD=6.46p PS=7.2u
+ PD=7.2u
* device instance $2039 r0 *1 497.2,360.9 NMOS
XM$2039 VSS \$I4256 \$I4257 VSS NMOS L=1u W=3.4u AS=6.46p AD=6.46p PS=7.2u
+ PD=7.2u
* device instance $2040 r0 *1 502,360.9 NMOS
XM$2040 \$I4257 WL12 BLB20 VSS NMOS L=1u W=3.4u AS=6.46p AD=10.88p PS=7.2u
+ PD=13.2u
* device instance $2041 r0 *1 515.6,381.3 PMOS
XM$2041 \$I4258 \$I4259 VDD VDD PMOS L=1u W=3.4u AS=10.88p AD=6.46p PS=13.2u
+ PD=7.2u
* device instance $2042 r0 *1 520.4,381.3 PMOS
XM$2042 VDD \$I4258 \$I4259 VDD PMOS L=1u W=3.4u AS=6.46p AD=10.88p PS=7.2u
+ PD=13.2u
* device instance $2043 r0 *1 510.8,360.9 NMOS
XM$2043 BL21 WL12 \$I4258 VSS NMOS L=1u W=3.4u AS=10.88p AD=6.46p PS=13.2u
+ PD=7.2u
* device instance $2044 r0 *1 515.6,360.9 NMOS
XM$2044 \$I4258 \$I4259 VSS VSS NMOS L=1u W=3.4u AS=6.46p AD=6.46p PS=7.2u
+ PD=7.2u
* device instance $2045 r0 *1 520.4,360.9 NMOS
XM$2045 VSS \$I4258 \$I4259 VSS NMOS L=1u W=3.4u AS=6.46p AD=6.46p PS=7.2u
+ PD=7.2u
* device instance $2046 r0 *1 525.2,360.9 NMOS
XM$2046 \$I4259 WL12 BLB21 VSS NMOS L=1u W=3.4u AS=6.46p AD=10.88p PS=7.2u
+ PD=13.2u
* device instance $2047 r0 *1 678,322.1 PMOS
XM$2047 \$I4260 \$I4261 VDD VDD PMOS L=1u W=3.4u AS=10.88p AD=6.46p PS=13.2u
+ PD=7.2u
* device instance $2048 r0 *1 682.8,322.1 PMOS
XM$2048 VDD \$I4260 \$I4261 VDD PMOS L=1u W=3.4u AS=6.46p AD=10.88p PS=7.2u
+ PD=13.2u
* device instance $2049 r0 *1 673.2,301.7 NMOS
XM$2049 BL28 WL10 \$I4260 VSS NMOS L=1u W=3.4u AS=10.88p AD=6.46p PS=13.2u
+ PD=7.2u
* device instance $2050 r0 *1 678,301.7 NMOS
XM$2050 \$I4260 \$I4261 VSS VSS NMOS L=1u W=3.4u AS=6.46p AD=6.46p PS=7.2u
+ PD=7.2u
* device instance $2051 r0 *1 682.8,301.7 NMOS
XM$2051 VSS \$I4260 \$I4261 VSS NMOS L=1u W=3.4u AS=6.46p AD=6.46p PS=7.2u
+ PD=7.2u
* device instance $2052 r0 *1 687.6,301.7 NMOS
XM$2052 \$I4261 WL10 BLB28 VSS NMOS L=1u W=3.4u AS=6.46p AD=10.88p PS=7.2u
+ PD=13.2u
* device instance $2053 r0 *1 701.2,322.1 PMOS
XM$2053 \$I4262 \$I4263 VDD VDD PMOS L=1u W=3.4u AS=10.88p AD=6.46p PS=13.2u
+ PD=7.2u
* device instance $2054 r0 *1 706,322.1 PMOS
XM$2054 VDD \$I4262 \$I4263 VDD PMOS L=1u W=3.4u AS=6.46p AD=10.88p PS=7.2u
+ PD=13.2u
* device instance $2055 r0 *1 696.4,301.7 NMOS
XM$2055 BL29 WL10 \$I4262 VSS NMOS L=1u W=3.4u AS=10.88p AD=6.46p PS=13.2u
+ PD=7.2u
* device instance $2056 r0 *1 701.2,301.7 NMOS
XM$2056 \$I4262 \$I4263 VSS VSS NMOS L=1u W=3.4u AS=6.46p AD=6.46p PS=7.2u
+ PD=7.2u
* device instance $2057 r0 *1 706,301.7 NMOS
XM$2057 VSS \$I4262 \$I4263 VSS NMOS L=1u W=3.4u AS=6.46p AD=6.46p PS=7.2u
+ PD=7.2u
* device instance $2058 r0 *1 710.8,301.7 NMOS
XM$2058 \$I4263 WL10 BLB29 VSS NMOS L=1u W=3.4u AS=6.46p AD=10.88p PS=7.2u
+ PD=13.2u
* device instance $2059 r0 *1 747.6,322.1 PMOS
XM$2059 \$I4264 \$I4265 VDD VDD PMOS L=1u W=3.4u AS=10.88p AD=6.46p PS=13.2u
+ PD=7.2u
* device instance $2060 r0 *1 752.4,322.1 PMOS
XM$2060 VDD \$I4264 \$I4265 VDD PMOS L=1u W=3.4u AS=6.46p AD=10.88p PS=7.2u
+ PD=13.2u
* device instance $2061 r0 *1 742.8,301.7 NMOS
XM$2061 BL31 WL10 \$I4264 VSS NMOS L=1u W=3.4u AS=10.88p AD=6.46p PS=13.2u
+ PD=7.2u
* device instance $2062 r0 *1 747.6,301.7 NMOS
XM$2062 \$I4264 \$I4265 VSS VSS NMOS L=1u W=3.4u AS=6.46p AD=6.46p PS=7.2u
+ PD=7.2u
* device instance $2063 r0 *1 752.4,301.7 NMOS
XM$2063 VSS \$I4264 \$I4265 VSS NMOS L=1u W=3.4u AS=6.46p AD=6.46p PS=7.2u
+ PD=7.2u
* device instance $2064 r0 *1 757.2,301.7 NMOS
XM$2064 \$I4265 WL10 BLB31 VSS NMOS L=1u W=3.4u AS=6.46p AD=10.88p PS=7.2u
+ PD=13.2u
* device instance $2065 r0 *1 724.4,322.1 PMOS
XM$2065 \$I4266 \$I4267 VDD VDD PMOS L=1u W=3.4u AS=10.88p AD=6.46p PS=13.2u
+ PD=7.2u
* device instance $2066 r0 *1 729.2,322.1 PMOS
XM$2066 VDD \$I4266 \$I4267 VDD PMOS L=1u W=3.4u AS=6.46p AD=10.88p PS=7.2u
+ PD=13.2u
* device instance $2067 r0 *1 719.6,301.7 NMOS
XM$2067 BL30 WL10 \$I4266 VSS NMOS L=1u W=3.4u AS=10.88p AD=6.46p PS=13.2u
+ PD=7.2u
* device instance $2068 r0 *1 724.4,301.7 NMOS
XM$2068 \$I4266 \$I4267 VSS VSS NMOS L=1u W=3.4u AS=6.46p AD=6.46p PS=7.2u
+ PD=7.2u
* device instance $2069 r0 *1 729.2,301.7 NMOS
XM$2069 VSS \$I4266 \$I4267 VSS NMOS L=1u W=3.4u AS=6.46p AD=6.46p PS=7.2u
+ PD=7.2u
* device instance $2070 r0 *1 734,301.7 NMOS
XM$2070 \$I4267 WL10 BLB30 VSS NMOS L=1u W=3.4u AS=6.46p AD=10.88p PS=7.2u
+ PD=13.2u
* device instance $2071 r0 *1 422.8,381.3 PMOS
XM$2071 \$I4268 \$I4269 VDD VDD PMOS L=1u W=3.4u AS=10.88p AD=6.46p PS=13.2u
+ PD=7.2u
* device instance $2072 r0 *1 427.6,381.3 PMOS
XM$2072 VDD \$I4268 \$I4269 VDD PMOS L=1u W=3.4u AS=6.46p AD=10.88p PS=7.2u
+ PD=13.2u
* device instance $2073 r0 *1 418,360.9 NMOS
XM$2073 BL17 WL12 \$I4268 VSS NMOS L=1u W=3.4u AS=10.88p AD=6.46p PS=13.2u
+ PD=7.2u
* device instance $2074 r0 *1 422.8,360.9 NMOS
XM$2074 \$I4268 \$I4269 VSS VSS NMOS L=1u W=3.4u AS=6.46p AD=6.46p PS=7.2u
+ PD=7.2u
* device instance $2075 r0 *1 427.6,360.9 NMOS
XM$2075 VSS \$I4268 \$I4269 VSS NMOS L=1u W=3.4u AS=6.46p AD=6.46p PS=7.2u
+ PD=7.2u
* device instance $2076 r0 *1 432.4,360.9 NMOS
XM$2076 \$I4269 WL12 BLB17 VSS NMOS L=1u W=3.4u AS=6.46p AD=10.88p PS=7.2u
+ PD=13.2u
* device instance $2077 r0 *1 216,440.5 PMOS
XM$2077 \$I4270 \$I4271 VDD VDD PMOS L=1u W=3.4u AS=10.88p AD=6.46p PS=13.2u
+ PD=7.2u
* device instance $2078 r0 *1 220.8,440.5 PMOS
XM$2078 VDD \$I4270 \$I4271 VDD PMOS L=1u W=3.4u AS=6.46p AD=10.88p PS=7.2u
+ PD=13.2u
* device instance $2079 r0 *1 211.2,420.1 NMOS
XM$2079 BL9 WL14 \$I4270 VSS NMOS L=1u W=3.4u AS=10.88p AD=6.46p PS=13.2u
+ PD=7.2u
* device instance $2080 r0 *1 216,420.1 NMOS
XM$2080 \$I4270 \$I4271 VSS VSS NMOS L=1u W=3.4u AS=6.46p AD=6.46p PS=7.2u
+ PD=7.2u
* device instance $2081 r0 *1 220.8,420.1 NMOS
XM$2081 VSS \$I4270 \$I4271 VSS NMOS L=1u W=3.4u AS=6.46p AD=6.46p PS=7.2u
+ PD=7.2u
* device instance $2082 r0 *1 225.6,420.1 NMOS
XM$2082 \$I4271 WL14 BLB9 VSS NMOS L=1u W=3.4u AS=6.46p AD=10.88p PS=7.2u
+ PD=13.2u
* device instance $2083 r0 *1 701.2,440.5 PMOS
XM$2083 \$I4272 \$I4273 VDD VDD PMOS L=1u W=3.4u AS=10.88p AD=6.46p PS=13.2u
+ PD=7.2u
* device instance $2084 r0 *1 706,440.5 PMOS
XM$2084 VDD \$I4272 \$I4273 VDD PMOS L=1u W=3.4u AS=6.46p AD=10.88p PS=7.2u
+ PD=13.2u
* device instance $2085 r0 *1 696.4,420.1 NMOS
XM$2085 BL29 WL14 \$I4272 VSS NMOS L=1u W=3.4u AS=10.88p AD=6.46p PS=13.2u
+ PD=7.2u
* device instance $2086 r0 *1 701.2,420.1 NMOS
XM$2086 \$I4272 \$I4273 VSS VSS NMOS L=1u W=3.4u AS=6.46p AD=6.46p PS=7.2u
+ PD=7.2u
* device instance $2087 r0 *1 706,420.1 NMOS
XM$2087 VSS \$I4272 \$I4273 VSS NMOS L=1u W=3.4u AS=6.46p AD=6.46p PS=7.2u
+ PD=7.2u
* device instance $2088 r0 *1 710.8,420.1 NMOS
XM$2088 \$I4273 WL14 BLB29 VSS NMOS L=1u W=3.4u AS=6.46p AD=10.88p PS=7.2u
+ PD=13.2u
* device instance $2089 r0 *1 724.4,440.5 PMOS
XM$2089 \$I4274 \$I4275 VDD VDD PMOS L=1u W=3.4u AS=10.88p AD=6.46p PS=13.2u
+ PD=7.2u
* device instance $2090 r0 *1 729.2,440.5 PMOS
XM$2090 VDD \$I4274 \$I4275 VDD PMOS L=1u W=3.4u AS=6.46p AD=10.88p PS=7.2u
+ PD=13.2u
* device instance $2091 r0 *1 719.6,420.1 NMOS
XM$2091 BL30 WL14 \$I4274 VSS NMOS L=1u W=3.4u AS=10.88p AD=6.46p PS=13.2u
+ PD=7.2u
* device instance $2092 r0 *1 724.4,420.1 NMOS
XM$2092 \$I4274 \$I4275 VSS VSS NMOS L=1u W=3.4u AS=6.46p AD=6.46p PS=7.2u
+ PD=7.2u
* device instance $2093 r0 *1 729.2,420.1 NMOS
XM$2093 VSS \$I4274 \$I4275 VSS NMOS L=1u W=3.4u AS=6.46p AD=6.46p PS=7.2u
+ PD=7.2u
* device instance $2094 r0 *1 734,420.1 NMOS
XM$2094 \$I4275 WL14 BLB30 VSS NMOS L=1u W=3.4u AS=6.46p AD=10.88p PS=7.2u
+ PD=13.2u
* device instance $2095 r0 *1 747.6,440.5 PMOS
XM$2095 \$I4276 \$I4277 VDD VDD PMOS L=1u W=3.4u AS=10.88p AD=6.46p PS=13.2u
+ PD=7.2u
* device instance $2096 r0 *1 752.4,440.5 PMOS
XM$2096 VDD \$I4276 \$I4277 VDD PMOS L=1u W=3.4u AS=6.46p AD=10.88p PS=7.2u
+ PD=13.2u
* device instance $2097 r0 *1 742.8,420.1 NMOS
XM$2097 BL31 WL14 \$I4276 VSS NMOS L=1u W=3.4u AS=10.88p AD=6.46p PS=13.2u
+ PD=7.2u
* device instance $2098 r0 *1 747.6,420.1 NMOS
XM$2098 \$I4276 \$I4277 VSS VSS NMOS L=1u W=3.4u AS=6.46p AD=6.46p PS=7.2u
+ PD=7.2u
* device instance $2099 r0 *1 752.4,420.1 NMOS
XM$2099 VSS \$I4276 \$I4277 VSS NMOS L=1u W=3.4u AS=6.46p AD=6.46p PS=7.2u
+ PD=7.2u
* device instance $2100 r0 *1 757.2,420.1 NMOS
XM$2100 \$I4277 WL14 BLB31 VSS NMOS L=1u W=3.4u AS=6.46p AD=10.88p PS=7.2u
+ PD=13.2u
* device instance $2101 r0 *1 631.6,381.3 PMOS
XM$2101 \$I4278 \$I4279 VDD VDD PMOS L=1u W=3.4u AS=10.88p AD=6.46p PS=13.2u
+ PD=7.2u
* device instance $2102 r0 *1 636.4,381.3 PMOS
XM$2102 VDD \$I4278 \$I4279 VDD PMOS L=1u W=3.4u AS=6.46p AD=10.88p PS=7.2u
+ PD=13.2u
* device instance $2103 r0 *1 626.8,360.9 NMOS
XM$2103 BL26 WL12 \$I4278 VSS NMOS L=1u W=3.4u AS=10.88p AD=6.46p PS=13.2u
+ PD=7.2u
* device instance $2104 r0 *1 631.6,360.9 NMOS
XM$2104 \$I4278 \$I4279 VSS VSS NMOS L=1u W=3.4u AS=6.46p AD=6.46p PS=7.2u
+ PD=7.2u
* device instance $2105 r0 *1 636.4,360.9 NMOS
XM$2105 VSS \$I4278 \$I4279 VSS NMOS L=1u W=3.4u AS=6.46p AD=6.46p PS=7.2u
+ PD=7.2u
* device instance $2106 r0 *1 641.2,360.9 NMOS
XM$2106 \$I4279 WL12 BLB26 VSS NMOS L=1u W=3.4u AS=6.46p AD=10.88p PS=7.2u
+ PD=13.2u
* device instance $2107 r0 *1 469.2,440.5 PMOS
XM$2107 \$I4280 \$I4281 VDD VDD PMOS L=1u W=3.4u AS=10.88p AD=6.46p PS=13.2u
+ PD=7.2u
* device instance $2108 r0 *1 474,440.5 PMOS
XM$2108 VDD \$I4280 \$I4281 VDD PMOS L=1u W=3.4u AS=6.46p AD=10.88p PS=7.2u
+ PD=13.2u
* device instance $2109 r0 *1 464.4,420.1 NMOS
XM$2109 BL19 WL14 \$I4280 VSS NMOS L=1u W=3.4u AS=10.88p AD=6.46p PS=13.2u
+ PD=7.2u
* device instance $2110 r0 *1 469.2,420.1 NMOS
XM$2110 \$I4280 \$I4281 VSS VSS NMOS L=1u W=3.4u AS=6.46p AD=6.46p PS=7.2u
+ PD=7.2u
* device instance $2111 r0 *1 474,420.1 NMOS
XM$2111 VSS \$I4280 \$I4281 VSS NMOS L=1u W=3.4u AS=6.46p AD=6.46p PS=7.2u
+ PD=7.2u
* device instance $2112 r0 *1 478.8,420.1 NMOS
XM$2112 \$I4281 WL14 BLB19 VSS NMOS L=1u W=3.4u AS=6.46p AD=10.88p PS=7.2u
+ PD=13.2u
* device instance $2113 r0 *1 285.6,381.3 PMOS
XM$2113 \$I4282 \$I4283 VDD VDD PMOS L=1u W=3.4u AS=10.88p AD=6.46p PS=13.2u
+ PD=7.2u
* device instance $2114 r0 *1 290.4,381.3 PMOS
XM$2114 VDD \$I4282 \$I4283 VDD PMOS L=1u W=3.4u AS=6.46p AD=10.88p PS=7.2u
+ PD=13.2u
* device instance $2115 r0 *1 280.8,360.9 NMOS
XM$2115 BL12 WL12 \$I4282 VSS NMOS L=1u W=3.4u AS=10.88p AD=6.46p PS=13.2u
+ PD=7.2u
* device instance $2116 r0 *1 285.6,360.9 NMOS
XM$2116 \$I4282 \$I4283 VSS VSS NMOS L=1u W=3.4u AS=6.46p AD=6.46p PS=7.2u
+ PD=7.2u
* device instance $2117 r0 *1 290.4,360.9 NMOS
XM$2117 VSS \$I4282 \$I4283 VSS NMOS L=1u W=3.4u AS=6.46p AD=6.46p PS=7.2u
+ PD=7.2u
* device instance $2118 r0 *1 295.2,360.9 NMOS
XM$2118 \$I4283 WL12 BLB12 VSS NMOS L=1u W=3.4u AS=6.46p AD=10.88p PS=7.2u
+ PD=13.2u
* device instance $2119 r0 *1 262.4,381.3 PMOS
XM$2119 \$I4284 \$I4285 VDD VDD PMOS L=1u W=3.4u AS=10.88p AD=6.46p PS=13.2u
+ PD=7.2u
* device instance $2120 r0 *1 267.2,381.3 PMOS
XM$2120 VDD \$I4284 \$I4285 VDD PMOS L=1u W=3.4u AS=6.46p AD=10.88p PS=7.2u
+ PD=13.2u
* device instance $2121 r0 *1 257.6,360.9 NMOS
XM$2121 BL11 WL12 \$I4284 VSS NMOS L=1u W=3.4u AS=10.88p AD=6.46p PS=13.2u
+ PD=7.2u
* device instance $2122 r0 *1 262.4,360.9 NMOS
XM$2122 \$I4284 \$I4285 VSS VSS NMOS L=1u W=3.4u AS=6.46p AD=6.46p PS=7.2u
+ PD=7.2u
* device instance $2123 r0 *1 267.2,360.9 NMOS
XM$2123 VSS \$I4284 \$I4285 VSS NMOS L=1u W=3.4u AS=6.46p AD=6.46p PS=7.2u
+ PD=7.2u
* device instance $2124 r0 *1 272,360.9 NMOS
XM$2124 \$I4285 WL12 BLB11 VSS NMOS L=1u W=3.4u AS=6.46p AD=10.88p PS=7.2u
+ PD=13.2u
* device instance $2125 r0 *1 469.2,262.9 PMOS
XM$2125 \$I4286 \$I4287 VDD VDD PMOS L=1u W=3.4u AS=10.88p AD=6.46p PS=13.2u
+ PD=7.2u
* device instance $2126 r0 *1 474,262.9 PMOS
XM$2126 VDD \$I4286 \$I4287 VDD PMOS L=1u W=3.4u AS=6.46p AD=10.88p PS=7.2u
+ PD=13.2u
* device instance $2127 r0 *1 464.4,242.5 NMOS
XM$2127 BL19 WL8 \$I4286 VSS NMOS L=1u W=3.4u AS=10.88p AD=6.46p PS=13.2u
+ PD=7.2u
* device instance $2128 r0 *1 469.2,242.5 NMOS
XM$2128 \$I4286 \$I4287 VSS VSS NMOS L=1u W=3.4u AS=6.46p AD=6.46p PS=7.2u
+ PD=7.2u
* device instance $2129 r0 *1 474,242.5 NMOS
XM$2129 VSS \$I4286 \$I4287 VSS NMOS L=1u W=3.4u AS=6.46p AD=6.46p PS=7.2u
+ PD=7.2u
* device instance $2130 r0 *1 478.8,242.5 NMOS
XM$2130 \$I4287 WL8 BLB19 VSS NMOS L=1u W=3.4u AS=6.46p AD=10.88p PS=7.2u
+ PD=13.2u
* device instance $2131 r0 *1 492.4,262.9 PMOS
XM$2131 \$I4288 \$I4289 VDD VDD PMOS L=1u W=3.4u AS=10.88p AD=6.46p PS=13.2u
+ PD=7.2u
* device instance $2132 r0 *1 497.2,262.9 PMOS
XM$2132 VDD \$I4288 \$I4289 VDD PMOS L=1u W=3.4u AS=6.46p AD=10.88p PS=7.2u
+ PD=13.2u
* device instance $2133 r0 *1 487.6,242.5 NMOS
XM$2133 BL20 WL8 \$I4288 VSS NMOS L=1u W=3.4u AS=10.88p AD=6.46p PS=13.2u
+ PD=7.2u
* device instance $2134 r0 *1 492.4,242.5 NMOS
XM$2134 \$I4288 \$I4289 VSS VSS NMOS L=1u W=3.4u AS=6.46p AD=6.46p PS=7.2u
+ PD=7.2u
* device instance $2135 r0 *1 497.2,242.5 NMOS
XM$2135 VSS \$I4288 \$I4289 VSS NMOS L=1u W=3.4u AS=6.46p AD=6.46p PS=7.2u
+ PD=7.2u
* device instance $2136 r0 *1 502,242.5 NMOS
XM$2136 \$I4289 WL8 BLB20 VSS NMOS L=1u W=3.4u AS=6.46p AD=10.88p PS=7.2u
+ PD=13.2u
* device instance $2137 r0 *1 515.6,262.9 PMOS
XM$2137 \$I4290 \$I4291 VDD VDD PMOS L=1u W=3.4u AS=10.88p AD=6.46p PS=13.2u
+ PD=7.2u
* device instance $2138 r0 *1 520.4,262.9 PMOS
XM$2138 VDD \$I4290 \$I4291 VDD PMOS L=1u W=3.4u AS=6.46p AD=10.88p PS=7.2u
+ PD=13.2u
* device instance $2139 r0 *1 510.8,242.5 NMOS
XM$2139 BL21 WL8 \$I4290 VSS NMOS L=1u W=3.4u AS=10.88p AD=6.46p PS=13.2u
+ PD=7.2u
* device instance $2140 r0 *1 515.6,242.5 NMOS
XM$2140 \$I4290 \$I4291 VSS VSS NMOS L=1u W=3.4u AS=6.46p AD=6.46p PS=7.2u
+ PD=7.2u
* device instance $2141 r0 *1 520.4,242.5 NMOS
XM$2141 VSS \$I4290 \$I4291 VSS NMOS L=1u W=3.4u AS=6.46p AD=6.46p PS=7.2u
+ PD=7.2u
* device instance $2142 r0 *1 525.2,242.5 NMOS
XM$2142 \$I4291 WL8 BLB21 VSS NMOS L=1u W=3.4u AS=6.46p AD=10.88p PS=7.2u
+ PD=13.2u
* device instance $2143 r0 *1 192.8,381.3 PMOS
XM$2143 \$I4292 \$I4293 VDD VDD PMOS L=1u W=3.4u AS=10.88p AD=6.46p PS=13.2u
+ PD=7.2u
* device instance $2144 r0 *1 197.6,381.3 PMOS
XM$2144 VDD \$I4292 \$I4293 VDD PMOS L=1u W=3.4u AS=6.46p AD=10.88p PS=7.2u
+ PD=13.2u
* device instance $2145 r0 *1 188,360.9 NMOS
XM$2145 BL8 WL12 \$I4292 VSS NMOS L=1u W=3.4u AS=10.88p AD=6.46p PS=13.2u
+ PD=7.2u
* device instance $2146 r0 *1 192.8,360.9 NMOS
XM$2146 \$I4292 \$I4293 VSS VSS NMOS L=1u W=3.4u AS=6.46p AD=6.46p PS=7.2u
+ PD=7.2u
* device instance $2147 r0 *1 197.6,360.9 NMOS
XM$2147 VSS \$I4292 \$I4293 VSS NMOS L=1u W=3.4u AS=6.46p AD=6.46p PS=7.2u
+ PD=7.2u
* device instance $2148 r0 *1 202.4,360.9 NMOS
XM$2148 \$I4293 WL12 BLB8 VSS NMOS L=1u W=3.4u AS=6.46p AD=10.88p PS=7.2u
+ PD=13.2u
* device instance $2149 r0 *1 446,440.5 PMOS
XM$2149 \$I4294 \$I4295 VDD VDD PMOS L=1u W=3.4u AS=10.88p AD=6.46p PS=13.2u
+ PD=7.2u
* device instance $2150 r0 *1 450.8,440.5 PMOS
XM$2150 VDD \$I4294 \$I4295 VDD PMOS L=1u W=3.4u AS=6.46p AD=10.88p PS=7.2u
+ PD=13.2u
* device instance $2151 r0 *1 441.2,420.1 NMOS
XM$2151 BL18 WL14 \$I4294 VSS NMOS L=1u W=3.4u AS=10.88p AD=6.46p PS=13.2u
+ PD=7.2u
* device instance $2152 r0 *1 446,420.1 NMOS
XM$2152 \$I4294 \$I4295 VSS VSS NMOS L=1u W=3.4u AS=6.46p AD=6.46p PS=7.2u
+ PD=7.2u
* device instance $2153 r0 *1 450.8,420.1 NMOS
XM$2153 VSS \$I4294 \$I4295 VSS NMOS L=1u W=3.4u AS=6.46p AD=6.46p PS=7.2u
+ PD=7.2u
* device instance $2154 r0 *1 455.6,420.1 NMOS
XM$2154 \$I4295 WL14 BLB18 VSS NMOS L=1u W=3.4u AS=6.46p AD=10.88p PS=7.2u
+ PD=13.2u
* device instance $2155 r0 *1 422.8,440.5 PMOS
XM$2155 \$I4296 \$I4297 VDD VDD PMOS L=1u W=3.4u AS=10.88p AD=6.46p PS=13.2u
+ PD=7.2u
* device instance $2156 r0 *1 427.6,440.5 PMOS
XM$2156 VDD \$I4296 \$I4297 VDD PMOS L=1u W=3.4u AS=6.46p AD=10.88p PS=7.2u
+ PD=13.2u
* device instance $2157 r0 *1 418,420.1 NMOS
XM$2157 BL17 WL14 \$I4296 VSS NMOS L=1u W=3.4u AS=10.88p AD=6.46p PS=13.2u
+ PD=7.2u
* device instance $2158 r0 *1 422.8,420.1 NMOS
XM$2158 \$I4296 \$I4297 VSS VSS NMOS L=1u W=3.4u AS=6.46p AD=6.46p PS=7.2u
+ PD=7.2u
* device instance $2159 r0 *1 427.6,420.1 NMOS
XM$2159 VSS \$I4296 \$I4297 VSS NMOS L=1u W=3.4u AS=6.46p AD=6.46p PS=7.2u
+ PD=7.2u
* device instance $2160 r0 *1 432.4,420.1 NMOS
XM$2160 \$I4297 WL14 BLB17 VSS NMOS L=1u W=3.4u AS=6.46p AD=10.88p PS=7.2u
+ PD=13.2u
* device instance $2161 r0 *1 399.6,440.5 PMOS
XM$2161 \$I4298 \$I4299 VDD VDD PMOS L=1u W=3.4u AS=10.88p AD=6.46p PS=13.2u
+ PD=7.2u
* device instance $2162 r0 *1 404.4,440.5 PMOS
XM$2162 VDD \$I4298 \$I4299 VDD PMOS L=1u W=3.4u AS=6.46p AD=10.88p PS=7.2u
+ PD=13.2u
* device instance $2163 r0 *1 394.8,420.1 NMOS
XM$2163 BL16 WL14 \$I4298 VSS NMOS L=1u W=3.4u AS=10.88p AD=6.46p PS=13.2u
+ PD=7.2u
* device instance $2164 r0 *1 399.6,420.1 NMOS
XM$2164 \$I4298 \$I4299 VSS VSS NMOS L=1u W=3.4u AS=6.46p AD=6.46p PS=7.2u
+ PD=7.2u
* device instance $2165 r0 *1 404.4,420.1 NMOS
XM$2165 VSS \$I4298 \$I4299 VSS NMOS L=1u W=3.4u AS=6.46p AD=6.46p PS=7.2u
+ PD=7.2u
* device instance $2166 r0 *1 409.2,420.1 NMOS
XM$2166 \$I4299 WL14 BLB16 VSS NMOS L=1u W=3.4u AS=6.46p AD=10.88p PS=7.2u
+ PD=13.2u
* device instance $2167 r0 *1 585.2,262.9 PMOS
XM$2167 \$I4300 \$I4301 VDD VDD PMOS L=1u W=3.4u AS=10.88p AD=6.46p PS=13.2u
+ PD=7.2u
* device instance $2168 r0 *1 590,262.9 PMOS
XM$2168 VDD \$I4300 \$I4301 VDD PMOS L=1u W=3.4u AS=6.46p AD=10.88p PS=7.2u
+ PD=13.2u
* device instance $2169 r0 *1 580.4,242.5 NMOS
XM$2169 BL24 WL8 \$I4300 VSS NMOS L=1u W=3.4u AS=10.88p AD=6.46p PS=13.2u
+ PD=7.2u
* device instance $2170 r0 *1 585.2,242.5 NMOS
XM$2170 \$I4300 \$I4301 VSS VSS NMOS L=1u W=3.4u AS=6.46p AD=6.46p PS=7.2u
+ PD=7.2u
* device instance $2171 r0 *1 590,242.5 NMOS
XM$2171 VSS \$I4300 \$I4301 VSS NMOS L=1u W=3.4u AS=6.46p AD=6.46p PS=7.2u
+ PD=7.2u
* device instance $2172 r0 *1 594.8,242.5 NMOS
XM$2172 \$I4301 WL8 BLB24 VSS NMOS L=1u W=3.4u AS=6.46p AD=10.88p PS=7.2u
+ PD=13.2u
* device instance $2173 r0 *1 608.4,262.9 PMOS
XM$2173 \$I4302 \$I4303 VDD VDD PMOS L=1u W=3.4u AS=10.88p AD=6.46p PS=13.2u
+ PD=7.2u
* device instance $2174 r0 *1 613.2,262.9 PMOS
XM$2174 VDD \$I4302 \$I4303 VDD PMOS L=1u W=3.4u AS=6.46p AD=10.88p PS=7.2u
+ PD=13.2u
* device instance $2175 r0 *1 603.6,242.5 NMOS
XM$2175 BL25 WL8 \$I4302 VSS NMOS L=1u W=3.4u AS=10.88p AD=6.46p PS=13.2u
+ PD=7.2u
* device instance $2176 r0 *1 608.4,242.5 NMOS
XM$2176 \$I4302 \$I4303 VSS VSS NMOS L=1u W=3.4u AS=6.46p AD=6.46p PS=7.2u
+ PD=7.2u
* device instance $2177 r0 *1 613.2,242.5 NMOS
XM$2177 VSS \$I4302 \$I4303 VSS NMOS L=1u W=3.4u AS=6.46p AD=6.46p PS=7.2u
+ PD=7.2u
* device instance $2178 r0 *1 618,242.5 NMOS
XM$2178 \$I4303 WL8 BLB25 VSS NMOS L=1u W=3.4u AS=6.46p AD=10.88p PS=7.2u
+ PD=13.2u
* device instance $2179 r0 *1 192.8,262.9 PMOS
XM$2179 \$I4304 \$I4305 VDD VDD PMOS L=1u W=3.4u AS=10.88p AD=6.46p PS=13.2u
+ PD=7.2u
* device instance $2180 r0 *1 197.6,262.9 PMOS
XM$2180 VDD \$I4304 \$I4305 VDD PMOS L=1u W=3.4u AS=6.46p AD=10.88p PS=7.2u
+ PD=13.2u
* device instance $2181 r0 *1 188,242.5 NMOS
XM$2181 BL8 WL8 \$I4304 VSS NMOS L=1u W=3.4u AS=10.88p AD=6.46p PS=13.2u PD=7.2u
* device instance $2182 r0 *1 192.8,242.5 NMOS
XM$2182 \$I4304 \$I4305 VSS VSS NMOS L=1u W=3.4u AS=6.46p AD=6.46p PS=7.2u
+ PD=7.2u
* device instance $2183 r0 *1 197.6,242.5 NMOS
XM$2183 VSS \$I4304 \$I4305 VSS NMOS L=1u W=3.4u AS=6.46p AD=6.46p PS=7.2u
+ PD=7.2u
* device instance $2184 r0 *1 202.4,242.5 NMOS
XM$2184 \$I4305 WL8 BLB8 VSS NMOS L=1u W=3.4u AS=6.46p AD=10.88p PS=7.2u
+ PD=13.2u
* device instance $2185 r0 *1 631.6,262.9 PMOS
XM$2185 \$I4306 \$I4307 VDD VDD PMOS L=1u W=3.4u AS=10.88p AD=6.46p PS=13.2u
+ PD=7.2u
* device instance $2186 r0 *1 636.4,262.9 PMOS
XM$2186 VDD \$I4306 \$I4307 VDD PMOS L=1u W=3.4u AS=6.46p AD=10.88p PS=7.2u
+ PD=13.2u
* device instance $2187 r0 *1 626.8,242.5 NMOS
XM$2187 BL26 WL8 \$I4306 VSS NMOS L=1u W=3.4u AS=10.88p AD=6.46p PS=13.2u
+ PD=7.2u
* device instance $2188 r0 *1 631.6,242.5 NMOS
XM$2188 \$I4306 \$I4307 VSS VSS NMOS L=1u W=3.4u AS=6.46p AD=6.46p PS=7.2u
+ PD=7.2u
* device instance $2189 r0 *1 636.4,242.5 NMOS
XM$2189 VSS \$I4306 \$I4307 VSS NMOS L=1u W=3.4u AS=6.46p AD=6.46p PS=7.2u
+ PD=7.2u
* device instance $2190 r0 *1 641.2,242.5 NMOS
XM$2190 \$I4307 WL8 BLB26 VSS NMOS L=1u W=3.4u AS=6.46p AD=10.88p PS=7.2u
+ PD=13.2u
* device instance $2191 r0 *1 654.8,262.9 PMOS
XM$2191 \$I4308 \$I4309 VDD VDD PMOS L=1u W=3.4u AS=10.88p AD=6.46p PS=13.2u
+ PD=7.2u
* device instance $2192 r0 *1 659.6,262.9 PMOS
XM$2192 VDD \$I4308 \$I4309 VDD PMOS L=1u W=3.4u AS=6.46p AD=10.88p PS=7.2u
+ PD=13.2u
* device instance $2193 r0 *1 650,242.5 NMOS
XM$2193 BL27 WL8 \$I4308 VSS NMOS L=1u W=3.4u AS=10.88p AD=6.46p PS=13.2u
+ PD=7.2u
* device instance $2194 r0 *1 654.8,242.5 NMOS
XM$2194 \$I4308 \$I4309 VSS VSS NMOS L=1u W=3.4u AS=6.46p AD=6.46p PS=7.2u
+ PD=7.2u
* device instance $2195 r0 *1 659.6,242.5 NMOS
XM$2195 VSS \$I4308 \$I4309 VSS NMOS L=1u W=3.4u AS=6.46p AD=6.46p PS=7.2u
+ PD=7.2u
* device instance $2196 r0 *1 664.4,242.5 NMOS
XM$2196 \$I4309 WL8 BLB27 VSS NMOS L=1u W=3.4u AS=6.46p AD=10.88p PS=7.2u
+ PD=13.2u
* device instance $2197 r0 *1 192.8,322.1 PMOS
XM$2197 \$I4310 \$I4311 VDD VDD PMOS L=1u W=3.4u AS=10.88p AD=6.46p PS=13.2u
+ PD=7.2u
* device instance $2198 r0 *1 197.6,322.1 PMOS
XM$2198 VDD \$I4310 \$I4311 VDD PMOS L=1u W=3.4u AS=6.46p AD=10.88p PS=7.2u
+ PD=13.2u
* device instance $2199 r0 *1 188,301.7 NMOS
XM$2199 BL8 WL10 \$I4310 VSS NMOS L=1u W=3.4u AS=10.88p AD=6.46p PS=13.2u
+ PD=7.2u
* device instance $2200 r0 *1 192.8,301.7 NMOS
XM$2200 \$I4310 \$I4311 VSS VSS NMOS L=1u W=3.4u AS=6.46p AD=6.46p PS=7.2u
+ PD=7.2u
* device instance $2201 r0 *1 197.6,301.7 NMOS
XM$2201 VSS \$I4310 \$I4311 VSS NMOS L=1u W=3.4u AS=6.46p AD=6.46p PS=7.2u
+ PD=7.2u
* device instance $2202 r0 *1 202.4,301.7 NMOS
XM$2202 \$I4311 WL10 BLB8 VSS NMOS L=1u W=3.4u AS=6.46p AD=10.88p PS=7.2u
+ PD=13.2u
* device instance $2203 r0 *1 678,262.9 PMOS
XM$2203 \$I4312 \$I4313 VDD VDD PMOS L=1u W=3.4u AS=10.88p AD=6.46p PS=13.2u
+ PD=7.2u
* device instance $2204 r0 *1 682.8,262.9 PMOS
XM$2204 VDD \$I4312 \$I4313 VDD PMOS L=1u W=3.4u AS=6.46p AD=10.88p PS=7.2u
+ PD=13.2u
* device instance $2205 r0 *1 673.2,242.5 NMOS
XM$2205 BL28 WL8 \$I4312 VSS NMOS L=1u W=3.4u AS=10.88p AD=6.46p PS=13.2u
+ PD=7.2u
* device instance $2206 r0 *1 678,242.5 NMOS
XM$2206 \$I4312 \$I4313 VSS VSS NMOS L=1u W=3.4u AS=6.46p AD=6.46p PS=7.2u
+ PD=7.2u
* device instance $2207 r0 *1 682.8,242.5 NMOS
XM$2207 VSS \$I4312 \$I4313 VSS NMOS L=1u W=3.4u AS=6.46p AD=6.46p PS=7.2u
+ PD=7.2u
* device instance $2208 r0 *1 687.6,242.5 NMOS
XM$2208 \$I4313 WL8 BLB28 VSS NMOS L=1u W=3.4u AS=6.46p AD=10.88p PS=7.2u
+ PD=13.2u
* device instance $2209 r0 *1 192.8,440.5 PMOS
XM$2209 \$I4314 \$I4315 VDD VDD PMOS L=1u W=3.4u AS=10.88p AD=6.46p PS=13.2u
+ PD=7.2u
* device instance $2210 r0 *1 197.6,440.5 PMOS
XM$2210 VDD \$I4314 \$I4315 VDD PMOS L=1u W=3.4u AS=6.46p AD=10.88p PS=7.2u
+ PD=13.2u
* device instance $2211 r0 *1 188,420.1 NMOS
XM$2211 BL8 WL14 \$I4314 VSS NMOS L=1u W=3.4u AS=10.88p AD=6.46p PS=13.2u
+ PD=7.2u
* device instance $2212 r0 *1 192.8,420.1 NMOS
XM$2212 \$I4314 \$I4315 VSS VSS NMOS L=1u W=3.4u AS=6.46p AD=6.46p PS=7.2u
+ PD=7.2u
* device instance $2213 r0 *1 197.6,420.1 NMOS
XM$2213 VSS \$I4314 \$I4315 VSS NMOS L=1u W=3.4u AS=6.46p AD=6.46p PS=7.2u
+ PD=7.2u
* device instance $2214 r0 *1 202.4,420.1 NMOS
XM$2214 \$I4315 WL14 BLB8 VSS NMOS L=1u W=3.4u AS=6.46p AD=10.88p PS=7.2u
+ PD=13.2u
* device instance $2215 r0 *1 701.2,262.9 PMOS
XM$2215 \$I4316 \$I4317 VDD VDD PMOS L=1u W=3.4u AS=10.88p AD=6.46p PS=13.2u
+ PD=7.2u
* device instance $2216 r0 *1 706,262.9 PMOS
XM$2216 VDD \$I4316 \$I4317 VDD PMOS L=1u W=3.4u AS=6.46p AD=10.88p PS=7.2u
+ PD=13.2u
* device instance $2217 r0 *1 696.4,242.5 NMOS
XM$2217 BL29 WL8 \$I4316 VSS NMOS L=1u W=3.4u AS=10.88p AD=6.46p PS=13.2u
+ PD=7.2u
* device instance $2218 r0 *1 701.2,242.5 NMOS
XM$2218 \$I4316 \$I4317 VSS VSS NMOS L=1u W=3.4u AS=6.46p AD=6.46p PS=7.2u
+ PD=7.2u
* device instance $2219 r0 *1 706,242.5 NMOS
XM$2219 VSS \$I4316 \$I4317 VSS NMOS L=1u W=3.4u AS=6.46p AD=6.46p PS=7.2u
+ PD=7.2u
* device instance $2220 r0 *1 710.8,242.5 NMOS
XM$2220 \$I4317 WL8 BLB29 VSS NMOS L=1u W=3.4u AS=6.46p AD=10.88p PS=7.2u
+ PD=13.2u
* device instance $2221 r0 *1 399.6,262.9 PMOS
XM$2221 \$I4318 \$I4319 VDD VDD PMOS L=1u W=3.4u AS=10.88p AD=6.46p PS=13.2u
+ PD=7.2u
* device instance $2222 r0 *1 404.4,262.9 PMOS
XM$2222 VDD \$I4318 \$I4319 VDD PMOS L=1u W=3.4u AS=6.46p AD=10.88p PS=7.2u
+ PD=13.2u
* device instance $2223 r0 *1 394.8,242.5 NMOS
XM$2223 BL16 WL8 \$I4318 VSS NMOS L=1u W=3.4u AS=10.88p AD=6.46p PS=13.2u
+ PD=7.2u
* device instance $2224 r0 *1 399.6,242.5 NMOS
XM$2224 \$I4318 \$I4319 VSS VSS NMOS L=1u W=3.4u AS=6.46p AD=6.46p PS=7.2u
+ PD=7.2u
* device instance $2225 r0 *1 404.4,242.5 NMOS
XM$2225 VSS \$I4318 \$I4319 VSS NMOS L=1u W=3.4u AS=6.46p AD=6.46p PS=7.2u
+ PD=7.2u
* device instance $2226 r0 *1 409.2,242.5 NMOS
XM$2226 \$I4319 WL8 BLB16 VSS NMOS L=1u W=3.4u AS=6.46p AD=10.88p PS=7.2u
+ PD=13.2u
* device instance $2227 r0 *1 562,203.7 PMOS
XM$2227 \$I4320 \$I4321 VDD VDD PMOS L=1u W=3.4u AS=10.88p AD=6.46p PS=13.2u
+ PD=7.2u
* device instance $2228 r0 *1 566.8,203.7 PMOS
XM$2228 VDD \$I4320 \$I4321 VDD PMOS L=1u W=3.4u AS=6.46p AD=10.88p PS=7.2u
+ PD=13.2u
* device instance $2229 r0 *1 557.2,183.3 NMOS
XM$2229 BL23 WL6 \$I4320 VSS NMOS L=1u W=3.4u AS=10.88p AD=6.46p PS=13.2u
+ PD=7.2u
* device instance $2230 r0 *1 562,183.3 NMOS
XM$2230 \$I4320 \$I4321 VSS VSS NMOS L=1u W=3.4u AS=6.46p AD=6.46p PS=7.2u
+ PD=7.2u
* device instance $2231 r0 *1 566.8,183.3 NMOS
XM$2231 VSS \$I4320 \$I4321 VSS NMOS L=1u W=3.4u AS=6.46p AD=6.46p PS=7.2u
+ PD=7.2u
* device instance $2232 r0 *1 571.6,183.3 NMOS
XM$2232 \$I4321 WL6 BLB23 VSS NMOS L=1u W=3.4u AS=6.46p AD=10.88p PS=7.2u
+ PD=13.2u
* device instance $2233 r0 *1 562,85.3 PMOS
XM$2233 \$I4322 \$I4323 VDD VDD PMOS L=1u W=3.4u AS=10.88p AD=6.46p PS=13.2u
+ PD=7.2u
* device instance $2234 r0 *1 566.8,85.3 PMOS
XM$2234 VDD \$I4322 \$I4323 VDD PMOS L=1u W=3.4u AS=6.46p AD=10.88p PS=7.2u
+ PD=13.2u
* device instance $2235 r0 *1 557.2,64.9 NMOS
XM$2235 BL23 WL2 \$I4322 VSS NMOS L=1u W=3.4u AS=10.88p AD=6.46p PS=13.2u
+ PD=7.2u
* device instance $2236 r0 *1 562,64.9 NMOS
XM$2236 \$I4322 \$I4323 VSS VSS NMOS L=1u W=3.4u AS=6.46p AD=6.46p PS=7.2u
+ PD=7.2u
* device instance $2237 r0 *1 566.8,64.9 NMOS
XM$2237 VSS \$I4322 \$I4323 VSS NMOS L=1u W=3.4u AS=6.46p AD=6.46p PS=7.2u
+ PD=7.2u
* device instance $2238 r0 *1 571.6,64.9 NMOS
XM$2238 \$I4323 WL2 BLB23 VSS NMOS L=1u W=3.4u AS=6.46p AD=10.88p PS=7.2u
+ PD=13.2u
* device instance $2239 r0 *1 631.6,144.5 PMOS
XM$2239 \$I4324 \$I4325 VDD VDD PMOS L=1u W=3.4u AS=10.88p AD=6.46p PS=13.2u
+ PD=7.2u
* device instance $2240 r0 *1 636.4,144.5 PMOS
XM$2240 VDD \$I4324 \$I4325 VDD PMOS L=1u W=3.4u AS=6.46p AD=10.88p PS=7.2u
+ PD=13.2u
* device instance $2241 r0 *1 626.8,124.1 NMOS
XM$2241 BL26 WL4 \$I4324 VSS NMOS L=1u W=3.4u AS=10.88p AD=6.46p PS=13.2u
+ PD=7.2u
* device instance $2242 r0 *1 631.6,124.1 NMOS
XM$2242 \$I4324 \$I4325 VSS VSS NMOS L=1u W=3.4u AS=6.46p AD=6.46p PS=7.2u
+ PD=7.2u
* device instance $2243 r0 *1 636.4,124.1 NMOS
XM$2243 VSS \$I4324 \$I4325 VSS NMOS L=1u W=3.4u AS=6.46p AD=6.46p PS=7.2u
+ PD=7.2u
* device instance $2244 r0 *1 641.2,124.1 NMOS
XM$2244 \$I4325 WL4 BLB26 VSS NMOS L=1u W=3.4u AS=6.46p AD=10.88p PS=7.2u
+ PD=13.2u
* device instance $2245 r0 *1 654.8,144.5 PMOS
XM$2245 \$I4326 \$I4327 VDD VDD PMOS L=1u W=3.4u AS=10.88p AD=6.46p PS=13.2u
+ PD=7.2u
* device instance $2246 r0 *1 659.6,144.5 PMOS
XM$2246 VDD \$I4326 \$I4327 VDD PMOS L=1u W=3.4u AS=6.46p AD=10.88p PS=7.2u
+ PD=13.2u
* device instance $2247 r0 *1 650,124.1 NMOS
XM$2247 BL27 WL4 \$I4326 VSS NMOS L=1u W=3.4u AS=10.88p AD=6.46p PS=13.2u
+ PD=7.2u
* device instance $2248 r0 *1 654.8,124.1 NMOS
XM$2248 \$I4326 \$I4327 VSS VSS NMOS L=1u W=3.4u AS=6.46p AD=6.46p PS=7.2u
+ PD=7.2u
* device instance $2249 r0 *1 659.6,124.1 NMOS
XM$2249 VSS \$I4326 \$I4327 VSS NMOS L=1u W=3.4u AS=6.46p AD=6.46p PS=7.2u
+ PD=7.2u
* device instance $2250 r0 *1 664.4,124.1 NMOS
XM$2250 \$I4327 WL4 BLB27 VSS NMOS L=1u W=3.4u AS=6.46p AD=10.88p PS=7.2u
+ PD=13.2u
* device instance $2251 r0 *1 585.2,203.7 PMOS
XM$2251 \$I4328 \$I4329 VDD VDD PMOS L=1u W=3.4u AS=10.88p AD=6.46p PS=13.2u
+ PD=7.2u
* device instance $2252 r0 *1 590,203.7 PMOS
XM$2252 VDD \$I4328 \$I4329 VDD PMOS L=1u W=3.4u AS=6.46p AD=10.88p PS=7.2u
+ PD=13.2u
* device instance $2253 r0 *1 580.4,183.3 NMOS
XM$2253 BL24 WL6 \$I4328 VSS NMOS L=1u W=3.4u AS=10.88p AD=6.46p PS=13.2u
+ PD=7.2u
* device instance $2254 r0 *1 585.2,183.3 NMOS
XM$2254 \$I4328 \$I4329 VSS VSS NMOS L=1u W=3.4u AS=6.46p AD=6.46p PS=7.2u
+ PD=7.2u
* device instance $2255 r0 *1 590,183.3 NMOS
XM$2255 VSS \$I4328 \$I4329 VSS NMOS L=1u W=3.4u AS=6.46p AD=6.46p PS=7.2u
+ PD=7.2u
* device instance $2256 r0 *1 594.8,183.3 NMOS
XM$2256 \$I4329 WL6 BLB24 VSS NMOS L=1u W=3.4u AS=6.46p AD=10.88p PS=7.2u
+ PD=13.2u
* device instance $2257 r0 *1 608.4,203.7 PMOS
XM$2257 \$I4330 \$I4331 VDD VDD PMOS L=1u W=3.4u AS=10.88p AD=6.46p PS=13.2u
+ PD=7.2u
* device instance $2258 r0 *1 613.2,203.7 PMOS
XM$2258 VDD \$I4330 \$I4331 VDD PMOS L=1u W=3.4u AS=6.46p AD=10.88p PS=7.2u
+ PD=13.2u
* device instance $2259 r0 *1 603.6,183.3 NMOS
XM$2259 BL25 WL6 \$I4330 VSS NMOS L=1u W=3.4u AS=10.88p AD=6.46p PS=13.2u
+ PD=7.2u
* device instance $2260 r0 *1 608.4,183.3 NMOS
XM$2260 \$I4330 \$I4331 VSS VSS NMOS L=1u W=3.4u AS=6.46p AD=6.46p PS=7.2u
+ PD=7.2u
* device instance $2261 r0 *1 613.2,183.3 NMOS
XM$2261 VSS \$I4330 \$I4331 VSS NMOS L=1u W=3.4u AS=6.46p AD=6.46p PS=7.2u
+ PD=7.2u
* device instance $2262 r0 *1 618,183.3 NMOS
XM$2262 \$I4331 WL6 BLB25 VSS NMOS L=1u W=3.4u AS=6.46p AD=10.88p PS=7.2u
+ PD=13.2u
* device instance $2263 r0 *1 631.6,203.7 PMOS
XM$2263 \$I4332 \$I4333 VDD VDD PMOS L=1u W=3.4u AS=10.88p AD=6.46p PS=13.2u
+ PD=7.2u
* device instance $2264 r0 *1 636.4,203.7 PMOS
XM$2264 VDD \$I4332 \$I4333 VDD PMOS L=1u W=3.4u AS=6.46p AD=10.88p PS=7.2u
+ PD=13.2u
* device instance $2265 r0 *1 626.8,183.3 NMOS
XM$2265 BL26 WL6 \$I4332 VSS NMOS L=1u W=3.4u AS=10.88p AD=6.46p PS=13.2u
+ PD=7.2u
* device instance $2266 r0 *1 631.6,183.3 NMOS
XM$2266 \$I4332 \$I4333 VSS VSS NMOS L=1u W=3.4u AS=6.46p AD=6.46p PS=7.2u
+ PD=7.2u
* device instance $2267 r0 *1 636.4,183.3 NMOS
XM$2267 VSS \$I4332 \$I4333 VSS NMOS L=1u W=3.4u AS=6.46p AD=6.46p PS=7.2u
+ PD=7.2u
* device instance $2268 r0 *1 641.2,183.3 NMOS
XM$2268 \$I4333 WL6 BLB26 VSS NMOS L=1u W=3.4u AS=6.46p AD=10.88p PS=7.2u
+ PD=13.2u
* device instance $2269 r0 *1 654.8,203.7 PMOS
XM$2269 \$I4334 \$I4335 VDD VDD PMOS L=1u W=3.4u AS=10.88p AD=6.46p PS=13.2u
+ PD=7.2u
* device instance $2270 r0 *1 659.6,203.7 PMOS
XM$2270 VDD \$I4334 \$I4335 VDD PMOS L=1u W=3.4u AS=6.46p AD=10.88p PS=7.2u
+ PD=13.2u
* device instance $2271 r0 *1 650,183.3 NMOS
XM$2271 BL27 WL6 \$I4334 VSS NMOS L=1u W=3.4u AS=10.88p AD=6.46p PS=13.2u
+ PD=7.2u
* device instance $2272 r0 *1 654.8,183.3 NMOS
XM$2272 \$I4334 \$I4335 VSS VSS NMOS L=1u W=3.4u AS=6.46p AD=6.46p PS=7.2u
+ PD=7.2u
* device instance $2273 r0 *1 659.6,183.3 NMOS
XM$2273 VSS \$I4334 \$I4335 VSS NMOS L=1u W=3.4u AS=6.46p AD=6.46p PS=7.2u
+ PD=7.2u
* device instance $2274 r0 *1 664.4,183.3 NMOS
XM$2274 \$I4335 WL6 BLB27 VSS NMOS L=1u W=3.4u AS=6.46p AD=10.88p PS=7.2u
+ PD=13.2u
* device instance $2275 r0 *1 192.8,144.5 PMOS
XM$2275 \$I4336 \$I4337 VDD VDD PMOS L=1u W=3.4u AS=10.88p AD=6.46p PS=13.2u
+ PD=7.2u
* device instance $2276 r0 *1 197.6,144.5 PMOS
XM$2276 VDD \$I4336 \$I4337 VDD PMOS L=1u W=3.4u AS=6.46p AD=10.88p PS=7.2u
+ PD=13.2u
* device instance $2277 r0 *1 188,124.1 NMOS
XM$2277 BL8 WL4 \$I4336 VSS NMOS L=1u W=3.4u AS=10.88p AD=6.46p PS=13.2u PD=7.2u
* device instance $2278 r0 *1 192.8,124.1 NMOS
XM$2278 \$I4336 \$I4337 VSS VSS NMOS L=1u W=3.4u AS=6.46p AD=6.46p PS=7.2u
+ PD=7.2u
* device instance $2279 r0 *1 197.6,124.1 NMOS
XM$2279 VSS \$I4336 \$I4337 VSS NMOS L=1u W=3.4u AS=6.46p AD=6.46p PS=7.2u
+ PD=7.2u
* device instance $2280 r0 *1 202.4,124.1 NMOS
XM$2280 \$I4337 WL4 BLB8 VSS NMOS L=1u W=3.4u AS=6.46p AD=10.88p PS=7.2u
+ PD=13.2u
* device instance $2281 r0 *1 701.2,203.7 PMOS
XM$2281 \$I4338 \$I4339 VDD VDD PMOS L=1u W=3.4u AS=10.88p AD=6.46p PS=13.2u
+ PD=7.2u
* device instance $2282 r0 *1 706,203.7 PMOS
XM$2282 VDD \$I4338 \$I4339 VDD PMOS L=1u W=3.4u AS=6.46p AD=10.88p PS=7.2u
+ PD=13.2u
* device instance $2283 r0 *1 696.4,183.3 NMOS
XM$2283 BL29 WL6 \$I4338 VSS NMOS L=1u W=3.4u AS=10.88p AD=6.46p PS=13.2u
+ PD=7.2u
* device instance $2284 r0 *1 701.2,183.3 NMOS
XM$2284 \$I4338 \$I4339 VSS VSS NMOS L=1u W=3.4u AS=6.46p AD=6.46p PS=7.2u
+ PD=7.2u
* device instance $2285 r0 *1 706,183.3 NMOS
XM$2285 VSS \$I4338 \$I4339 VSS NMOS L=1u W=3.4u AS=6.46p AD=6.46p PS=7.2u
+ PD=7.2u
* device instance $2286 r0 *1 710.8,183.3 NMOS
XM$2286 \$I4339 WL6 BLB29 VSS NMOS L=1u W=3.4u AS=6.46p AD=10.88p PS=7.2u
+ PD=13.2u
* device instance $2287 r0 *1 724.4,203.7 PMOS
XM$2287 \$I4340 \$I4341 VDD VDD PMOS L=1u W=3.4u AS=10.88p AD=6.46p PS=13.2u
+ PD=7.2u
* device instance $2288 r0 *1 729.2,203.7 PMOS
XM$2288 VDD \$I4340 \$I4341 VDD PMOS L=1u W=3.4u AS=6.46p AD=10.88p PS=7.2u
+ PD=13.2u
* device instance $2289 r0 *1 719.6,183.3 NMOS
XM$2289 BL30 WL6 \$I4340 VSS NMOS L=1u W=3.4u AS=10.88p AD=6.46p PS=13.2u
+ PD=7.2u
* device instance $2290 r0 *1 724.4,183.3 NMOS
XM$2290 \$I4340 \$I4341 VSS VSS NMOS L=1u W=3.4u AS=6.46p AD=6.46p PS=7.2u
+ PD=7.2u
* device instance $2291 r0 *1 729.2,183.3 NMOS
XM$2291 VSS \$I4340 \$I4341 VSS NMOS L=1u W=3.4u AS=6.46p AD=6.46p PS=7.2u
+ PD=7.2u
* device instance $2292 r0 *1 734,183.3 NMOS
XM$2292 \$I4341 WL6 BLB30 VSS NMOS L=1u W=3.4u AS=6.46p AD=10.88p PS=7.2u
+ PD=13.2u
* device instance $2293 r0 *1 747.6,203.7 PMOS
XM$2293 \$I4342 \$I4343 VDD VDD PMOS L=1u W=3.4u AS=10.88p AD=6.46p PS=13.2u
+ PD=7.2u
* device instance $2294 r0 *1 752.4,203.7 PMOS
XM$2294 VDD \$I4342 \$I4343 VDD PMOS L=1u W=3.4u AS=6.46p AD=10.88p PS=7.2u
+ PD=13.2u
* device instance $2295 r0 *1 742.8,183.3 NMOS
XM$2295 BL31 WL6 \$I4342 VSS NMOS L=1u W=3.4u AS=10.88p AD=6.46p PS=13.2u
+ PD=7.2u
* device instance $2296 r0 *1 747.6,183.3 NMOS
XM$2296 \$I4342 \$I4343 VSS VSS NMOS L=1u W=3.4u AS=6.46p AD=6.46p PS=7.2u
+ PD=7.2u
* device instance $2297 r0 *1 752.4,183.3 NMOS
XM$2297 VSS \$I4342 \$I4343 VSS NMOS L=1u W=3.4u AS=6.46p AD=6.46p PS=7.2u
+ PD=7.2u
* device instance $2298 r0 *1 757.2,183.3 NMOS
XM$2298 \$I4343 WL6 BLB31 VSS NMOS L=1u W=3.4u AS=6.46p AD=10.88p PS=7.2u
+ PD=13.2u
* device instance $2299 r0 *1 678,144.5 PMOS
XM$2299 \$I4344 \$I4345 VDD VDD PMOS L=1u W=3.4u AS=10.88p AD=6.46p PS=13.2u
+ PD=7.2u
* device instance $2300 r0 *1 682.8,144.5 PMOS
XM$2300 VDD \$I4344 \$I4345 VDD PMOS L=1u W=3.4u AS=6.46p AD=10.88p PS=7.2u
+ PD=13.2u
* device instance $2301 r0 *1 673.2,124.1 NMOS
XM$2301 BL28 WL4 \$I4344 VSS NMOS L=1u W=3.4u AS=10.88p AD=6.46p PS=13.2u
+ PD=7.2u
* device instance $2302 r0 *1 678,124.1 NMOS
XM$2302 \$I4344 \$I4345 VSS VSS NMOS L=1u W=3.4u AS=6.46p AD=6.46p PS=7.2u
+ PD=7.2u
* device instance $2303 r0 *1 682.8,124.1 NMOS
XM$2303 VSS \$I4344 \$I4345 VSS NMOS L=1u W=3.4u AS=6.46p AD=6.46p PS=7.2u
+ PD=7.2u
* device instance $2304 r0 *1 687.6,124.1 NMOS
XM$2304 \$I4345 WL4 BLB28 VSS NMOS L=1u W=3.4u AS=6.46p AD=10.88p PS=7.2u
+ PD=13.2u
* device instance $2305 r0 *1 701.2,144.5 PMOS
XM$2305 \$I4346 \$I4347 VDD VDD PMOS L=1u W=3.4u AS=10.88p AD=6.46p PS=13.2u
+ PD=7.2u
* device instance $2306 r0 *1 706,144.5 PMOS
XM$2306 VDD \$I4346 \$I4347 VDD PMOS L=1u W=3.4u AS=6.46p AD=10.88p PS=7.2u
+ PD=13.2u
* device instance $2307 r0 *1 696.4,124.1 NMOS
XM$2307 BL29 WL4 \$I4346 VSS NMOS L=1u W=3.4u AS=10.88p AD=6.46p PS=13.2u
+ PD=7.2u
* device instance $2308 r0 *1 701.2,124.1 NMOS
XM$2308 \$I4346 \$I4347 VSS VSS NMOS L=1u W=3.4u AS=6.46p AD=6.46p PS=7.2u
+ PD=7.2u
* device instance $2309 r0 *1 706,124.1 NMOS
XM$2309 VSS \$I4346 \$I4347 VSS NMOS L=1u W=3.4u AS=6.46p AD=6.46p PS=7.2u
+ PD=7.2u
* device instance $2310 r0 *1 710.8,124.1 NMOS
XM$2310 \$I4347 WL4 BLB29 VSS NMOS L=1u W=3.4u AS=6.46p AD=10.88p PS=7.2u
+ PD=13.2u
* device instance $2311 r0 *1 724.4,144.5 PMOS
XM$2311 \$I4348 \$I4349 VDD VDD PMOS L=1u W=3.4u AS=10.88p AD=6.46p PS=13.2u
+ PD=7.2u
* device instance $2312 r0 *1 729.2,144.5 PMOS
XM$2312 VDD \$I4348 \$I4349 VDD PMOS L=1u W=3.4u AS=6.46p AD=10.88p PS=7.2u
+ PD=13.2u
* device instance $2313 r0 *1 719.6,124.1 NMOS
XM$2313 BL30 WL4 \$I4348 VSS NMOS L=1u W=3.4u AS=10.88p AD=6.46p PS=13.2u
+ PD=7.2u
* device instance $2314 r0 *1 724.4,124.1 NMOS
XM$2314 \$I4348 \$I4349 VSS VSS NMOS L=1u W=3.4u AS=6.46p AD=6.46p PS=7.2u
+ PD=7.2u
* device instance $2315 r0 *1 729.2,124.1 NMOS
XM$2315 VSS \$I4348 \$I4349 VSS NMOS L=1u W=3.4u AS=6.46p AD=6.46p PS=7.2u
+ PD=7.2u
* device instance $2316 r0 *1 734,124.1 NMOS
XM$2316 \$I4349 WL4 BLB30 VSS NMOS L=1u W=3.4u AS=6.46p AD=10.88p PS=7.2u
+ PD=13.2u
* device instance $2317 r0 *1 747.6,144.5 PMOS
XM$2317 \$I4350 \$I4351 VDD VDD PMOS L=1u W=3.4u AS=10.88p AD=6.46p PS=13.2u
+ PD=7.2u
* device instance $2318 r0 *1 752.4,144.5 PMOS
XM$2318 VDD \$I4350 \$I4351 VDD PMOS L=1u W=3.4u AS=6.46p AD=10.88p PS=7.2u
+ PD=13.2u
* device instance $2319 r0 *1 742.8,124.1 NMOS
XM$2319 BL31 WL4 \$I4350 VSS NMOS L=1u W=3.4u AS=10.88p AD=6.46p PS=13.2u
+ PD=7.2u
* device instance $2320 r0 *1 747.6,124.1 NMOS
XM$2320 \$I4350 \$I4351 VSS VSS NMOS L=1u W=3.4u AS=6.46p AD=6.46p PS=7.2u
+ PD=7.2u
* device instance $2321 r0 *1 752.4,124.1 NMOS
XM$2321 VSS \$I4350 \$I4351 VSS NMOS L=1u W=3.4u AS=6.46p AD=6.46p PS=7.2u
+ PD=7.2u
* device instance $2322 r0 *1 757.2,124.1 NMOS
XM$2322 \$I4351 WL4 BLB31 VSS NMOS L=1u W=3.4u AS=6.46p AD=10.88p PS=7.2u
+ PD=13.2u
* device instance $2323 r0 *1 585.2,144.5 PMOS
XM$2323 \$I4352 \$I4353 VDD VDD PMOS L=1u W=3.4u AS=10.88p AD=6.46p PS=13.2u
+ PD=7.2u
* device instance $2324 r0 *1 590,144.5 PMOS
XM$2324 VDD \$I4352 \$I4353 VDD PMOS L=1u W=3.4u AS=6.46p AD=10.88p PS=7.2u
+ PD=13.2u
* device instance $2325 r0 *1 580.4,124.1 NMOS
XM$2325 BL24 WL4 \$I4352 VSS NMOS L=1u W=3.4u AS=10.88p AD=6.46p PS=13.2u
+ PD=7.2u
* device instance $2326 r0 *1 585.2,124.1 NMOS
XM$2326 \$I4352 \$I4353 VSS VSS NMOS L=1u W=3.4u AS=6.46p AD=6.46p PS=7.2u
+ PD=7.2u
* device instance $2327 r0 *1 590,124.1 NMOS
XM$2327 VSS \$I4352 \$I4353 VSS NMOS L=1u W=3.4u AS=6.46p AD=6.46p PS=7.2u
+ PD=7.2u
* device instance $2328 r0 *1 594.8,124.1 NMOS
XM$2328 \$I4353 WL4 BLB24 VSS NMOS L=1u W=3.4u AS=6.46p AD=10.88p PS=7.2u
+ PD=13.2u
* device instance $2329 r0 *1 608.4,144.5 PMOS
XM$2329 \$I4354 \$I4355 VDD VDD PMOS L=1u W=3.4u AS=10.88p AD=6.46p PS=13.2u
+ PD=7.2u
* device instance $2330 r0 *1 613.2,144.5 PMOS
XM$2330 VDD \$I4354 \$I4355 VDD PMOS L=1u W=3.4u AS=6.46p AD=10.88p PS=7.2u
+ PD=13.2u
* device instance $2331 r0 *1 603.6,124.1 NMOS
XM$2331 BL25 WL4 \$I4354 VSS NMOS L=1u W=3.4u AS=10.88p AD=6.46p PS=13.2u
+ PD=7.2u
* device instance $2332 r0 *1 608.4,124.1 NMOS
XM$2332 \$I4354 \$I4355 VSS VSS NMOS L=1u W=3.4u AS=6.46p AD=6.46p PS=7.2u
+ PD=7.2u
* device instance $2333 r0 *1 613.2,124.1 NMOS
XM$2333 VSS \$I4354 \$I4355 VSS NMOS L=1u W=3.4u AS=6.46p AD=6.46p PS=7.2u
+ PD=7.2u
* device instance $2334 r0 *1 618,124.1 NMOS
XM$2334 \$I4355 WL4 BLB25 VSS NMOS L=1u W=3.4u AS=6.46p AD=10.88p PS=7.2u
+ PD=13.2u
* device instance $2335 r0 *1 469.2,144.5 PMOS
XM$2335 \$I4356 \$I4357 VDD VDD PMOS L=1u W=3.4u AS=10.88p AD=6.46p PS=13.2u
+ PD=7.2u
* device instance $2336 r0 *1 474,144.5 PMOS
XM$2336 VDD \$I4356 \$I4357 VDD PMOS L=1u W=3.4u AS=6.46p AD=10.88p PS=7.2u
+ PD=13.2u
* device instance $2337 r0 *1 464.4,124.1 NMOS
XM$2337 BL19 WL4 \$I4356 VSS NMOS L=1u W=3.4u AS=10.88p AD=6.46p PS=13.2u
+ PD=7.2u
* device instance $2338 r0 *1 469.2,124.1 NMOS
XM$2338 \$I4356 \$I4357 VSS VSS NMOS L=1u W=3.4u AS=6.46p AD=6.46p PS=7.2u
+ PD=7.2u
* device instance $2339 r0 *1 474,124.1 NMOS
XM$2339 VSS \$I4356 \$I4357 VSS NMOS L=1u W=3.4u AS=6.46p AD=6.46p PS=7.2u
+ PD=7.2u
* device instance $2340 r0 *1 478.8,124.1 NMOS
XM$2340 \$I4357 WL4 BLB19 VSS NMOS L=1u W=3.4u AS=6.46p AD=10.88p PS=7.2u
+ PD=13.2u
* device instance $2341 r0 *1 678,203.7 PMOS
XM$2341 \$I4358 \$I4359 VDD VDD PMOS L=1u W=3.4u AS=10.88p AD=6.46p PS=13.2u
+ PD=7.2u
* device instance $2342 r0 *1 682.8,203.7 PMOS
XM$2342 VDD \$I4358 \$I4359 VDD PMOS L=1u W=3.4u AS=6.46p AD=10.88p PS=7.2u
+ PD=13.2u
* device instance $2343 r0 *1 673.2,183.3 NMOS
XM$2343 BL28 WL6 \$I4358 VSS NMOS L=1u W=3.4u AS=10.88p AD=6.46p PS=13.2u
+ PD=7.2u
* device instance $2344 r0 *1 678,183.3 NMOS
XM$2344 \$I4358 \$I4359 VSS VSS NMOS L=1u W=3.4u AS=6.46p AD=6.46p PS=7.2u
+ PD=7.2u
* device instance $2345 r0 *1 682.8,183.3 NMOS
XM$2345 VSS \$I4358 \$I4359 VSS NMOS L=1u W=3.4u AS=6.46p AD=6.46p PS=7.2u
+ PD=7.2u
* device instance $2346 r0 *1 687.6,183.3 NMOS
XM$2346 \$I4359 WL6 BLB28 VSS NMOS L=1u W=3.4u AS=6.46p AD=10.88p PS=7.2u
+ PD=13.2u
* device instance $2347 r0 *1 169.6,85.3 PMOS
XM$2347 \$I4360 \$I4361 VDD VDD PMOS L=1u W=3.4u AS=10.88p AD=6.46p PS=13.2u
+ PD=7.2u
* device instance $2348 r0 *1 174.4,85.3 PMOS
XM$2348 VDD \$I4360 \$I4361 VDD PMOS L=1u W=3.4u AS=6.46p AD=10.88p PS=7.2u
+ PD=13.2u
* device instance $2349 r0 *1 164.8,64.9 NMOS
XM$2349 BL7 WL2 \$I4360 VSS NMOS L=1u W=3.4u AS=10.88p AD=6.46p PS=13.2u PD=7.2u
* device instance $2350 r0 *1 169.6,64.9 NMOS
XM$2350 \$I4360 \$I4361 VSS VSS NMOS L=1u W=3.4u AS=6.46p AD=6.46p PS=7.2u
+ PD=7.2u
* device instance $2351 r0 *1 174.4,64.9 NMOS
XM$2351 VSS \$I4360 \$I4361 VSS NMOS L=1u W=3.4u AS=6.46p AD=6.46p PS=7.2u
+ PD=7.2u
* device instance $2352 r0 *1 179.2,64.9 NMOS
XM$2352 \$I4361 WL2 BLB7 VSS NMOS L=1u W=3.4u AS=6.46p AD=10.88p PS=7.2u
+ PD=13.2u
* device instance $2353 r0 *1 285.6,85.3 PMOS
XM$2353 \$I4362 \$I4363 VDD VDD PMOS L=1u W=3.4u AS=10.88p AD=6.46p PS=13.2u
+ PD=7.2u
* device instance $2354 r0 *1 290.4,85.3 PMOS
XM$2354 VDD \$I4362 \$I4363 VDD PMOS L=1u W=3.4u AS=6.46p AD=10.88p PS=7.2u
+ PD=13.2u
* device instance $2355 r0 *1 280.8,64.9 NMOS
XM$2355 BL12 WL2 \$I4362 VSS NMOS L=1u W=3.4u AS=10.88p AD=6.46p PS=13.2u
+ PD=7.2u
* device instance $2356 r0 *1 285.6,64.9 NMOS
XM$2356 \$I4362 \$I4363 VSS VSS NMOS L=1u W=3.4u AS=6.46p AD=6.46p PS=7.2u
+ PD=7.2u
* device instance $2357 r0 *1 290.4,64.9 NMOS
XM$2357 VSS \$I4362 \$I4363 VSS NMOS L=1u W=3.4u AS=6.46p AD=6.46p PS=7.2u
+ PD=7.2u
* device instance $2358 r0 *1 295.2,64.9 NMOS
XM$2358 \$I4363 WL2 BLB12 VSS NMOS L=1u W=3.4u AS=6.46p AD=10.88p PS=7.2u
+ PD=13.2u
* device instance $2359 r0 *1 308.8,85.3 PMOS
XM$2359 \$I4364 \$I4365 VDD VDD PMOS L=1u W=3.4u AS=10.88p AD=6.46p PS=13.2u
+ PD=7.2u
* device instance $2360 r0 *1 313.6,85.3 PMOS
XM$2360 VDD \$I4364 \$I4365 VDD PMOS L=1u W=3.4u AS=6.46p AD=10.88p PS=7.2u
+ PD=13.2u
* device instance $2361 r0 *1 304,64.9 NMOS
XM$2361 BL13 WL2 \$I4364 VSS NMOS L=1u W=3.4u AS=10.88p AD=6.46p PS=13.2u
+ PD=7.2u
* device instance $2362 r0 *1 308.8,64.9 NMOS
XM$2362 \$I4364 \$I4365 VSS VSS NMOS L=1u W=3.4u AS=6.46p AD=6.46p PS=7.2u
+ PD=7.2u
* device instance $2363 r0 *1 313.6,64.9 NMOS
XM$2363 VSS \$I4364 \$I4365 VSS NMOS L=1u W=3.4u AS=6.46p AD=6.46p PS=7.2u
+ PD=7.2u
* device instance $2364 r0 *1 318.4,64.9 NMOS
XM$2364 \$I4365 WL2 BLB13 VSS NMOS L=1u W=3.4u AS=6.46p AD=10.88p PS=7.2u
+ PD=13.2u
* device instance $2365 r0 *1 332,85.3 PMOS
XM$2365 \$I4366 \$I4367 VDD VDD PMOS L=1u W=3.4u AS=10.88p AD=6.46p PS=13.2u
+ PD=7.2u
* device instance $2366 r0 *1 336.8,85.3 PMOS
XM$2366 VDD \$I4366 \$I4367 VDD PMOS L=1u W=3.4u AS=6.46p AD=10.88p PS=7.2u
+ PD=13.2u
* device instance $2367 r0 *1 327.2,64.9 NMOS
XM$2367 BL14 WL2 \$I4366 VSS NMOS L=1u W=3.4u AS=10.88p AD=6.46p PS=13.2u
+ PD=7.2u
* device instance $2368 r0 *1 332,64.9 NMOS
XM$2368 \$I4366 \$I4367 VSS VSS NMOS L=1u W=3.4u AS=6.46p AD=6.46p PS=7.2u
+ PD=7.2u
* device instance $2369 r0 *1 336.8,64.9 NMOS
XM$2369 VSS \$I4366 \$I4367 VSS NMOS L=1u W=3.4u AS=6.46p AD=6.46p PS=7.2u
+ PD=7.2u
* device instance $2370 r0 *1 341.6,64.9 NMOS
XM$2370 \$I4367 WL2 BLB14 VSS NMOS L=1u W=3.4u AS=6.46p AD=10.88p PS=7.2u
+ PD=13.2u
* device instance $2371 r0 *1 562,144.5 PMOS
XM$2371 \$I4368 \$I4369 VDD VDD PMOS L=1u W=3.4u AS=10.88p AD=6.46p PS=13.2u
+ PD=7.2u
* device instance $2372 r0 *1 566.8,144.5 PMOS
XM$2372 VDD \$I4368 \$I4369 VDD PMOS L=1u W=3.4u AS=6.46p AD=10.88p PS=7.2u
+ PD=13.2u
* device instance $2373 r0 *1 557.2,124.1 NMOS
XM$2373 BL23 WL4 \$I4368 VSS NMOS L=1u W=3.4u AS=10.88p AD=6.46p PS=13.2u
+ PD=7.2u
* device instance $2374 r0 *1 562,124.1 NMOS
XM$2374 \$I4368 \$I4369 VSS VSS NMOS L=1u W=3.4u AS=6.46p AD=6.46p PS=7.2u
+ PD=7.2u
* device instance $2375 r0 *1 566.8,124.1 NMOS
XM$2375 VSS \$I4368 \$I4369 VSS NMOS L=1u W=3.4u AS=6.46p AD=6.46p PS=7.2u
+ PD=7.2u
* device instance $2376 r0 *1 571.6,124.1 NMOS
XM$2376 \$I4369 WL4 BLB23 VSS NMOS L=1u W=3.4u AS=6.46p AD=10.88p PS=7.2u
+ PD=13.2u
* device instance $2377 r0 *1 216,85.3 PMOS
XM$2377 \$I4370 \$I4371 VDD VDD PMOS L=1u W=3.4u AS=10.88p AD=6.46p PS=13.2u
+ PD=7.2u
* device instance $2378 r0 *1 220.8,85.3 PMOS
XM$2378 VDD \$I4370 \$I4371 VDD PMOS L=1u W=3.4u AS=6.46p AD=10.88p PS=7.2u
+ PD=13.2u
* device instance $2379 r0 *1 211.2,64.9 NMOS
XM$2379 BL9 WL2 \$I4370 VSS NMOS L=1u W=3.4u AS=10.88p AD=6.46p PS=13.2u PD=7.2u
* device instance $2380 r0 *1 216,64.9 NMOS
XM$2380 \$I4370 \$I4371 VSS VSS NMOS L=1u W=3.4u AS=6.46p AD=6.46p PS=7.2u
+ PD=7.2u
* device instance $2381 r0 *1 220.8,64.9 NMOS
XM$2381 VSS \$I4370 \$I4371 VSS NMOS L=1u W=3.4u AS=6.46p AD=6.46p PS=7.2u
+ PD=7.2u
* device instance $2382 r0 *1 225.6,64.9 NMOS
XM$2382 \$I4371 WL2 BLB9 VSS NMOS L=1u W=3.4u AS=6.46p AD=10.88p PS=7.2u
+ PD=13.2u
* device instance $2383 r0 *1 239.2,85.3 PMOS
XM$2383 \$I4372 \$I4373 VDD VDD PMOS L=1u W=3.4u AS=10.88p AD=6.46p PS=13.2u
+ PD=7.2u
* device instance $2384 r0 *1 244,85.3 PMOS
XM$2384 VDD \$I4372 \$I4373 VDD PMOS L=1u W=3.4u AS=6.46p AD=10.88p PS=7.2u
+ PD=13.2u
* device instance $2385 r0 *1 234.4,64.9 NMOS
XM$2385 BL10 WL2 \$I4372 VSS NMOS L=1u W=3.4u AS=10.88p AD=6.46p PS=13.2u
+ PD=7.2u
* device instance $2386 r0 *1 239.2,64.9 NMOS
XM$2386 \$I4372 \$I4373 VSS VSS NMOS L=1u W=3.4u AS=6.46p AD=6.46p PS=7.2u
+ PD=7.2u
* device instance $2387 r0 *1 244,64.9 NMOS
XM$2387 VSS \$I4372 \$I4373 VSS NMOS L=1u W=3.4u AS=6.46p AD=6.46p PS=7.2u
+ PD=7.2u
* device instance $2388 r0 *1 248.8,64.9 NMOS
XM$2388 \$I4373 WL2 BLB10 VSS NMOS L=1u W=3.4u AS=6.46p AD=10.88p PS=7.2u
+ PD=13.2u
* device instance $2389 r0 *1 262.4,85.3 PMOS
XM$2389 \$I4374 \$I4375 VDD VDD PMOS L=1u W=3.4u AS=10.88p AD=6.46p PS=13.2u
+ PD=7.2u
* device instance $2390 r0 *1 267.2,85.3 PMOS
XM$2390 VDD \$I4374 \$I4375 VDD PMOS L=1u W=3.4u AS=6.46p AD=10.88p PS=7.2u
+ PD=13.2u
* device instance $2391 r0 *1 257.6,64.9 NMOS
XM$2391 BL11 WL2 \$I4374 VSS NMOS L=1u W=3.4u AS=10.88p AD=6.46p PS=13.2u
+ PD=7.2u
* device instance $2392 r0 *1 262.4,64.9 NMOS
XM$2392 \$I4374 \$I4375 VSS VSS NMOS L=1u W=3.4u AS=6.46p AD=6.46p PS=7.2u
+ PD=7.2u
* device instance $2393 r0 *1 267.2,64.9 NMOS
XM$2393 VSS \$I4374 \$I4375 VSS NMOS L=1u W=3.4u AS=6.46p AD=6.46p PS=7.2u
+ PD=7.2u
* device instance $2394 r0 *1 272,64.9 NMOS
XM$2394 \$I4375 WL2 BLB11 VSS NMOS L=1u W=3.4u AS=6.46p AD=10.88p PS=7.2u
+ PD=13.2u
* device instance $2395 r0 *1 355.2,85.3 PMOS
XM$2395 \$I4376 \$I4377 VDD VDD PMOS L=1u W=3.4u AS=10.88p AD=6.46p PS=13.2u
+ PD=7.2u
* device instance $2396 r0 *1 360,85.3 PMOS
XM$2396 VDD \$I4376 \$I4377 VDD PMOS L=1u W=3.4u AS=6.46p AD=10.88p PS=7.2u
+ PD=13.2u
* device instance $2397 r0 *1 350.4,64.9 NMOS
XM$2397 BL15 WL2 \$I4376 VSS NMOS L=1u W=3.4u AS=10.88p AD=6.46p PS=13.2u
+ PD=7.2u
* device instance $2398 r0 *1 355.2,64.9 NMOS
XM$2398 \$I4376 \$I4377 VSS VSS NMOS L=1u W=3.4u AS=6.46p AD=6.46p PS=7.2u
+ PD=7.2u
* device instance $2399 r0 *1 360,64.9 NMOS
XM$2399 VSS \$I4376 \$I4377 VSS NMOS L=1u W=3.4u AS=6.46p AD=6.46p PS=7.2u
+ PD=7.2u
* device instance $2400 r0 *1 364.8,64.9 NMOS
XM$2400 \$I4377 WL2 BLB15 VSS NMOS L=1u W=3.4u AS=6.46p AD=10.88p PS=7.2u
+ PD=13.2u
* device instance $2401 r0 *1 515.6,85.3 PMOS
XM$2401 \$I4378 \$I4379 VDD VDD PMOS L=1u W=3.4u AS=10.88p AD=6.46p PS=13.2u
+ PD=7.2u
* device instance $2402 r0 *1 520.4,85.3 PMOS
XM$2402 VDD \$I4378 \$I4379 VDD PMOS L=1u W=3.4u AS=6.46p AD=10.88p PS=7.2u
+ PD=13.2u
* device instance $2403 r0 *1 510.8,64.9 NMOS
XM$2403 BL21 WL2 \$I4378 VSS NMOS L=1u W=3.4u AS=10.88p AD=6.46p PS=13.2u
+ PD=7.2u
* device instance $2404 r0 *1 515.6,64.9 NMOS
XM$2404 \$I4378 \$I4379 VSS VSS NMOS L=1u W=3.4u AS=6.46p AD=6.46p PS=7.2u
+ PD=7.2u
* device instance $2405 r0 *1 520.4,64.9 NMOS
XM$2405 VSS \$I4378 \$I4379 VSS NMOS L=1u W=3.4u AS=6.46p AD=6.46p PS=7.2u
+ PD=7.2u
* device instance $2406 r0 *1 525.2,64.9 NMOS
XM$2406 \$I4379 WL2 BLB21 VSS NMOS L=1u W=3.4u AS=6.46p AD=10.88p PS=7.2u
+ PD=13.2u
* device instance $2407 r0 *1 538.8,85.3 PMOS
XM$2407 \$I4380 \$I4381 VDD VDD PMOS L=1u W=3.4u AS=10.88p AD=6.46p PS=13.2u
+ PD=7.2u
* device instance $2408 r0 *1 543.6,85.3 PMOS
XM$2408 VDD \$I4380 \$I4381 VDD PMOS L=1u W=3.4u AS=6.46p AD=10.88p PS=7.2u
+ PD=13.2u
* device instance $2409 r0 *1 534,64.9 NMOS
XM$2409 BL22 WL2 \$I4380 VSS NMOS L=1u W=3.4u AS=10.88p AD=6.46p PS=13.2u
+ PD=7.2u
* device instance $2410 r0 *1 538.8,64.9 NMOS
XM$2410 \$I4380 \$I4381 VSS VSS NMOS L=1u W=3.4u AS=6.46p AD=6.46p PS=7.2u
+ PD=7.2u
* device instance $2411 r0 *1 543.6,64.9 NMOS
XM$2411 VSS \$I4380 \$I4381 VSS NMOS L=1u W=3.4u AS=6.46p AD=6.46p PS=7.2u
+ PD=7.2u
* device instance $2412 r0 *1 548.4,64.9 NMOS
XM$2412 \$I4381 WL2 BLB22 VSS NMOS L=1u W=3.4u AS=6.46p AD=10.88p PS=7.2u
+ PD=13.2u
* device instance $2413 r0 *1 585.2,85.3 PMOS
XM$2413 \$I4382 \$I4383 VDD VDD PMOS L=1u W=3.4u AS=10.88p AD=6.46p PS=13.2u
+ PD=7.2u
* device instance $2414 r0 *1 590,85.3 PMOS
XM$2414 VDD \$I4382 \$I4383 VDD PMOS L=1u W=3.4u AS=6.46p AD=10.88p PS=7.2u
+ PD=13.2u
* device instance $2415 r0 *1 580.4,64.9 NMOS
XM$2415 BL24 WL2 \$I4382 VSS NMOS L=1u W=3.4u AS=10.88p AD=6.46p PS=13.2u
+ PD=7.2u
* device instance $2416 r0 *1 585.2,64.9 NMOS
XM$2416 \$I4382 \$I4383 VSS VSS NMOS L=1u W=3.4u AS=6.46p AD=6.46p PS=7.2u
+ PD=7.2u
* device instance $2417 r0 *1 590,64.9 NMOS
XM$2417 VSS \$I4382 \$I4383 VSS NMOS L=1u W=3.4u AS=6.46p AD=6.46p PS=7.2u
+ PD=7.2u
* device instance $2418 r0 *1 594.8,64.9 NMOS
XM$2418 \$I4383 WL2 BLB24 VSS NMOS L=1u W=3.4u AS=6.46p AD=10.88p PS=7.2u
+ PD=13.2u
* device instance $2419 r0 *1 608.4,85.3 PMOS
XM$2419 \$I4384 \$I4385 VDD VDD PMOS L=1u W=3.4u AS=10.88p AD=6.46p PS=13.2u
+ PD=7.2u
* device instance $2420 r0 *1 613.2,85.3 PMOS
XM$2420 VDD \$I4384 \$I4385 VDD PMOS L=1u W=3.4u AS=6.46p AD=10.88p PS=7.2u
+ PD=13.2u
* device instance $2421 r0 *1 603.6,64.9 NMOS
XM$2421 BL25 WL2 \$I4384 VSS NMOS L=1u W=3.4u AS=10.88p AD=6.46p PS=13.2u
+ PD=7.2u
* device instance $2422 r0 *1 608.4,64.9 NMOS
XM$2422 \$I4384 \$I4385 VSS VSS NMOS L=1u W=3.4u AS=6.46p AD=6.46p PS=7.2u
+ PD=7.2u
* device instance $2423 r0 *1 613.2,64.9 NMOS
XM$2423 VSS \$I4384 \$I4385 VSS NMOS L=1u W=3.4u AS=6.46p AD=6.46p PS=7.2u
+ PD=7.2u
* device instance $2424 r0 *1 618,64.9 NMOS
XM$2424 \$I4385 WL2 BLB25 VSS NMOS L=1u W=3.4u AS=6.46p AD=10.88p PS=7.2u
+ PD=13.2u
* device instance $2425 r0 *1 631.6,85.3 PMOS
XM$2425 \$I4386 \$I4387 VDD VDD PMOS L=1u W=3.4u AS=10.88p AD=6.46p PS=13.2u
+ PD=7.2u
* device instance $2426 r0 *1 636.4,85.3 PMOS
XM$2426 VDD \$I4386 \$I4387 VDD PMOS L=1u W=3.4u AS=6.46p AD=10.88p PS=7.2u
+ PD=13.2u
* device instance $2427 r0 *1 626.8,64.9 NMOS
XM$2427 BL26 WL2 \$I4386 VSS NMOS L=1u W=3.4u AS=10.88p AD=6.46p PS=13.2u
+ PD=7.2u
* device instance $2428 r0 *1 631.6,64.9 NMOS
XM$2428 \$I4386 \$I4387 VSS VSS NMOS L=1u W=3.4u AS=6.46p AD=6.46p PS=7.2u
+ PD=7.2u
* device instance $2429 r0 *1 636.4,64.9 NMOS
XM$2429 VSS \$I4386 \$I4387 VSS NMOS L=1u W=3.4u AS=6.46p AD=6.46p PS=7.2u
+ PD=7.2u
* device instance $2430 r0 *1 641.2,64.9 NMOS
XM$2430 \$I4387 WL2 BLB26 VSS NMOS L=1u W=3.4u AS=6.46p AD=10.88p PS=7.2u
+ PD=13.2u
* device instance $2431 r0 *1 654.8,85.3 PMOS
XM$2431 \$I4388 \$I4389 VDD VDD PMOS L=1u W=3.4u AS=10.88p AD=6.46p PS=13.2u
+ PD=7.2u
* device instance $2432 r0 *1 659.6,85.3 PMOS
XM$2432 VDD \$I4388 \$I4389 VDD PMOS L=1u W=3.4u AS=6.46p AD=10.88p PS=7.2u
+ PD=13.2u
* device instance $2433 r0 *1 650,64.9 NMOS
XM$2433 BL27 WL2 \$I4388 VSS NMOS L=1u W=3.4u AS=10.88p AD=6.46p PS=13.2u
+ PD=7.2u
* device instance $2434 r0 *1 654.8,64.9 NMOS
XM$2434 \$I4388 \$I4389 VSS VSS NMOS L=1u W=3.4u AS=6.46p AD=6.46p PS=7.2u
+ PD=7.2u
* device instance $2435 r0 *1 659.6,64.9 NMOS
XM$2435 VSS \$I4388 \$I4389 VSS NMOS L=1u W=3.4u AS=6.46p AD=6.46p PS=7.2u
+ PD=7.2u
* device instance $2436 r0 *1 664.4,64.9 NMOS
XM$2436 \$I4389 WL2 BLB27 VSS NMOS L=1u W=3.4u AS=6.46p AD=10.88p PS=7.2u
+ PD=13.2u
* device instance $2437 r0 *1 678,85.3 PMOS
XM$2437 \$I4390 \$I4391 VDD VDD PMOS L=1u W=3.4u AS=10.88p AD=6.46p PS=13.2u
+ PD=7.2u
* device instance $2438 r0 *1 682.8,85.3 PMOS
XM$2438 VDD \$I4390 \$I4391 VDD PMOS L=1u W=3.4u AS=6.46p AD=10.88p PS=7.2u
+ PD=13.2u
* device instance $2439 r0 *1 673.2,64.9 NMOS
XM$2439 BL28 WL2 \$I4390 VSS NMOS L=1u W=3.4u AS=10.88p AD=6.46p PS=13.2u
+ PD=7.2u
* device instance $2440 r0 *1 678,64.9 NMOS
XM$2440 \$I4390 \$I4391 VSS VSS NMOS L=1u W=3.4u AS=6.46p AD=6.46p PS=7.2u
+ PD=7.2u
* device instance $2441 r0 *1 682.8,64.9 NMOS
XM$2441 VSS \$I4390 \$I4391 VSS NMOS L=1u W=3.4u AS=6.46p AD=6.46p PS=7.2u
+ PD=7.2u
* device instance $2442 r0 *1 687.6,64.9 NMOS
XM$2442 \$I4391 WL2 BLB28 VSS NMOS L=1u W=3.4u AS=6.46p AD=10.88p PS=7.2u
+ PD=13.2u
* device instance $2443 r0 *1 492.4,144.5 PMOS
XM$2443 \$I4392 \$I4393 VDD VDD PMOS L=1u W=3.4u AS=10.88p AD=6.46p PS=13.2u
+ PD=7.2u
* device instance $2444 r0 *1 497.2,144.5 PMOS
XM$2444 VDD \$I4392 \$I4393 VDD PMOS L=1u W=3.4u AS=6.46p AD=10.88p PS=7.2u
+ PD=13.2u
* device instance $2445 r0 *1 487.6,124.1 NMOS
XM$2445 BL20 WL4 \$I4392 VSS NMOS L=1u W=3.4u AS=10.88p AD=6.46p PS=13.2u
+ PD=7.2u
* device instance $2446 r0 *1 492.4,124.1 NMOS
XM$2446 \$I4392 \$I4393 VSS VSS NMOS L=1u W=3.4u AS=6.46p AD=6.46p PS=7.2u
+ PD=7.2u
* device instance $2447 r0 *1 497.2,124.1 NMOS
XM$2447 VSS \$I4392 \$I4393 VSS NMOS L=1u W=3.4u AS=6.46p AD=6.46p PS=7.2u
+ PD=7.2u
* device instance $2448 r0 *1 502,124.1 NMOS
XM$2448 \$I4393 WL4 BLB20 VSS NMOS L=1u W=3.4u AS=6.46p AD=10.88p PS=7.2u
+ PD=13.2u
* device instance $2449 r0 *1 724.4,85.3 PMOS
XM$2449 \$I4394 \$I4395 VDD VDD PMOS L=1u W=3.4u AS=10.88p AD=6.46p PS=13.2u
+ PD=7.2u
* device instance $2450 r0 *1 729.2,85.3 PMOS
XM$2450 VDD \$I4394 \$I4395 VDD PMOS L=1u W=3.4u AS=6.46p AD=10.88p PS=7.2u
+ PD=13.2u
* device instance $2451 r0 *1 719.6,64.9 NMOS
XM$2451 BL30 WL2 \$I4394 VSS NMOS L=1u W=3.4u AS=10.88p AD=6.46p PS=13.2u
+ PD=7.2u
* device instance $2452 r0 *1 724.4,64.9 NMOS
XM$2452 \$I4394 \$I4395 VSS VSS NMOS L=1u W=3.4u AS=6.46p AD=6.46p PS=7.2u
+ PD=7.2u
* device instance $2453 r0 *1 729.2,64.9 NMOS
XM$2453 VSS \$I4394 \$I4395 VSS NMOS L=1u W=3.4u AS=6.46p AD=6.46p PS=7.2u
+ PD=7.2u
* device instance $2454 r0 *1 734,64.9 NMOS
XM$2454 \$I4395 WL2 BLB30 VSS NMOS L=1u W=3.4u AS=6.46p AD=10.88p PS=7.2u
+ PD=13.2u
* device instance $2455 r0 *1 747.6,85.3 PMOS
XM$2455 \$I4396 \$I4397 VDD VDD PMOS L=1u W=3.4u AS=10.88p AD=6.46p PS=13.2u
+ PD=7.2u
* device instance $2456 r0 *1 752.4,85.3 PMOS
XM$2456 VDD \$I4396 \$I4397 VDD PMOS L=1u W=3.4u AS=6.46p AD=10.88p PS=7.2u
+ PD=13.2u
* device instance $2457 r0 *1 742.8,64.9 NMOS
XM$2457 BL31 WL2 \$I4396 VSS NMOS L=1u W=3.4u AS=10.88p AD=6.46p PS=13.2u
+ PD=7.2u
* device instance $2458 r0 *1 747.6,64.9 NMOS
XM$2458 \$I4396 \$I4397 VSS VSS NMOS L=1u W=3.4u AS=6.46p AD=6.46p PS=7.2u
+ PD=7.2u
* device instance $2459 r0 *1 752.4,64.9 NMOS
XM$2459 VSS \$I4396 \$I4397 VSS NMOS L=1u W=3.4u AS=6.46p AD=6.46p PS=7.2u
+ PD=7.2u
* device instance $2460 r0 *1 757.2,64.9 NMOS
XM$2460 \$I4397 WL2 BLB31 VSS NMOS L=1u W=3.4u AS=6.46p AD=10.88p PS=7.2u
+ PD=13.2u
* device instance $2461 r0 *1 701.2,85.3 PMOS
XM$2461 \$I4398 \$I4399 VDD VDD PMOS L=1u W=3.4u AS=10.88p AD=6.46p PS=13.2u
+ PD=7.2u
* device instance $2462 r0 *1 706,85.3 PMOS
XM$2462 VDD \$I4398 \$I4399 VDD PMOS L=1u W=3.4u AS=6.46p AD=10.88p PS=7.2u
+ PD=13.2u
* device instance $2463 r0 *1 696.4,64.9 NMOS
XM$2463 BL29 WL2 \$I4398 VSS NMOS L=1u W=3.4u AS=10.88p AD=6.46p PS=13.2u
+ PD=7.2u
* device instance $2464 r0 *1 701.2,64.9 NMOS
XM$2464 \$I4398 \$I4399 VSS VSS NMOS L=1u W=3.4u AS=6.46p AD=6.46p PS=7.2u
+ PD=7.2u
* device instance $2465 r0 *1 706,64.9 NMOS
XM$2465 VSS \$I4398 \$I4399 VSS NMOS L=1u W=3.4u AS=6.46p AD=6.46p PS=7.2u
+ PD=7.2u
* device instance $2466 r0 *1 710.8,64.9 NMOS
XM$2466 \$I4399 WL2 BLB29 VSS NMOS L=1u W=3.4u AS=6.46p AD=10.88p PS=7.2u
+ PD=13.2u
* device instance $2467 r0 *1 515.6,144.5 PMOS
XM$2467 \$I4400 \$I4401 VDD VDD PMOS L=1u W=3.4u AS=10.88p AD=6.46p PS=13.2u
+ PD=7.2u
* device instance $2468 r0 *1 520.4,144.5 PMOS
XM$2468 VDD \$I4400 \$I4401 VDD PMOS L=1u W=3.4u AS=6.46p AD=10.88p PS=7.2u
+ PD=13.2u
* device instance $2469 r0 *1 510.8,124.1 NMOS
XM$2469 BL21 WL4 \$I4400 VSS NMOS L=1u W=3.4u AS=10.88p AD=6.46p PS=13.2u
+ PD=7.2u
* device instance $2470 r0 *1 515.6,124.1 NMOS
XM$2470 \$I4400 \$I4401 VSS VSS NMOS L=1u W=3.4u AS=6.46p AD=6.46p PS=7.2u
+ PD=7.2u
* device instance $2471 r0 *1 520.4,124.1 NMOS
XM$2471 VSS \$I4400 \$I4401 VSS NMOS L=1u W=3.4u AS=6.46p AD=6.46p PS=7.2u
+ PD=7.2u
* device instance $2472 r0 *1 525.2,124.1 NMOS
XM$2472 \$I4401 WL4 BLB21 VSS NMOS L=1u W=3.4u AS=6.46p AD=10.88p PS=7.2u
+ PD=13.2u
* device instance $2473 r0 *1 538.8,144.5 PMOS
XM$2473 \$I4402 \$I4403 VDD VDD PMOS L=1u W=3.4u AS=10.88p AD=6.46p PS=13.2u
+ PD=7.2u
* device instance $2474 r0 *1 543.6,144.5 PMOS
XM$2474 VDD \$I4402 \$I4403 VDD PMOS L=1u W=3.4u AS=6.46p AD=10.88p PS=7.2u
+ PD=13.2u
* device instance $2475 r0 *1 534,124.1 NMOS
XM$2475 BL22 WL4 \$I4402 VSS NMOS L=1u W=3.4u AS=10.88p AD=6.46p PS=13.2u
+ PD=7.2u
* device instance $2476 r0 *1 538.8,124.1 NMOS
XM$2476 \$I4402 \$I4403 VSS VSS NMOS L=1u W=3.4u AS=6.46p AD=6.46p PS=7.2u
+ PD=7.2u
* device instance $2477 r0 *1 543.6,124.1 NMOS
XM$2477 VSS \$I4402 \$I4403 VSS NMOS L=1u W=3.4u AS=6.46p AD=6.46p PS=7.2u
+ PD=7.2u
* device instance $2478 r0 *1 548.4,124.1 NMOS
XM$2478 \$I4403 WL4 BLB22 VSS NMOS L=1u W=3.4u AS=6.46p AD=10.88p PS=7.2u
+ PD=13.2u
* device instance $2479 r0 *1 399.6,144.5 PMOS
XM$2479 \$I4404 \$I4405 VDD VDD PMOS L=1u W=3.4u AS=10.88p AD=6.46p PS=13.2u
+ PD=7.2u
* device instance $2480 r0 *1 404.4,144.5 PMOS
XM$2480 VDD \$I4404 \$I4405 VDD PMOS L=1u W=3.4u AS=6.46p AD=10.88p PS=7.2u
+ PD=13.2u
* device instance $2481 r0 *1 394.8,124.1 NMOS
XM$2481 BL16 WL4 \$I4404 VSS NMOS L=1u W=3.4u AS=10.88p AD=6.46p PS=13.2u
+ PD=7.2u
* device instance $2482 r0 *1 399.6,124.1 NMOS
XM$2482 \$I4404 \$I4405 VSS VSS NMOS L=1u W=3.4u AS=6.46p AD=6.46p PS=7.2u
+ PD=7.2u
* device instance $2483 r0 *1 404.4,124.1 NMOS
XM$2483 VSS \$I4404 \$I4405 VSS NMOS L=1u W=3.4u AS=6.46p AD=6.46p PS=7.2u
+ PD=7.2u
* device instance $2484 r0 *1 409.2,124.1 NMOS
XM$2484 \$I4405 WL4 BLB16 VSS NMOS L=1u W=3.4u AS=6.46p AD=10.88p PS=7.2u
+ PD=13.2u
* device instance $2485 r0 *1 422.8,144.5 PMOS
XM$2485 \$I4406 \$I4407 VDD VDD PMOS L=1u W=3.4u AS=10.88p AD=6.46p PS=13.2u
+ PD=7.2u
* device instance $2486 r0 *1 427.6,144.5 PMOS
XM$2486 VDD \$I4406 \$I4407 VDD PMOS L=1u W=3.4u AS=6.46p AD=10.88p PS=7.2u
+ PD=13.2u
* device instance $2487 r0 *1 418,124.1 NMOS
XM$2487 BL17 WL4 \$I4406 VSS NMOS L=1u W=3.4u AS=10.88p AD=6.46p PS=13.2u
+ PD=7.2u
* device instance $2488 r0 *1 422.8,124.1 NMOS
XM$2488 \$I4406 \$I4407 VSS VSS NMOS L=1u W=3.4u AS=6.46p AD=6.46p PS=7.2u
+ PD=7.2u
* device instance $2489 r0 *1 427.6,124.1 NMOS
XM$2489 VSS \$I4406 \$I4407 VSS NMOS L=1u W=3.4u AS=6.46p AD=6.46p PS=7.2u
+ PD=7.2u
* device instance $2490 r0 *1 432.4,124.1 NMOS
XM$2490 \$I4407 WL4 BLB17 VSS NMOS L=1u W=3.4u AS=6.46p AD=10.88p PS=7.2u
+ PD=13.2u
* device instance $2491 r0 *1 446,144.5 PMOS
XM$2491 \$I4408 \$I4409 VDD VDD PMOS L=1u W=3.4u AS=10.88p AD=6.46p PS=13.2u
+ PD=7.2u
* device instance $2492 r0 *1 450.8,144.5 PMOS
XM$2492 VDD \$I4408 \$I4409 VDD PMOS L=1u W=3.4u AS=6.46p AD=10.88p PS=7.2u
+ PD=13.2u
* device instance $2493 r0 *1 441.2,124.1 NMOS
XM$2493 BL18 WL4 \$I4408 VSS NMOS L=1u W=3.4u AS=10.88p AD=6.46p PS=13.2u
+ PD=7.2u
* device instance $2494 r0 *1 446,124.1 NMOS
XM$2494 \$I4408 \$I4409 VSS VSS NMOS L=1u W=3.4u AS=6.46p AD=6.46p PS=7.2u
+ PD=7.2u
* device instance $2495 r0 *1 450.8,124.1 NMOS
XM$2495 VSS \$I4408 \$I4409 VSS NMOS L=1u W=3.4u AS=6.46p AD=6.46p PS=7.2u
+ PD=7.2u
* device instance $2496 r0 *1 455.6,124.1 NMOS
XM$2496 \$I4409 WL4 BLB18 VSS NMOS L=1u W=3.4u AS=6.46p AD=10.88p PS=7.2u
+ PD=13.2u
* device instance $2497 r0 *1 399.6,203.7 PMOS
XM$2497 \$I4410 \$I4411 VDD VDD PMOS L=1u W=3.4u AS=10.88p AD=6.46p PS=13.2u
+ PD=7.2u
* device instance $2498 r0 *1 404.4,203.7 PMOS
XM$2498 VDD \$I4410 \$I4411 VDD PMOS L=1u W=3.4u AS=6.46p AD=10.88p PS=7.2u
+ PD=13.2u
* device instance $2499 r0 *1 394.8,183.3 NMOS
XM$2499 BL16 WL6 \$I4410 VSS NMOS L=1u W=3.4u AS=10.88p AD=6.46p PS=13.2u
+ PD=7.2u
* device instance $2500 r0 *1 399.6,183.3 NMOS
XM$2500 \$I4410 \$I4411 VSS VSS NMOS L=1u W=3.4u AS=6.46p AD=6.46p PS=7.2u
+ PD=7.2u
* device instance $2501 r0 *1 404.4,183.3 NMOS
XM$2501 VSS \$I4410 \$I4411 VSS NMOS L=1u W=3.4u AS=6.46p AD=6.46p PS=7.2u
+ PD=7.2u
* device instance $2502 r0 *1 409.2,183.3 NMOS
XM$2502 \$I4411 WL6 BLB16 VSS NMOS L=1u W=3.4u AS=6.46p AD=10.88p PS=7.2u
+ PD=13.2u
* device instance $2503 r0 *1 422.8,203.7 PMOS
XM$2503 \$I4412 \$I4413 VDD VDD PMOS L=1u W=3.4u AS=10.88p AD=6.46p PS=13.2u
+ PD=7.2u
* device instance $2504 r0 *1 427.6,203.7 PMOS
XM$2504 VDD \$I4412 \$I4413 VDD PMOS L=1u W=3.4u AS=6.46p AD=10.88p PS=7.2u
+ PD=13.2u
* device instance $2505 r0 *1 418,183.3 NMOS
XM$2505 BL17 WL6 \$I4412 VSS NMOS L=1u W=3.4u AS=10.88p AD=6.46p PS=13.2u
+ PD=7.2u
* device instance $2506 r0 *1 422.8,183.3 NMOS
XM$2506 \$I4412 \$I4413 VSS VSS NMOS L=1u W=3.4u AS=6.46p AD=6.46p PS=7.2u
+ PD=7.2u
* device instance $2507 r0 *1 427.6,183.3 NMOS
XM$2507 VSS \$I4412 \$I4413 VSS NMOS L=1u W=3.4u AS=6.46p AD=6.46p PS=7.2u
+ PD=7.2u
* device instance $2508 r0 *1 432.4,183.3 NMOS
XM$2508 \$I4413 WL6 BLB17 VSS NMOS L=1u W=3.4u AS=6.46p AD=10.88p PS=7.2u
+ PD=13.2u
* device instance $2509 r0 *1 446,203.7 PMOS
XM$2509 \$I4414 \$I4415 VDD VDD PMOS L=1u W=3.4u AS=10.88p AD=6.46p PS=13.2u
+ PD=7.2u
* device instance $2510 r0 *1 450.8,203.7 PMOS
XM$2510 VDD \$I4414 \$I4415 VDD PMOS L=1u W=3.4u AS=6.46p AD=10.88p PS=7.2u
+ PD=13.2u
* device instance $2511 r0 *1 441.2,183.3 NMOS
XM$2511 BL18 WL6 \$I4414 VSS NMOS L=1u W=3.4u AS=10.88p AD=6.46p PS=13.2u
+ PD=7.2u
* device instance $2512 r0 *1 446,183.3 NMOS
XM$2512 \$I4414 \$I4415 VSS VSS NMOS L=1u W=3.4u AS=6.46p AD=6.46p PS=7.2u
+ PD=7.2u
* device instance $2513 r0 *1 450.8,183.3 NMOS
XM$2513 VSS \$I4414 \$I4415 VSS NMOS L=1u W=3.4u AS=6.46p AD=6.46p PS=7.2u
+ PD=7.2u
* device instance $2514 r0 *1 455.6,183.3 NMOS
XM$2514 \$I4415 WL6 BLB18 VSS NMOS L=1u W=3.4u AS=6.46p AD=10.88p PS=7.2u
+ PD=13.2u
* device instance $2515 r0 *1 469.2,203.7 PMOS
XM$2515 \$I4416 \$I4417 VDD VDD PMOS L=1u W=3.4u AS=10.88p AD=6.46p PS=13.2u
+ PD=7.2u
* device instance $2516 r0 *1 474,203.7 PMOS
XM$2516 VDD \$I4416 \$I4417 VDD PMOS L=1u W=3.4u AS=6.46p AD=10.88p PS=7.2u
+ PD=13.2u
* device instance $2517 r0 *1 464.4,183.3 NMOS
XM$2517 BL19 WL6 \$I4416 VSS NMOS L=1u W=3.4u AS=10.88p AD=6.46p PS=13.2u
+ PD=7.2u
* device instance $2518 r0 *1 469.2,183.3 NMOS
XM$2518 \$I4416 \$I4417 VSS VSS NMOS L=1u W=3.4u AS=6.46p AD=6.46p PS=7.2u
+ PD=7.2u
* device instance $2519 r0 *1 474,183.3 NMOS
XM$2519 VSS \$I4416 \$I4417 VSS NMOS L=1u W=3.4u AS=6.46p AD=6.46p PS=7.2u
+ PD=7.2u
* device instance $2520 r0 *1 478.8,183.3 NMOS
XM$2520 \$I4417 WL6 BLB19 VSS NMOS L=1u W=3.4u AS=6.46p AD=10.88p PS=7.2u
+ PD=13.2u
* device instance $2521 r0 *1 492.4,203.7 PMOS
XM$2521 \$I4418 \$I4419 VDD VDD PMOS L=1u W=3.4u AS=10.88p AD=6.46p PS=13.2u
+ PD=7.2u
* device instance $2522 r0 *1 497.2,203.7 PMOS
XM$2522 VDD \$I4418 \$I4419 VDD PMOS L=1u W=3.4u AS=6.46p AD=10.88p PS=7.2u
+ PD=13.2u
* device instance $2523 r0 *1 487.6,183.3 NMOS
XM$2523 BL20 WL6 \$I4418 VSS NMOS L=1u W=3.4u AS=10.88p AD=6.46p PS=13.2u
+ PD=7.2u
* device instance $2524 r0 *1 492.4,183.3 NMOS
XM$2524 \$I4418 \$I4419 VSS VSS NMOS L=1u W=3.4u AS=6.46p AD=6.46p PS=7.2u
+ PD=7.2u
* device instance $2525 r0 *1 497.2,183.3 NMOS
XM$2525 VSS \$I4418 \$I4419 VSS NMOS L=1u W=3.4u AS=6.46p AD=6.46p PS=7.2u
+ PD=7.2u
* device instance $2526 r0 *1 502,183.3 NMOS
XM$2526 \$I4419 WL6 BLB20 VSS NMOS L=1u W=3.4u AS=6.46p AD=10.88p PS=7.2u
+ PD=13.2u
* device instance $2527 r0 *1 492.4,85.3 PMOS
XM$2527 \$I4420 \$I4421 VDD VDD PMOS L=1u W=3.4u AS=10.88p AD=6.46p PS=13.2u
+ PD=7.2u
* device instance $2528 r0 *1 497.2,85.3 PMOS
XM$2528 VDD \$I4420 \$I4421 VDD PMOS L=1u W=3.4u AS=6.46p AD=10.88p PS=7.2u
+ PD=13.2u
* device instance $2529 r0 *1 487.6,64.9 NMOS
XM$2529 BL20 WL2 \$I4420 VSS NMOS L=1u W=3.4u AS=10.88p AD=6.46p PS=13.2u
+ PD=7.2u
* device instance $2530 r0 *1 492.4,64.9 NMOS
XM$2530 \$I4420 \$I4421 VSS VSS NMOS L=1u W=3.4u AS=6.46p AD=6.46p PS=7.2u
+ PD=7.2u
* device instance $2531 r0 *1 497.2,64.9 NMOS
XM$2531 VSS \$I4420 \$I4421 VSS NMOS L=1u W=3.4u AS=6.46p AD=6.46p PS=7.2u
+ PD=7.2u
* device instance $2532 r0 *1 502,64.9 NMOS
XM$2532 \$I4421 WL2 BLB20 VSS NMOS L=1u W=3.4u AS=6.46p AD=10.88p PS=7.2u
+ PD=13.2u
* device instance $2533 r0 *1 538.8,203.7 PMOS
XM$2533 \$I4422 \$I4423 VDD VDD PMOS L=1u W=3.4u AS=10.88p AD=6.46p PS=13.2u
+ PD=7.2u
* device instance $2534 r0 *1 543.6,203.7 PMOS
XM$2534 VDD \$I4422 \$I4423 VDD PMOS L=1u W=3.4u AS=6.46p AD=10.88p PS=7.2u
+ PD=13.2u
* device instance $2535 r0 *1 534,183.3 NMOS
XM$2535 BL22 WL6 \$I4422 VSS NMOS L=1u W=3.4u AS=10.88p AD=6.46p PS=13.2u
+ PD=7.2u
* device instance $2536 r0 *1 538.8,183.3 NMOS
XM$2536 \$I4422 \$I4423 VSS VSS NMOS L=1u W=3.4u AS=6.46p AD=6.46p PS=7.2u
+ PD=7.2u
* device instance $2537 r0 *1 543.6,183.3 NMOS
XM$2537 VSS \$I4422 \$I4423 VSS NMOS L=1u W=3.4u AS=6.46p AD=6.46p PS=7.2u
+ PD=7.2u
* device instance $2538 r0 *1 548.4,183.3 NMOS
XM$2538 \$I4423 WL6 BLB22 VSS NMOS L=1u W=3.4u AS=6.46p AD=10.88p PS=7.2u
+ PD=13.2u
* device instance $2539 r0 *1 399.6,85.3 PMOS
XM$2539 \$I4424 \$I4425 VDD VDD PMOS L=1u W=3.4u AS=10.88p AD=6.46p PS=13.2u
+ PD=7.2u
* device instance $2540 r0 *1 404.4,85.3 PMOS
XM$2540 VDD \$I4424 \$I4425 VDD PMOS L=1u W=3.4u AS=6.46p AD=10.88p PS=7.2u
+ PD=13.2u
* device instance $2541 r0 *1 394.8,64.9 NMOS
XM$2541 BL16 WL2 \$I4424 VSS NMOS L=1u W=3.4u AS=10.88p AD=6.46p PS=13.2u
+ PD=7.2u
* device instance $2542 r0 *1 399.6,64.9 NMOS
XM$2542 \$I4424 \$I4425 VSS VSS NMOS L=1u W=3.4u AS=6.46p AD=6.46p PS=7.2u
+ PD=7.2u
* device instance $2543 r0 *1 404.4,64.9 NMOS
XM$2543 VSS \$I4424 \$I4425 VSS NMOS L=1u W=3.4u AS=6.46p AD=6.46p PS=7.2u
+ PD=7.2u
* device instance $2544 r0 *1 409.2,64.9 NMOS
XM$2544 \$I4425 WL2 BLB16 VSS NMOS L=1u W=3.4u AS=6.46p AD=10.88p PS=7.2u
+ PD=13.2u
* device instance $2545 r0 *1 422.8,85.3 PMOS
XM$2545 \$I4426 \$I4427 VDD VDD PMOS L=1u W=3.4u AS=10.88p AD=6.46p PS=13.2u
+ PD=7.2u
* device instance $2546 r0 *1 427.6,85.3 PMOS
XM$2546 VDD \$I4426 \$I4427 VDD PMOS L=1u W=3.4u AS=6.46p AD=10.88p PS=7.2u
+ PD=13.2u
* device instance $2547 r0 *1 418,64.9 NMOS
XM$2547 BL17 WL2 \$I4426 VSS NMOS L=1u W=3.4u AS=10.88p AD=6.46p PS=13.2u
+ PD=7.2u
* device instance $2548 r0 *1 422.8,64.9 NMOS
XM$2548 \$I4426 \$I4427 VSS VSS NMOS L=1u W=3.4u AS=6.46p AD=6.46p PS=7.2u
+ PD=7.2u
* device instance $2549 r0 *1 427.6,64.9 NMOS
XM$2549 VSS \$I4426 \$I4427 VSS NMOS L=1u W=3.4u AS=6.46p AD=6.46p PS=7.2u
+ PD=7.2u
* device instance $2550 r0 *1 432.4,64.9 NMOS
XM$2550 \$I4427 WL2 BLB17 VSS NMOS L=1u W=3.4u AS=6.46p AD=10.88p PS=7.2u
+ PD=13.2u
* device instance $2551 r0 *1 446,85.3 PMOS
XM$2551 \$I4428 \$I4429 VDD VDD PMOS L=1u W=3.4u AS=10.88p AD=6.46p PS=13.2u
+ PD=7.2u
* device instance $2552 r0 *1 450.8,85.3 PMOS
XM$2552 VDD \$I4428 \$I4429 VDD PMOS L=1u W=3.4u AS=6.46p AD=10.88p PS=7.2u
+ PD=13.2u
* device instance $2553 r0 *1 441.2,64.9 NMOS
XM$2553 BL18 WL2 \$I4428 VSS NMOS L=1u W=3.4u AS=10.88p AD=6.46p PS=13.2u
+ PD=7.2u
* device instance $2554 r0 *1 446,64.9 NMOS
XM$2554 \$I4428 \$I4429 VSS VSS NMOS L=1u W=3.4u AS=6.46p AD=6.46p PS=7.2u
+ PD=7.2u
* device instance $2555 r0 *1 450.8,64.9 NMOS
XM$2555 VSS \$I4428 \$I4429 VSS NMOS L=1u W=3.4u AS=6.46p AD=6.46p PS=7.2u
+ PD=7.2u
* device instance $2556 r0 *1 455.6,64.9 NMOS
XM$2556 \$I4429 WL2 BLB18 VSS NMOS L=1u W=3.4u AS=6.46p AD=10.88p PS=7.2u
+ PD=13.2u
* device instance $2557 r0 *1 469.2,85.3 PMOS
XM$2557 \$I4430 \$I4431 VDD VDD PMOS L=1u W=3.4u AS=10.88p AD=6.46p PS=13.2u
+ PD=7.2u
* device instance $2558 r0 *1 474,85.3 PMOS
XM$2558 VDD \$I4430 \$I4431 VDD PMOS L=1u W=3.4u AS=6.46p AD=10.88p PS=7.2u
+ PD=13.2u
* device instance $2559 r0 *1 464.4,64.9 NMOS
XM$2559 BL19 WL2 \$I4430 VSS NMOS L=1u W=3.4u AS=10.88p AD=6.46p PS=13.2u
+ PD=7.2u
* device instance $2560 r0 *1 469.2,64.9 NMOS
XM$2560 \$I4430 \$I4431 VSS VSS NMOS L=1u W=3.4u AS=6.46p AD=6.46p PS=7.2u
+ PD=7.2u
* device instance $2561 r0 *1 474,64.9 NMOS
XM$2561 VSS \$I4430 \$I4431 VSS NMOS L=1u W=3.4u AS=6.46p AD=6.46p PS=7.2u
+ PD=7.2u
* device instance $2562 r0 *1 478.8,64.9 NMOS
XM$2562 \$I4431 WL2 BLB19 VSS NMOS L=1u W=3.4u AS=6.46p AD=10.88p PS=7.2u
+ PD=13.2u
* device instance $2563 r0 *1 515.6,203.7 PMOS
XM$2563 \$I4432 \$I4433 VDD VDD PMOS L=1u W=3.4u AS=10.88p AD=6.46p PS=13.2u
+ PD=7.2u
* device instance $2564 r0 *1 520.4,203.7 PMOS
XM$2564 VDD \$I4432 \$I4433 VDD PMOS L=1u W=3.4u AS=6.46p AD=10.88p PS=7.2u
+ PD=13.2u
* device instance $2565 r0 *1 510.8,183.3 NMOS
XM$2565 BL21 WL6 \$I4432 VSS NMOS L=1u W=3.4u AS=10.88p AD=6.46p PS=13.2u
+ PD=7.2u
* device instance $2566 r0 *1 515.6,183.3 NMOS
XM$2566 \$I4432 \$I4433 VSS VSS NMOS L=1u W=3.4u AS=6.46p AD=6.46p PS=7.2u
+ PD=7.2u
* device instance $2567 r0 *1 520.4,183.3 NMOS
XM$2567 VSS \$I4432 \$I4433 VSS NMOS L=1u W=3.4u AS=6.46p AD=6.46p PS=7.2u
+ PD=7.2u
* device instance $2568 r0 *1 525.2,183.3 NMOS
XM$2568 \$I4433 WL6 BLB21 VSS NMOS L=1u W=3.4u AS=6.46p AD=10.88p PS=7.2u
+ PD=13.2u
* device instance $2569 r0 *1 7.2,262.9 PMOS
XM$2569 \$I4434 \$I4435 VDD VDD PMOS L=1u W=3.4u AS=10.88p AD=6.46p PS=13.2u
+ PD=7.2u
* device instance $2570 r0 *1 12,262.9 PMOS
XM$2570 VDD \$I4434 \$I4435 VDD PMOS L=1u W=3.4u AS=6.46p AD=10.88p PS=7.2u
+ PD=13.2u
* device instance $2571 r0 *1 2.4,242.5 NMOS
XM$2571 BL0 WL8 \$I4434 VSS NMOS L=1u W=3.4u AS=10.88p AD=6.46p PS=13.2u PD=7.2u
* device instance $2572 r0 *1 7.2,242.5 NMOS
XM$2572 \$I4434 \$I4435 VSS VSS NMOS L=1u W=3.4u AS=6.46p AD=6.46p PS=7.2u
+ PD=7.2u
* device instance $2573 r0 *1 12,242.5 NMOS
XM$2573 VSS \$I4434 \$I4435 VSS NMOS L=1u W=3.4u AS=6.46p AD=6.46p PS=7.2u
+ PD=7.2u
* device instance $2574 r0 *1 16.8,242.5 NMOS
XM$2574 \$I4435 WL8 BLB0 VSS NMOS L=1u W=3.4u AS=6.46p AD=10.88p PS=7.2u
+ PD=13.2u
* device instance $2575 r0 *1 30.4,262.9 PMOS
XM$2575 \$I4436 \$I4437 VDD VDD PMOS L=1u W=3.4u AS=10.88p AD=6.46p PS=13.2u
+ PD=7.2u
* device instance $2576 r0 *1 35.2,262.9 PMOS
XM$2576 VDD \$I4436 \$I4437 VDD PMOS L=1u W=3.4u AS=6.46p AD=10.88p PS=7.2u
+ PD=13.2u
* device instance $2577 r0 *1 25.6,242.5 NMOS
XM$2577 BL1 WL8 \$I4436 VSS NMOS L=1u W=3.4u AS=10.88p AD=6.46p PS=13.2u PD=7.2u
* device instance $2578 r0 *1 30.4,242.5 NMOS
XM$2578 \$I4436 \$I4437 VSS VSS NMOS L=1u W=3.4u AS=6.46p AD=6.46p PS=7.2u
+ PD=7.2u
* device instance $2579 r0 *1 35.2,242.5 NMOS
XM$2579 VSS \$I4436 \$I4437 VSS NMOS L=1u W=3.4u AS=6.46p AD=6.46p PS=7.2u
+ PD=7.2u
* device instance $2580 r0 *1 40,242.5 NMOS
XM$2580 \$I4437 WL8 BLB1 VSS NMOS L=1u W=3.4u AS=6.46p AD=10.88p PS=7.2u
+ PD=13.2u
* device instance $2581 r0 *1 53.6,262.9 PMOS
XM$2581 \$I4438 \$I4439 VDD VDD PMOS L=1u W=3.4u AS=10.88p AD=6.46p PS=13.2u
+ PD=7.2u
* device instance $2582 r0 *1 58.4,262.9 PMOS
XM$2582 VDD \$I4438 \$I4439 VDD PMOS L=1u W=3.4u AS=6.46p AD=10.88p PS=7.2u
+ PD=13.2u
* device instance $2583 r0 *1 48.8,242.5 NMOS
XM$2583 BL2 WL8 \$I4438 VSS NMOS L=1u W=3.4u AS=10.88p AD=6.46p PS=13.2u PD=7.2u
* device instance $2584 r0 *1 53.6,242.5 NMOS
XM$2584 \$I4438 \$I4439 VSS VSS NMOS L=1u W=3.4u AS=6.46p AD=6.46p PS=7.2u
+ PD=7.2u
* device instance $2585 r0 *1 58.4,242.5 NMOS
XM$2585 VSS \$I4438 \$I4439 VSS NMOS L=1u W=3.4u AS=6.46p AD=6.46p PS=7.2u
+ PD=7.2u
* device instance $2586 r0 *1 63.2,242.5 NMOS
XM$2586 \$I4439 WL8 BLB2 VSS NMOS L=1u W=3.4u AS=6.46p AD=10.88p PS=7.2u
+ PD=13.2u
* device instance $2587 r0 *1 76.8,262.9 PMOS
XM$2587 \$I4440 \$I4441 VDD VDD PMOS L=1u W=3.4u AS=10.88p AD=6.46p PS=13.2u
+ PD=7.2u
* device instance $2588 r0 *1 81.6,262.9 PMOS
XM$2588 VDD \$I4440 \$I4441 VDD PMOS L=1u W=3.4u AS=6.46p AD=10.88p PS=7.2u
+ PD=13.2u
* device instance $2589 r0 *1 72,242.5 NMOS
XM$2589 BL3 WL8 \$I4440 VSS NMOS L=1u W=3.4u AS=10.88p AD=6.46p PS=13.2u PD=7.2u
* device instance $2590 r0 *1 76.8,242.5 NMOS
XM$2590 \$I4440 \$I4441 VSS VSS NMOS L=1u W=3.4u AS=6.46p AD=6.46p PS=7.2u
+ PD=7.2u
* device instance $2591 r0 *1 81.6,242.5 NMOS
XM$2591 VSS \$I4440 \$I4441 VSS NMOS L=1u W=3.4u AS=6.46p AD=6.46p PS=7.2u
+ PD=7.2u
* device instance $2592 r0 *1 86.4,242.5 NMOS
XM$2592 \$I4441 WL8 BLB3 VSS NMOS L=1u W=3.4u AS=6.46p AD=10.88p PS=7.2u
+ PD=13.2u
* device instance $2593 r0 *1 100,262.9 PMOS
XM$2593 \$I4442 \$I4443 VDD VDD PMOS L=1u W=3.4u AS=10.88p AD=6.46p PS=13.2u
+ PD=7.2u
* device instance $2594 r0 *1 104.8,262.9 PMOS
XM$2594 VDD \$I4442 \$I4443 VDD PMOS L=1u W=3.4u AS=6.46p AD=10.88p PS=7.2u
+ PD=13.2u
* device instance $2595 r0 *1 95.2,242.5 NMOS
XM$2595 BL4 WL8 \$I4442 VSS NMOS L=1u W=3.4u AS=10.88p AD=6.46p PS=13.2u PD=7.2u
* device instance $2596 r0 *1 100,242.5 NMOS
XM$2596 \$I4442 \$I4443 VSS VSS NMOS L=1u W=3.4u AS=6.46p AD=6.46p PS=7.2u
+ PD=7.2u
* device instance $2597 r0 *1 104.8,242.5 NMOS
XM$2597 VSS \$I4442 \$I4443 VSS NMOS L=1u W=3.4u AS=6.46p AD=6.46p PS=7.2u
+ PD=7.2u
* device instance $2598 r0 *1 109.6,242.5 NMOS
XM$2598 \$I4443 WL8 BLB4 VSS NMOS L=1u W=3.4u AS=6.46p AD=10.88p PS=7.2u
+ PD=13.2u
* device instance $2599 r0 *1 123.2,262.9 PMOS
XM$2599 \$I4444 \$I4445 VDD VDD PMOS L=1u W=3.4u AS=10.88p AD=6.46p PS=13.2u
+ PD=7.2u
* device instance $2600 r0 *1 128,262.9 PMOS
XM$2600 VDD \$I4444 \$I4445 VDD PMOS L=1u W=3.4u AS=6.46p AD=10.88p PS=7.2u
+ PD=13.2u
* device instance $2601 r0 *1 118.4,242.5 NMOS
XM$2601 BL5 WL8 \$I4444 VSS NMOS L=1u W=3.4u AS=10.88p AD=6.46p PS=13.2u PD=7.2u
* device instance $2602 r0 *1 123.2,242.5 NMOS
XM$2602 \$I4444 \$I4445 VSS VSS NMOS L=1u W=3.4u AS=6.46p AD=6.46p PS=7.2u
+ PD=7.2u
* device instance $2603 r0 *1 128,242.5 NMOS
XM$2603 VSS \$I4444 \$I4445 VSS NMOS L=1u W=3.4u AS=6.46p AD=6.46p PS=7.2u
+ PD=7.2u
* device instance $2604 r0 *1 132.8,242.5 NMOS
XM$2604 \$I4445 WL8 BLB5 VSS NMOS L=1u W=3.4u AS=6.46p AD=10.88p PS=7.2u
+ PD=13.2u
* device instance $2605 r0 *1 146.4,262.9 PMOS
XM$2605 \$I4446 \$I4447 VDD VDD PMOS L=1u W=3.4u AS=10.88p AD=6.46p PS=13.2u
+ PD=7.2u
* device instance $2606 r0 *1 151.2,262.9 PMOS
XM$2606 VDD \$I4446 \$I4447 VDD PMOS L=1u W=3.4u AS=6.46p AD=10.88p PS=7.2u
+ PD=13.2u
* device instance $2607 r0 *1 141.6,242.5 NMOS
XM$2607 BL6 WL8 \$I4446 VSS NMOS L=1u W=3.4u AS=10.88p AD=6.46p PS=13.2u PD=7.2u
* device instance $2608 r0 *1 146.4,242.5 NMOS
XM$2608 \$I4446 \$I4447 VSS VSS NMOS L=1u W=3.4u AS=6.46p AD=6.46p PS=7.2u
+ PD=7.2u
* device instance $2609 r0 *1 151.2,242.5 NMOS
XM$2609 VSS \$I4446 \$I4447 VSS NMOS L=1u W=3.4u AS=6.46p AD=6.46p PS=7.2u
+ PD=7.2u
* device instance $2610 r0 *1 156,242.5 NMOS
XM$2610 \$I4447 WL8 BLB6 VSS NMOS L=1u W=3.4u AS=6.46p AD=10.88p PS=7.2u
+ PD=13.2u
* device instance $2611 r0 *1 169.6,262.9 PMOS
XM$2611 \$I4448 \$I4449 VDD VDD PMOS L=1u W=3.4u AS=10.88p AD=6.46p PS=13.2u
+ PD=7.2u
* device instance $2612 r0 *1 174.4,262.9 PMOS
XM$2612 VDD \$I4448 \$I4449 VDD PMOS L=1u W=3.4u AS=6.46p AD=10.88p PS=7.2u
+ PD=13.2u
* device instance $2613 r0 *1 164.8,242.5 NMOS
XM$2613 BL7 WL8 \$I4448 VSS NMOS L=1u W=3.4u AS=10.88p AD=6.46p PS=13.2u PD=7.2u
* device instance $2614 r0 *1 169.6,242.5 NMOS
XM$2614 \$I4448 \$I4449 VSS VSS NMOS L=1u W=3.4u AS=6.46p AD=6.46p PS=7.2u
+ PD=7.2u
* device instance $2615 r0 *1 174.4,242.5 NMOS
XM$2615 VSS \$I4448 \$I4449 VSS NMOS L=1u W=3.4u AS=6.46p AD=6.46p PS=7.2u
+ PD=7.2u
* device instance $2616 r0 *1 179.2,242.5 NMOS
XM$2616 \$I4449 WL8 BLB7 VSS NMOS L=1u W=3.4u AS=6.46p AD=10.88p PS=7.2u
+ PD=13.2u
* device instance $2617 r0 *1 332,322.1 PMOS
XM$2617 \$I4450 \$I4451 VDD VDD PMOS L=1u W=3.4u AS=10.88p AD=6.46p PS=13.2u
+ PD=7.2u
* device instance $2618 r0 *1 336.8,322.1 PMOS
XM$2618 VDD \$I4450 \$I4451 VDD PMOS L=1u W=3.4u AS=6.46p AD=10.88p PS=7.2u
+ PD=13.2u
* device instance $2619 r0 *1 327.2,301.7 NMOS
XM$2619 BL14 WL10 \$I4450 VSS NMOS L=1u W=3.4u AS=10.88p AD=6.46p PS=13.2u
+ PD=7.2u
* device instance $2620 r0 *1 332,301.7 NMOS
XM$2620 \$I4450 \$I4451 VSS VSS NMOS L=1u W=3.4u AS=6.46p AD=6.46p PS=7.2u
+ PD=7.2u
* device instance $2621 r0 *1 336.8,301.7 NMOS
XM$2621 VSS \$I4450 \$I4451 VSS NMOS L=1u W=3.4u AS=6.46p AD=6.46p PS=7.2u
+ PD=7.2u
* device instance $2622 r0 *1 341.6,301.7 NMOS
XM$2622 \$I4451 WL10 BLB14 VSS NMOS L=1u W=3.4u AS=6.46p AD=10.88p PS=7.2u
+ PD=13.2u
* device instance $2623 r0 *1 146.4,85.3 PMOS
XM$2623 \$I4452 \$I4453 VDD VDD PMOS L=1u W=3.4u AS=10.88p AD=6.46p PS=13.2u
+ PD=7.2u
* device instance $2624 r0 *1 151.2,85.3 PMOS
XM$2624 VDD \$I4452 \$I4453 VDD PMOS L=1u W=3.4u AS=6.46p AD=10.88p PS=7.2u
+ PD=13.2u
* device instance $2625 r0 *1 141.6,64.9 NMOS
XM$2625 BL6 WL2 \$I4452 VSS NMOS L=1u W=3.4u AS=10.88p AD=6.46p PS=13.2u PD=7.2u
* device instance $2626 r0 *1 146.4,64.9 NMOS
XM$2626 \$I4452 \$I4453 VSS VSS NMOS L=1u W=3.4u AS=6.46p AD=6.46p PS=7.2u
+ PD=7.2u
* device instance $2627 r0 *1 151.2,64.9 NMOS
XM$2627 VSS \$I4452 \$I4453 VSS NMOS L=1u W=3.4u AS=6.46p AD=6.46p PS=7.2u
+ PD=7.2u
* device instance $2628 r0 *1 156,64.9 NMOS
XM$2628 \$I4453 WL2 BLB6 VSS NMOS L=1u W=3.4u AS=6.46p AD=10.88p PS=7.2u
+ PD=13.2u
* device instance $2629 r0 *1 216,322.1 PMOS
XM$2629 \$I4454 \$I4455 VDD VDD PMOS L=1u W=3.4u AS=10.88p AD=6.46p PS=13.2u
+ PD=7.2u
* device instance $2630 r0 *1 220.8,322.1 PMOS
XM$2630 VDD \$I4454 \$I4455 VDD PMOS L=1u W=3.4u AS=6.46p AD=10.88p PS=7.2u
+ PD=13.2u
* device instance $2631 r0 *1 211.2,301.7 NMOS
XM$2631 BL9 WL10 \$I4454 VSS NMOS L=1u W=3.4u AS=10.88p AD=6.46p PS=13.2u
+ PD=7.2u
* device instance $2632 r0 *1 216,301.7 NMOS
XM$2632 \$I4454 \$I4455 VSS VSS NMOS L=1u W=3.4u AS=6.46p AD=6.46p PS=7.2u
+ PD=7.2u
* device instance $2633 r0 *1 220.8,301.7 NMOS
XM$2633 VSS \$I4454 \$I4455 VSS NMOS L=1u W=3.4u AS=6.46p AD=6.46p PS=7.2u
+ PD=7.2u
* device instance $2634 r0 *1 225.6,301.7 NMOS
XM$2634 \$I4455 WL10 BLB9 VSS NMOS L=1u W=3.4u AS=6.46p AD=10.88p PS=7.2u
+ PD=13.2u
* device instance $2635 r0 *1 239.2,322.1 PMOS
XM$2635 \$I4456 \$I4457 VDD VDD PMOS L=1u W=3.4u AS=10.88p AD=6.46p PS=13.2u
+ PD=7.2u
* device instance $2636 r0 *1 244,322.1 PMOS
XM$2636 VDD \$I4456 \$I4457 VDD PMOS L=1u W=3.4u AS=6.46p AD=10.88p PS=7.2u
+ PD=13.2u
* device instance $2637 r0 *1 234.4,301.7 NMOS
XM$2637 BL10 WL10 \$I4456 VSS NMOS L=1u W=3.4u AS=10.88p AD=6.46p PS=13.2u
+ PD=7.2u
* device instance $2638 r0 *1 239.2,301.7 NMOS
XM$2638 \$I4456 \$I4457 VSS VSS NMOS L=1u W=3.4u AS=6.46p AD=6.46p PS=7.2u
+ PD=7.2u
* device instance $2639 r0 *1 244,301.7 NMOS
XM$2639 VSS \$I4456 \$I4457 VSS NMOS L=1u W=3.4u AS=6.46p AD=6.46p PS=7.2u
+ PD=7.2u
* device instance $2640 r0 *1 248.8,301.7 NMOS
XM$2640 \$I4457 WL10 BLB10 VSS NMOS L=1u W=3.4u AS=6.46p AD=10.88p PS=7.2u
+ PD=13.2u
* device instance $2641 r0 *1 262.4,322.1 PMOS
XM$2641 \$I4458 \$I4459 VDD VDD PMOS L=1u W=3.4u AS=10.88p AD=6.46p PS=13.2u
+ PD=7.2u
* device instance $2642 r0 *1 267.2,322.1 PMOS
XM$2642 VDD \$I4458 \$I4459 VDD PMOS L=1u W=3.4u AS=6.46p AD=10.88p PS=7.2u
+ PD=13.2u
* device instance $2643 r0 *1 257.6,301.7 NMOS
XM$2643 BL11 WL10 \$I4458 VSS NMOS L=1u W=3.4u AS=10.88p AD=6.46p PS=13.2u
+ PD=7.2u
* device instance $2644 r0 *1 262.4,301.7 NMOS
XM$2644 \$I4458 \$I4459 VSS VSS NMOS L=1u W=3.4u AS=6.46p AD=6.46p PS=7.2u
+ PD=7.2u
* device instance $2645 r0 *1 267.2,301.7 NMOS
XM$2645 VSS \$I4458 \$I4459 VSS NMOS L=1u W=3.4u AS=6.46p AD=6.46p PS=7.2u
+ PD=7.2u
* device instance $2646 r0 *1 272,301.7 NMOS
XM$2646 \$I4459 WL10 BLB11 VSS NMOS L=1u W=3.4u AS=6.46p AD=10.88p PS=7.2u
+ PD=13.2u
* device instance $2647 r0 *1 285.6,322.1 PMOS
XM$2647 \$I4460 \$I4461 VDD VDD PMOS L=1u W=3.4u AS=10.88p AD=6.46p PS=13.2u
+ PD=7.2u
* device instance $2648 r0 *1 290.4,322.1 PMOS
XM$2648 VDD \$I4460 \$I4461 VDD PMOS L=1u W=3.4u AS=6.46p AD=10.88p PS=7.2u
+ PD=13.2u
* device instance $2649 r0 *1 280.8,301.7 NMOS
XM$2649 BL12 WL10 \$I4460 VSS NMOS L=1u W=3.4u AS=10.88p AD=6.46p PS=13.2u
+ PD=7.2u
* device instance $2650 r0 *1 285.6,301.7 NMOS
XM$2650 \$I4460 \$I4461 VSS VSS NMOS L=1u W=3.4u AS=6.46p AD=6.46p PS=7.2u
+ PD=7.2u
* device instance $2651 r0 *1 290.4,301.7 NMOS
XM$2651 VSS \$I4460 \$I4461 VSS NMOS L=1u W=3.4u AS=6.46p AD=6.46p PS=7.2u
+ PD=7.2u
* device instance $2652 r0 *1 295.2,301.7 NMOS
XM$2652 \$I4461 WL10 BLB12 VSS NMOS L=1u W=3.4u AS=6.46p AD=10.88p PS=7.2u
+ PD=13.2u
* device instance $2653 r0 *1 308.8,322.1 PMOS
XM$2653 \$I4462 \$I4463 VDD VDD PMOS L=1u W=3.4u AS=10.88p AD=6.46p PS=13.2u
+ PD=7.2u
* device instance $2654 r0 *1 313.6,322.1 PMOS
XM$2654 VDD \$I4462 \$I4463 VDD PMOS L=1u W=3.4u AS=6.46p AD=10.88p PS=7.2u
+ PD=13.2u
* device instance $2655 r0 *1 304,301.7 NMOS
XM$2655 BL13 WL10 \$I4462 VSS NMOS L=1u W=3.4u AS=10.88p AD=6.46p PS=13.2u
+ PD=7.2u
* device instance $2656 r0 *1 308.8,301.7 NMOS
XM$2656 \$I4462 \$I4463 VSS VSS NMOS L=1u W=3.4u AS=6.46p AD=6.46p PS=7.2u
+ PD=7.2u
* device instance $2657 r0 *1 313.6,301.7 NMOS
XM$2657 VSS \$I4462 \$I4463 VSS NMOS L=1u W=3.4u AS=6.46p AD=6.46p PS=7.2u
+ PD=7.2u
* device instance $2658 r0 *1 318.4,301.7 NMOS
XM$2658 \$I4463 WL10 BLB13 VSS NMOS L=1u W=3.4u AS=6.46p AD=10.88p PS=7.2u
+ PD=13.2u
* device instance $2659 r0 *1 216,262.9 PMOS
XM$2659 \$I4464 \$I4465 VDD VDD PMOS L=1u W=3.4u AS=10.88p AD=6.46p PS=13.2u
+ PD=7.2u
* device instance $2660 r0 *1 220.8,262.9 PMOS
XM$2660 VDD \$I4464 \$I4465 VDD PMOS L=1u W=3.4u AS=6.46p AD=10.88p PS=7.2u
+ PD=13.2u
* device instance $2661 r0 *1 211.2,242.5 NMOS
XM$2661 BL9 WL8 \$I4464 VSS NMOS L=1u W=3.4u AS=10.88p AD=6.46p PS=13.2u PD=7.2u
* device instance $2662 r0 *1 216,242.5 NMOS
XM$2662 \$I4464 \$I4465 VSS VSS NMOS L=1u W=3.4u AS=6.46p AD=6.46p PS=7.2u
+ PD=7.2u
* device instance $2663 r0 *1 220.8,242.5 NMOS
XM$2663 VSS \$I4464 \$I4465 VSS NMOS L=1u W=3.4u AS=6.46p AD=6.46p PS=7.2u
+ PD=7.2u
* device instance $2664 r0 *1 225.6,242.5 NMOS
XM$2664 \$I4465 WL8 BLB9 VSS NMOS L=1u W=3.4u AS=6.46p AD=10.88p PS=7.2u
+ PD=13.2u
* device instance $2665 r0 *1 239.2,262.9 PMOS
XM$2665 \$I4466 \$I4467 VDD VDD PMOS L=1u W=3.4u AS=10.88p AD=6.46p PS=13.2u
+ PD=7.2u
* device instance $2666 r0 *1 244,262.9 PMOS
XM$2666 VDD \$I4466 \$I4467 VDD PMOS L=1u W=3.4u AS=6.46p AD=10.88p PS=7.2u
+ PD=13.2u
* device instance $2667 r0 *1 234.4,242.5 NMOS
XM$2667 BL10 WL8 \$I4466 VSS NMOS L=1u W=3.4u AS=10.88p AD=6.46p PS=13.2u
+ PD=7.2u
* device instance $2668 r0 *1 239.2,242.5 NMOS
XM$2668 \$I4466 \$I4467 VSS VSS NMOS L=1u W=3.4u AS=6.46p AD=6.46p PS=7.2u
+ PD=7.2u
* device instance $2669 r0 *1 244,242.5 NMOS
XM$2669 VSS \$I4466 \$I4467 VSS NMOS L=1u W=3.4u AS=6.46p AD=6.46p PS=7.2u
+ PD=7.2u
* device instance $2670 r0 *1 248.8,242.5 NMOS
XM$2670 \$I4467 WL8 BLB10 VSS NMOS L=1u W=3.4u AS=6.46p AD=10.88p PS=7.2u
+ PD=13.2u
* device instance $2671 r0 *1 262.4,262.9 PMOS
XM$2671 \$I4468 \$I4469 VDD VDD PMOS L=1u W=3.4u AS=10.88p AD=6.46p PS=13.2u
+ PD=7.2u
* device instance $2672 r0 *1 267.2,262.9 PMOS
XM$2672 VDD \$I4468 \$I4469 VDD PMOS L=1u W=3.4u AS=6.46p AD=10.88p PS=7.2u
+ PD=13.2u
* device instance $2673 r0 *1 257.6,242.5 NMOS
XM$2673 BL11 WL8 \$I4468 VSS NMOS L=1u W=3.4u AS=10.88p AD=6.46p PS=13.2u
+ PD=7.2u
* device instance $2674 r0 *1 262.4,242.5 NMOS
XM$2674 \$I4468 \$I4469 VSS VSS NMOS L=1u W=3.4u AS=6.46p AD=6.46p PS=7.2u
+ PD=7.2u
* device instance $2675 r0 *1 267.2,242.5 NMOS
XM$2675 VSS \$I4468 \$I4469 VSS NMOS L=1u W=3.4u AS=6.46p AD=6.46p PS=7.2u
+ PD=7.2u
* device instance $2676 r0 *1 272,242.5 NMOS
XM$2676 \$I4469 WL8 BLB11 VSS NMOS L=1u W=3.4u AS=6.46p AD=10.88p PS=7.2u
+ PD=13.2u
* device instance $2677 r0 *1 285.6,262.9 PMOS
XM$2677 \$I4470 \$I4471 VDD VDD PMOS L=1u W=3.4u AS=10.88p AD=6.46p PS=13.2u
+ PD=7.2u
* device instance $2678 r0 *1 290.4,262.9 PMOS
XM$2678 VDD \$I4470 \$I4471 VDD PMOS L=1u W=3.4u AS=6.46p AD=10.88p PS=7.2u
+ PD=13.2u
* device instance $2679 r0 *1 280.8,242.5 NMOS
XM$2679 BL12 WL8 \$I4470 VSS NMOS L=1u W=3.4u AS=10.88p AD=6.46p PS=13.2u
+ PD=7.2u
* device instance $2680 r0 *1 285.6,242.5 NMOS
XM$2680 \$I4470 \$I4471 VSS VSS NMOS L=1u W=3.4u AS=6.46p AD=6.46p PS=7.2u
+ PD=7.2u
* device instance $2681 r0 *1 290.4,242.5 NMOS
XM$2681 VSS \$I4470 \$I4471 VSS NMOS L=1u W=3.4u AS=6.46p AD=6.46p PS=7.2u
+ PD=7.2u
* device instance $2682 r0 *1 295.2,242.5 NMOS
XM$2682 \$I4471 WL8 BLB12 VSS NMOS L=1u W=3.4u AS=6.46p AD=10.88p PS=7.2u
+ PD=13.2u
* device instance $2683 r0 *1 308.8,262.9 PMOS
XM$2683 \$I4472 \$I4473 VDD VDD PMOS L=1u W=3.4u AS=10.88p AD=6.46p PS=13.2u
+ PD=7.2u
* device instance $2684 r0 *1 313.6,262.9 PMOS
XM$2684 VDD \$I4472 \$I4473 VDD PMOS L=1u W=3.4u AS=6.46p AD=10.88p PS=7.2u
+ PD=13.2u
* device instance $2685 r0 *1 304,242.5 NMOS
XM$2685 BL13 WL8 \$I4472 VSS NMOS L=1u W=3.4u AS=10.88p AD=6.46p PS=13.2u
+ PD=7.2u
* device instance $2686 r0 *1 308.8,242.5 NMOS
XM$2686 \$I4472 \$I4473 VSS VSS NMOS L=1u W=3.4u AS=6.46p AD=6.46p PS=7.2u
+ PD=7.2u
* device instance $2687 r0 *1 313.6,242.5 NMOS
XM$2687 VSS \$I4472 \$I4473 VSS NMOS L=1u W=3.4u AS=6.46p AD=6.46p PS=7.2u
+ PD=7.2u
* device instance $2688 r0 *1 318.4,242.5 NMOS
XM$2688 \$I4473 WL8 BLB13 VSS NMOS L=1u W=3.4u AS=6.46p AD=10.88p PS=7.2u
+ PD=13.2u
* device instance $2689 r0 *1 355.2,322.1 PMOS
XM$2689 \$I4474 \$I4475 VDD VDD PMOS L=1u W=3.4u AS=10.88p AD=6.46p PS=13.2u
+ PD=7.2u
* device instance $2690 r0 *1 360,322.1 PMOS
XM$2690 VDD \$I4474 \$I4475 VDD PMOS L=1u W=3.4u AS=6.46p AD=10.88p PS=7.2u
+ PD=13.2u
* device instance $2691 r0 *1 350.4,301.7 NMOS
XM$2691 BL15 WL10 \$I4474 VSS NMOS L=1u W=3.4u AS=10.88p AD=6.46p PS=13.2u
+ PD=7.2u
* device instance $2692 r0 *1 355.2,301.7 NMOS
XM$2692 \$I4474 \$I4475 VSS VSS NMOS L=1u W=3.4u AS=6.46p AD=6.46p PS=7.2u
+ PD=7.2u
* device instance $2693 r0 *1 360,301.7 NMOS
XM$2693 VSS \$I4474 \$I4475 VSS NMOS L=1u W=3.4u AS=6.46p AD=6.46p PS=7.2u
+ PD=7.2u
* device instance $2694 r0 *1 364.8,301.7 NMOS
XM$2694 \$I4475 WL10 BLB15 VSS NMOS L=1u W=3.4u AS=6.46p AD=10.88p PS=7.2u
+ PD=13.2u
* device instance $2695 r0 *1 30.4,381.3 PMOS
XM$2695 \$I4476 \$I4477 VDD VDD PMOS L=1u W=3.4u AS=10.88p AD=6.46p PS=13.2u
+ PD=7.2u
* device instance $2696 r0 *1 35.2,381.3 PMOS
XM$2696 VDD \$I4476 \$I4477 VDD PMOS L=1u W=3.4u AS=6.46p AD=10.88p PS=7.2u
+ PD=13.2u
* device instance $2697 r0 *1 25.6,360.9 NMOS
XM$2697 BL1 WL12 \$I4476 VSS NMOS L=1u W=3.4u AS=10.88p AD=6.46p PS=13.2u
+ PD=7.2u
* device instance $2698 r0 *1 30.4,360.9 NMOS
XM$2698 \$I4476 \$I4477 VSS VSS NMOS L=1u W=3.4u AS=6.46p AD=6.46p PS=7.2u
+ PD=7.2u
* device instance $2699 r0 *1 35.2,360.9 NMOS
XM$2699 VSS \$I4476 \$I4477 VSS NMOS L=1u W=3.4u AS=6.46p AD=6.46p PS=7.2u
+ PD=7.2u
* device instance $2700 r0 *1 40,360.9 NMOS
XM$2700 \$I4477 WL12 BLB1 VSS NMOS L=1u W=3.4u AS=6.46p AD=10.88p PS=7.2u
+ PD=13.2u
* device instance $2701 r0 *1 53.6,381.3 PMOS
XM$2701 \$I4478 \$I4479 VDD VDD PMOS L=1u W=3.4u AS=10.88p AD=6.46p PS=13.2u
+ PD=7.2u
* device instance $2702 r0 *1 58.4,381.3 PMOS
XM$2702 VDD \$I4478 \$I4479 VDD PMOS L=1u W=3.4u AS=6.46p AD=10.88p PS=7.2u
+ PD=13.2u
* device instance $2703 r0 *1 48.8,360.9 NMOS
XM$2703 BL2 WL12 \$I4478 VSS NMOS L=1u W=3.4u AS=10.88p AD=6.46p PS=13.2u
+ PD=7.2u
* device instance $2704 r0 *1 53.6,360.9 NMOS
XM$2704 \$I4478 \$I4479 VSS VSS NMOS L=1u W=3.4u AS=6.46p AD=6.46p PS=7.2u
+ PD=7.2u
* device instance $2705 r0 *1 58.4,360.9 NMOS
XM$2705 VSS \$I4478 \$I4479 VSS NMOS L=1u W=3.4u AS=6.46p AD=6.46p PS=7.2u
+ PD=7.2u
* device instance $2706 r0 *1 63.2,360.9 NMOS
XM$2706 \$I4479 WL12 BLB2 VSS NMOS L=1u W=3.4u AS=6.46p AD=10.88p PS=7.2u
+ PD=13.2u
* device instance $2707 r0 *1 76.8,381.3 PMOS
XM$2707 \$I4480 \$I4481 VDD VDD PMOS L=1u W=3.4u AS=10.88p AD=6.46p PS=13.2u
+ PD=7.2u
* device instance $2708 r0 *1 81.6,381.3 PMOS
XM$2708 VDD \$I4480 \$I4481 VDD PMOS L=1u W=3.4u AS=6.46p AD=10.88p PS=7.2u
+ PD=13.2u
* device instance $2709 r0 *1 72,360.9 NMOS
XM$2709 BL3 WL12 \$I4480 VSS NMOS L=1u W=3.4u AS=10.88p AD=6.46p PS=13.2u
+ PD=7.2u
* device instance $2710 r0 *1 76.8,360.9 NMOS
XM$2710 \$I4480 \$I4481 VSS VSS NMOS L=1u W=3.4u AS=6.46p AD=6.46p PS=7.2u
+ PD=7.2u
* device instance $2711 r0 *1 81.6,360.9 NMOS
XM$2711 VSS \$I4480 \$I4481 VSS NMOS L=1u W=3.4u AS=6.46p AD=6.46p PS=7.2u
+ PD=7.2u
* device instance $2712 r0 *1 86.4,360.9 NMOS
XM$2712 \$I4481 WL12 BLB3 VSS NMOS L=1u W=3.4u AS=6.46p AD=10.88p PS=7.2u
+ PD=13.2u
* device instance $2713 r0 *1 100,381.3 PMOS
XM$2713 \$I4482 \$I4483 VDD VDD PMOS L=1u W=3.4u AS=10.88p AD=6.46p PS=13.2u
+ PD=7.2u
* device instance $2714 r0 *1 104.8,381.3 PMOS
XM$2714 VDD \$I4482 \$I4483 VDD PMOS L=1u W=3.4u AS=6.46p AD=10.88p PS=7.2u
+ PD=13.2u
* device instance $2715 r0 *1 95.2,360.9 NMOS
XM$2715 BL4 WL12 \$I4482 VSS NMOS L=1u W=3.4u AS=10.88p AD=6.46p PS=13.2u
+ PD=7.2u
* device instance $2716 r0 *1 100,360.9 NMOS
XM$2716 \$I4482 \$I4483 VSS VSS NMOS L=1u W=3.4u AS=6.46p AD=6.46p PS=7.2u
+ PD=7.2u
* device instance $2717 r0 *1 104.8,360.9 NMOS
XM$2717 VSS \$I4482 \$I4483 VSS NMOS L=1u W=3.4u AS=6.46p AD=6.46p PS=7.2u
+ PD=7.2u
* device instance $2718 r0 *1 109.6,360.9 NMOS
XM$2718 \$I4483 WL12 BLB4 VSS NMOS L=1u W=3.4u AS=6.46p AD=10.88p PS=7.2u
+ PD=13.2u
* device instance $2719 r0 *1 123.2,381.3 PMOS
XM$2719 \$I4484 \$I4485 VDD VDD PMOS L=1u W=3.4u AS=10.88p AD=6.46p PS=13.2u
+ PD=7.2u
* device instance $2720 r0 *1 128,381.3 PMOS
XM$2720 VDD \$I4484 \$I4485 VDD PMOS L=1u W=3.4u AS=6.46p AD=10.88p PS=7.2u
+ PD=13.2u
* device instance $2721 r0 *1 118.4,360.9 NMOS
XM$2721 BL5 WL12 \$I4484 VSS NMOS L=1u W=3.4u AS=10.88p AD=6.46p PS=13.2u
+ PD=7.2u
* device instance $2722 r0 *1 123.2,360.9 NMOS
XM$2722 \$I4484 \$I4485 VSS VSS NMOS L=1u W=3.4u AS=6.46p AD=6.46p PS=7.2u
+ PD=7.2u
* device instance $2723 r0 *1 128,360.9 NMOS
XM$2723 VSS \$I4484 \$I4485 VSS NMOS L=1u W=3.4u AS=6.46p AD=6.46p PS=7.2u
+ PD=7.2u
* device instance $2724 r0 *1 132.8,360.9 NMOS
XM$2724 \$I4485 WL12 BLB5 VSS NMOS L=1u W=3.4u AS=6.46p AD=10.88p PS=7.2u
+ PD=13.2u
* device instance $2725 r0 *1 146.4,381.3 PMOS
XM$2725 \$I4486 \$I4487 VDD VDD PMOS L=1u W=3.4u AS=10.88p AD=6.46p PS=13.2u
+ PD=7.2u
* device instance $2726 r0 *1 151.2,381.3 PMOS
XM$2726 VDD \$I4486 \$I4487 VDD PMOS L=1u W=3.4u AS=6.46p AD=10.88p PS=7.2u
+ PD=13.2u
* device instance $2727 r0 *1 141.6,360.9 NMOS
XM$2727 BL6 WL12 \$I4486 VSS NMOS L=1u W=3.4u AS=10.88p AD=6.46p PS=13.2u
+ PD=7.2u
* device instance $2728 r0 *1 146.4,360.9 NMOS
XM$2728 \$I4486 \$I4487 VSS VSS NMOS L=1u W=3.4u AS=6.46p AD=6.46p PS=7.2u
+ PD=7.2u
* device instance $2729 r0 *1 151.2,360.9 NMOS
XM$2729 VSS \$I4486 \$I4487 VSS NMOS L=1u W=3.4u AS=6.46p AD=6.46p PS=7.2u
+ PD=7.2u
* device instance $2730 r0 *1 156,360.9 NMOS
XM$2730 \$I4487 WL12 BLB6 VSS NMOS L=1u W=3.4u AS=6.46p AD=10.88p PS=7.2u
+ PD=13.2u
* device instance $2731 r0 *1 169.6,381.3 PMOS
XM$2731 \$I4488 \$I4489 VDD VDD PMOS L=1u W=3.4u AS=10.88p AD=6.46p PS=13.2u
+ PD=7.2u
* device instance $2732 r0 *1 174.4,381.3 PMOS
XM$2732 VDD \$I4488 \$I4489 VDD PMOS L=1u W=3.4u AS=6.46p AD=10.88p PS=7.2u
+ PD=13.2u
* device instance $2733 r0 *1 164.8,360.9 NMOS
XM$2733 BL7 WL12 \$I4488 VSS NMOS L=1u W=3.4u AS=10.88p AD=6.46p PS=13.2u
+ PD=7.2u
* device instance $2734 r0 *1 169.6,360.9 NMOS
XM$2734 \$I4488 \$I4489 VSS VSS NMOS L=1u W=3.4u AS=6.46p AD=6.46p PS=7.2u
+ PD=7.2u
* device instance $2735 r0 *1 174.4,360.9 NMOS
XM$2735 VSS \$I4488 \$I4489 VSS NMOS L=1u W=3.4u AS=6.46p AD=6.46p PS=7.2u
+ PD=7.2u
* device instance $2736 r0 *1 179.2,360.9 NMOS
XM$2736 \$I4489 WL12 BLB7 VSS NMOS L=1u W=3.4u AS=6.46p AD=10.88p PS=7.2u
+ PD=13.2u
* device instance $2737 r0 *1 7.2,381.3 PMOS
XM$2737 \$I4490 \$I4491 VDD VDD PMOS L=1u W=3.4u AS=10.88p AD=6.46p PS=13.2u
+ PD=7.2u
* device instance $2738 r0 *1 12,381.3 PMOS
XM$2738 VDD \$I4490 \$I4491 VDD PMOS L=1u W=3.4u AS=6.46p AD=10.88p PS=7.2u
+ PD=13.2u
* device instance $2739 r0 *1 2.4,360.9 NMOS
XM$2739 BL0 WL12 \$I4490 VSS NMOS L=1u W=3.4u AS=10.88p AD=6.46p PS=13.2u
+ PD=7.2u
* device instance $2740 r0 *1 7.2,360.9 NMOS
XM$2740 \$I4490 \$I4491 VSS VSS NMOS L=1u W=3.4u AS=6.46p AD=6.46p PS=7.2u
+ PD=7.2u
* device instance $2741 r0 *1 12,360.9 NMOS
XM$2741 VSS \$I4490 \$I4491 VSS NMOS L=1u W=3.4u AS=6.46p AD=6.46p PS=7.2u
+ PD=7.2u
* device instance $2742 r0 *1 16.8,360.9 NMOS
XM$2742 \$I4491 WL12 BLB0 VSS NMOS L=1u W=3.4u AS=6.46p AD=10.88p PS=7.2u
+ PD=13.2u
* device instance $2743 r0 *1 7.2,440.5 PMOS
XM$2743 \$I4492 \$I4493 VDD VDD PMOS L=1u W=3.4u AS=10.88p AD=6.46p PS=13.2u
+ PD=7.2u
* device instance $2744 r0 *1 12,440.5 PMOS
XM$2744 VDD \$I4492 \$I4493 VDD PMOS L=1u W=3.4u AS=6.46p AD=10.88p PS=7.2u
+ PD=13.2u
* device instance $2745 r0 *1 2.4,420.1 NMOS
XM$2745 BL0 WL14 \$I4492 VSS NMOS L=1u W=3.4u AS=10.88p AD=6.46p PS=13.2u
+ PD=7.2u
* device instance $2746 r0 *1 7.2,420.1 NMOS
XM$2746 \$I4492 \$I4493 VSS VSS NMOS L=1u W=3.4u AS=6.46p AD=6.46p PS=7.2u
+ PD=7.2u
* device instance $2747 r0 *1 12,420.1 NMOS
XM$2747 VSS \$I4492 \$I4493 VSS NMOS L=1u W=3.4u AS=6.46p AD=6.46p PS=7.2u
+ PD=7.2u
* device instance $2748 r0 *1 16.8,420.1 NMOS
XM$2748 \$I4493 WL14 BLB0 VSS NMOS L=1u W=3.4u AS=6.46p AD=10.88p PS=7.2u
+ PD=13.2u
* device instance $2749 r0 *1 30.4,440.5 PMOS
XM$2749 \$I4494 \$I4495 VDD VDD PMOS L=1u W=3.4u AS=10.88p AD=6.46p PS=13.2u
+ PD=7.2u
* device instance $2750 r0 *1 35.2,440.5 PMOS
XM$2750 VDD \$I4494 \$I4495 VDD PMOS L=1u W=3.4u AS=6.46p AD=10.88p PS=7.2u
+ PD=13.2u
* device instance $2751 r0 *1 25.6,420.1 NMOS
XM$2751 BL1 WL14 \$I4494 VSS NMOS L=1u W=3.4u AS=10.88p AD=6.46p PS=13.2u
+ PD=7.2u
* device instance $2752 r0 *1 30.4,420.1 NMOS
XM$2752 \$I4494 \$I4495 VSS VSS NMOS L=1u W=3.4u AS=6.46p AD=6.46p PS=7.2u
+ PD=7.2u
* device instance $2753 r0 *1 35.2,420.1 NMOS
XM$2753 VSS \$I4494 \$I4495 VSS NMOS L=1u W=3.4u AS=6.46p AD=6.46p PS=7.2u
+ PD=7.2u
* device instance $2754 r0 *1 40,420.1 NMOS
XM$2754 \$I4495 WL14 BLB1 VSS NMOS L=1u W=3.4u AS=6.46p AD=10.88p PS=7.2u
+ PD=13.2u
* device instance $2755 r0 *1 30.4,322.1 PMOS
XM$2755 \$I4496 \$I4497 VDD VDD PMOS L=1u W=3.4u AS=10.88p AD=6.46p PS=13.2u
+ PD=7.2u
* device instance $2756 r0 *1 35.2,322.1 PMOS
XM$2756 VDD \$I4496 \$I4497 VDD PMOS L=1u W=3.4u AS=6.46p AD=10.88p PS=7.2u
+ PD=13.2u
* device instance $2757 r0 *1 25.6,301.7 NMOS
XM$2757 BL1 WL10 \$I4496 VSS NMOS L=1u W=3.4u AS=10.88p AD=6.46p PS=13.2u
+ PD=7.2u
* device instance $2758 r0 *1 30.4,301.7 NMOS
XM$2758 \$I4496 \$I4497 VSS VSS NMOS L=1u W=3.4u AS=6.46p AD=6.46p PS=7.2u
+ PD=7.2u
* device instance $2759 r0 *1 35.2,301.7 NMOS
XM$2759 VSS \$I4496 \$I4497 VSS NMOS L=1u W=3.4u AS=6.46p AD=6.46p PS=7.2u
+ PD=7.2u
* device instance $2760 r0 *1 40,301.7 NMOS
XM$2760 \$I4497 WL10 BLB1 VSS NMOS L=1u W=3.4u AS=6.46p AD=10.88p PS=7.2u
+ PD=13.2u
* device instance $2761 r0 *1 76.8,440.5 PMOS
XM$2761 \$I4498 \$I4499 VDD VDD PMOS L=1u W=3.4u AS=10.88p AD=6.46p PS=13.2u
+ PD=7.2u
* device instance $2762 r0 *1 81.6,440.5 PMOS
XM$2762 VDD \$I4498 \$I4499 VDD PMOS L=1u W=3.4u AS=6.46p AD=10.88p PS=7.2u
+ PD=13.2u
* device instance $2763 r0 *1 72,420.1 NMOS
XM$2763 BL3 WL14 \$I4498 VSS NMOS L=1u W=3.4u AS=10.88p AD=6.46p PS=13.2u
+ PD=7.2u
* device instance $2764 r0 *1 76.8,420.1 NMOS
XM$2764 \$I4498 \$I4499 VSS VSS NMOS L=1u W=3.4u AS=6.46p AD=6.46p PS=7.2u
+ PD=7.2u
* device instance $2765 r0 *1 81.6,420.1 NMOS
XM$2765 VSS \$I4498 \$I4499 VSS NMOS L=1u W=3.4u AS=6.46p AD=6.46p PS=7.2u
+ PD=7.2u
* device instance $2766 r0 *1 86.4,420.1 NMOS
XM$2766 \$I4499 WL14 BLB3 VSS NMOS L=1u W=3.4u AS=6.46p AD=10.88p PS=7.2u
+ PD=13.2u
* device instance $2767 r0 *1 100,440.5 PMOS
XM$2767 \$I4500 \$I4501 VDD VDD PMOS L=1u W=3.4u AS=10.88p AD=6.46p PS=13.2u
+ PD=7.2u
* device instance $2768 r0 *1 104.8,440.5 PMOS
XM$2768 VDD \$I4500 \$I4501 VDD PMOS L=1u W=3.4u AS=6.46p AD=10.88p PS=7.2u
+ PD=13.2u
* device instance $2769 r0 *1 95.2,420.1 NMOS
XM$2769 BL4 WL14 \$I4500 VSS NMOS L=1u W=3.4u AS=10.88p AD=6.46p PS=13.2u
+ PD=7.2u
* device instance $2770 r0 *1 100,420.1 NMOS
XM$2770 \$I4500 \$I4501 VSS VSS NMOS L=1u W=3.4u AS=6.46p AD=6.46p PS=7.2u
+ PD=7.2u
* device instance $2771 r0 *1 104.8,420.1 NMOS
XM$2771 VSS \$I4500 \$I4501 VSS NMOS L=1u W=3.4u AS=6.46p AD=6.46p PS=7.2u
+ PD=7.2u
* device instance $2772 r0 *1 109.6,420.1 NMOS
XM$2772 \$I4501 WL14 BLB4 VSS NMOS L=1u W=3.4u AS=6.46p AD=10.88p PS=7.2u
+ PD=13.2u
* device instance $2773 r0 *1 123.2,440.5 PMOS
XM$2773 \$I4502 \$I4503 VDD VDD PMOS L=1u W=3.4u AS=10.88p AD=6.46p PS=13.2u
+ PD=7.2u
* device instance $2774 r0 *1 128,440.5 PMOS
XM$2774 VDD \$I4502 \$I4503 VDD PMOS L=1u W=3.4u AS=6.46p AD=10.88p PS=7.2u
+ PD=13.2u
* device instance $2775 r0 *1 118.4,420.1 NMOS
XM$2775 BL5 WL14 \$I4502 VSS NMOS L=1u W=3.4u AS=10.88p AD=6.46p PS=13.2u
+ PD=7.2u
* device instance $2776 r0 *1 123.2,420.1 NMOS
XM$2776 \$I4502 \$I4503 VSS VSS NMOS L=1u W=3.4u AS=6.46p AD=6.46p PS=7.2u
+ PD=7.2u
* device instance $2777 r0 *1 128,420.1 NMOS
XM$2777 VSS \$I4502 \$I4503 VSS NMOS L=1u W=3.4u AS=6.46p AD=6.46p PS=7.2u
+ PD=7.2u
* device instance $2778 r0 *1 132.8,420.1 NMOS
XM$2778 \$I4503 WL14 BLB5 VSS NMOS L=1u W=3.4u AS=6.46p AD=10.88p PS=7.2u
+ PD=13.2u
* device instance $2779 r0 *1 53.6,322.1 PMOS
XM$2779 \$I4504 \$I4505 VDD VDD PMOS L=1u W=3.4u AS=10.88p AD=6.46p PS=13.2u
+ PD=7.2u
* device instance $2780 r0 *1 58.4,322.1 PMOS
XM$2780 VDD \$I4504 \$I4505 VDD PMOS L=1u W=3.4u AS=6.46p AD=10.88p PS=7.2u
+ PD=13.2u
* device instance $2781 r0 *1 48.8,301.7 NMOS
XM$2781 BL2 WL10 \$I4504 VSS NMOS L=1u W=3.4u AS=10.88p AD=6.46p PS=13.2u
+ PD=7.2u
* device instance $2782 r0 *1 53.6,301.7 NMOS
XM$2782 \$I4504 \$I4505 VSS VSS NMOS L=1u W=3.4u AS=6.46p AD=6.46p PS=7.2u
+ PD=7.2u
* device instance $2783 r0 *1 58.4,301.7 NMOS
XM$2783 VSS \$I4504 \$I4505 VSS NMOS L=1u W=3.4u AS=6.46p AD=6.46p PS=7.2u
+ PD=7.2u
* device instance $2784 r0 *1 63.2,301.7 NMOS
XM$2784 \$I4505 WL10 BLB2 VSS NMOS L=1u W=3.4u AS=6.46p AD=10.88p PS=7.2u
+ PD=13.2u
* device instance $2785 r0 *1 76.8,322.1 PMOS
XM$2785 \$I4506 \$I4507 VDD VDD PMOS L=1u W=3.4u AS=10.88p AD=6.46p PS=13.2u
+ PD=7.2u
* device instance $2786 r0 *1 81.6,322.1 PMOS
XM$2786 VDD \$I4506 \$I4507 VDD PMOS L=1u W=3.4u AS=6.46p AD=10.88p PS=7.2u
+ PD=13.2u
* device instance $2787 r0 *1 72,301.7 NMOS
XM$2787 BL3 WL10 \$I4506 VSS NMOS L=1u W=3.4u AS=10.88p AD=6.46p PS=13.2u
+ PD=7.2u
* device instance $2788 r0 *1 76.8,301.7 NMOS
XM$2788 \$I4506 \$I4507 VSS VSS NMOS L=1u W=3.4u AS=6.46p AD=6.46p PS=7.2u
+ PD=7.2u
* device instance $2789 r0 *1 81.6,301.7 NMOS
XM$2789 VSS \$I4506 \$I4507 VSS NMOS L=1u W=3.4u AS=6.46p AD=6.46p PS=7.2u
+ PD=7.2u
* device instance $2790 r0 *1 86.4,301.7 NMOS
XM$2790 \$I4507 WL10 BLB3 VSS NMOS L=1u W=3.4u AS=6.46p AD=10.88p PS=7.2u
+ PD=13.2u
* device instance $2791 r0 *1 100,322.1 PMOS
XM$2791 \$I4508 \$I4509 VDD VDD PMOS L=1u W=3.4u AS=10.88p AD=6.46p PS=13.2u
+ PD=7.2u
* device instance $2792 r0 *1 104.8,322.1 PMOS
XM$2792 VDD \$I4508 \$I4509 VDD PMOS L=1u W=3.4u AS=6.46p AD=10.88p PS=7.2u
+ PD=13.2u
* device instance $2793 r0 *1 95.2,301.7 NMOS
XM$2793 BL4 WL10 \$I4508 VSS NMOS L=1u W=3.4u AS=10.88p AD=6.46p PS=13.2u
+ PD=7.2u
* device instance $2794 r0 *1 100,301.7 NMOS
XM$2794 \$I4508 \$I4509 VSS VSS NMOS L=1u W=3.4u AS=6.46p AD=6.46p PS=7.2u
+ PD=7.2u
* device instance $2795 r0 *1 104.8,301.7 NMOS
XM$2795 VSS \$I4508 \$I4509 VSS NMOS L=1u W=3.4u AS=6.46p AD=6.46p PS=7.2u
+ PD=7.2u
* device instance $2796 r0 *1 109.6,301.7 NMOS
XM$2796 \$I4509 WL10 BLB4 VSS NMOS L=1u W=3.4u AS=6.46p AD=10.88p PS=7.2u
+ PD=13.2u
* device instance $2797 r0 *1 123.2,322.1 PMOS
XM$2797 \$I4510 \$I4511 VDD VDD PMOS L=1u W=3.4u AS=10.88p AD=6.46p PS=13.2u
+ PD=7.2u
* device instance $2798 r0 *1 128,322.1 PMOS
XM$2798 VDD \$I4510 \$I4511 VDD PMOS L=1u W=3.4u AS=6.46p AD=10.88p PS=7.2u
+ PD=13.2u
* device instance $2799 r0 *1 118.4,301.7 NMOS
XM$2799 BL5 WL10 \$I4510 VSS NMOS L=1u W=3.4u AS=10.88p AD=6.46p PS=13.2u
+ PD=7.2u
* device instance $2800 r0 *1 123.2,301.7 NMOS
XM$2800 \$I4510 \$I4511 VSS VSS NMOS L=1u W=3.4u AS=6.46p AD=6.46p PS=7.2u
+ PD=7.2u
* device instance $2801 r0 *1 128,301.7 NMOS
XM$2801 VSS \$I4510 \$I4511 VSS NMOS L=1u W=3.4u AS=6.46p AD=6.46p PS=7.2u
+ PD=7.2u
* device instance $2802 r0 *1 132.8,301.7 NMOS
XM$2802 \$I4511 WL10 BLB5 VSS NMOS L=1u W=3.4u AS=6.46p AD=10.88p PS=7.2u
+ PD=13.2u
* device instance $2803 r0 *1 146.4,322.1 PMOS
XM$2803 \$I4512 \$I4513 VDD VDD PMOS L=1u W=3.4u AS=10.88p AD=6.46p PS=13.2u
+ PD=7.2u
* device instance $2804 r0 *1 151.2,322.1 PMOS
XM$2804 VDD \$I4512 \$I4513 VDD PMOS L=1u W=3.4u AS=6.46p AD=10.88p PS=7.2u
+ PD=13.2u
* device instance $2805 r0 *1 141.6,301.7 NMOS
XM$2805 BL6 WL10 \$I4512 VSS NMOS L=1u W=3.4u AS=10.88p AD=6.46p PS=13.2u
+ PD=7.2u
* device instance $2806 r0 *1 146.4,301.7 NMOS
XM$2806 \$I4512 \$I4513 VSS VSS NMOS L=1u W=3.4u AS=6.46p AD=6.46p PS=7.2u
+ PD=7.2u
* device instance $2807 r0 *1 151.2,301.7 NMOS
XM$2807 VSS \$I4512 \$I4513 VSS NMOS L=1u W=3.4u AS=6.46p AD=6.46p PS=7.2u
+ PD=7.2u
* device instance $2808 r0 *1 156,301.7 NMOS
XM$2808 \$I4513 WL10 BLB6 VSS NMOS L=1u W=3.4u AS=6.46p AD=10.88p PS=7.2u
+ PD=13.2u
* device instance $2809 r0 *1 169.6,322.1 PMOS
XM$2809 \$I4514 \$I4515 VDD VDD PMOS L=1u W=3.4u AS=10.88p AD=6.46p PS=13.2u
+ PD=7.2u
* device instance $2810 r0 *1 174.4,322.1 PMOS
XM$2810 VDD \$I4514 \$I4515 VDD PMOS L=1u W=3.4u AS=6.46p AD=10.88p PS=7.2u
+ PD=13.2u
* device instance $2811 r0 *1 164.8,301.7 NMOS
XM$2811 BL7 WL10 \$I4514 VSS NMOS L=1u W=3.4u AS=10.88p AD=6.46p PS=13.2u
+ PD=7.2u
* device instance $2812 r0 *1 169.6,301.7 NMOS
XM$2812 \$I4514 \$I4515 VSS VSS NMOS L=1u W=3.4u AS=6.46p AD=6.46p PS=7.2u
+ PD=7.2u
* device instance $2813 r0 *1 174.4,301.7 NMOS
XM$2813 VSS \$I4514 \$I4515 VSS NMOS L=1u W=3.4u AS=6.46p AD=6.46p PS=7.2u
+ PD=7.2u
* device instance $2814 r0 *1 179.2,301.7 NMOS
XM$2814 \$I4515 WL10 BLB7 VSS NMOS L=1u W=3.4u AS=6.46p AD=10.88p PS=7.2u
+ PD=13.2u
* device instance $2815 r0 *1 7.2,322.1 PMOS
XM$2815 \$I4516 \$I4517 VDD VDD PMOS L=1u W=3.4u AS=10.88p AD=6.46p PS=13.2u
+ PD=7.2u
* device instance $2816 r0 *1 12,322.1 PMOS
XM$2816 VDD \$I4516 \$I4517 VDD PMOS L=1u W=3.4u AS=6.46p AD=10.88p PS=7.2u
+ PD=13.2u
* device instance $2817 r0 *1 2.4,301.7 NMOS
XM$2817 BL0 WL10 \$I4516 VSS NMOS L=1u W=3.4u AS=10.88p AD=6.46p PS=13.2u
+ PD=7.2u
* device instance $2818 r0 *1 7.2,301.7 NMOS
XM$2818 \$I4516 \$I4517 VSS VSS NMOS L=1u W=3.4u AS=6.46p AD=6.46p PS=7.2u
+ PD=7.2u
* device instance $2819 r0 *1 12,301.7 NMOS
XM$2819 VSS \$I4516 \$I4517 VSS NMOS L=1u W=3.4u AS=6.46p AD=6.46p PS=7.2u
+ PD=7.2u
* device instance $2820 r0 *1 16.8,301.7 NMOS
XM$2820 \$I4517 WL10 BLB0 VSS NMOS L=1u W=3.4u AS=6.46p AD=10.88p PS=7.2u
+ PD=13.2u
* device instance $2821 r0 *1 53.6,440.5 PMOS
XM$2821 \$I4518 \$I4519 VDD VDD PMOS L=1u W=3.4u AS=10.88p AD=6.46p PS=13.2u
+ PD=7.2u
* device instance $2822 r0 *1 58.4,440.5 PMOS
XM$2822 VDD \$I4518 \$I4519 VDD PMOS L=1u W=3.4u AS=6.46p AD=10.88p PS=7.2u
+ PD=13.2u
* device instance $2823 r0 *1 48.8,420.1 NMOS
XM$2823 BL2 WL14 \$I4518 VSS NMOS L=1u W=3.4u AS=10.88p AD=6.46p PS=13.2u
+ PD=7.2u
* device instance $2824 r0 *1 53.6,420.1 NMOS
XM$2824 \$I4518 \$I4519 VSS VSS NMOS L=1u W=3.4u AS=6.46p AD=6.46p PS=7.2u
+ PD=7.2u
* device instance $2825 r0 *1 58.4,420.1 NMOS
XM$2825 VSS \$I4518 \$I4519 VSS NMOS L=1u W=3.4u AS=6.46p AD=6.46p PS=7.2u
+ PD=7.2u
* device instance $2826 r0 *1 63.2,420.1 NMOS
XM$2826 \$I4519 WL14 BLB2 VSS NMOS L=1u W=3.4u AS=6.46p AD=10.88p PS=7.2u
+ PD=13.2u
* device instance $2827 r0 *1 169.6,203.7 PMOS
XM$2827 \$I4520 \$I4521 VDD VDD PMOS L=1u W=3.4u AS=10.88p AD=6.46p PS=13.2u
+ PD=7.2u
* device instance $2828 r0 *1 174.4,203.7 PMOS
XM$2828 VDD \$I4520 \$I4521 VDD PMOS L=1u W=3.4u AS=6.46p AD=10.88p PS=7.2u
+ PD=13.2u
* device instance $2829 r0 *1 164.8,183.3 NMOS
XM$2829 BL7 WL6 \$I4520 VSS NMOS L=1u W=3.4u AS=10.88p AD=6.46p PS=13.2u PD=7.2u
* device instance $2830 r0 *1 169.6,183.3 NMOS
XM$2830 \$I4520 \$I4521 VSS VSS NMOS L=1u W=3.4u AS=6.46p AD=6.46p PS=7.2u
+ PD=7.2u
* device instance $2831 r0 *1 174.4,183.3 NMOS
XM$2831 VSS \$I4520 \$I4521 VSS NMOS L=1u W=3.4u AS=6.46p AD=6.46p PS=7.2u
+ PD=7.2u
* device instance $2832 r0 *1 179.2,183.3 NMOS
XM$2832 \$I4521 WL6 BLB7 VSS NMOS L=1u W=3.4u AS=6.46p AD=10.88p PS=7.2u
+ PD=13.2u
* device instance $2833 r0 *1 7.2,144.5 PMOS
XM$2833 \$I4522 \$I4523 VDD VDD PMOS L=1u W=3.4u AS=10.88p AD=6.46p PS=13.2u
+ PD=7.2u
* device instance $2834 r0 *1 12,144.5 PMOS
XM$2834 VDD \$I4522 \$I4523 VDD PMOS L=1u W=3.4u AS=6.46p AD=10.88p PS=7.2u
+ PD=13.2u
* device instance $2835 r0 *1 2.4,124.1 NMOS
XM$2835 BL0 WL4 \$I4522 VSS NMOS L=1u W=3.4u AS=10.88p AD=6.46p PS=13.2u PD=7.2u
* device instance $2836 r0 *1 7.2,124.1 NMOS
XM$2836 \$I4522 \$I4523 VSS VSS NMOS L=1u W=3.4u AS=6.46p AD=6.46p PS=7.2u
+ PD=7.2u
* device instance $2837 r0 *1 12,124.1 NMOS
XM$2837 VSS \$I4522 \$I4523 VSS NMOS L=1u W=3.4u AS=6.46p AD=6.46p PS=7.2u
+ PD=7.2u
* device instance $2838 r0 *1 16.8,124.1 NMOS
XM$2838 \$I4523 WL4 BLB0 VSS NMOS L=1u W=3.4u AS=6.46p AD=10.88p PS=7.2u
+ PD=13.2u
* device instance $2839 r0 *1 30.4,144.5 PMOS
XM$2839 \$I4524 \$I4525 VDD VDD PMOS L=1u W=3.4u AS=10.88p AD=6.46p PS=13.2u
+ PD=7.2u
* device instance $2840 r0 *1 35.2,144.5 PMOS
XM$2840 VDD \$I4524 \$I4525 VDD PMOS L=1u W=3.4u AS=6.46p AD=10.88p PS=7.2u
+ PD=13.2u
* device instance $2841 r0 *1 25.6,124.1 NMOS
XM$2841 BL1 WL4 \$I4524 VSS NMOS L=1u W=3.4u AS=10.88p AD=6.46p PS=13.2u PD=7.2u
* device instance $2842 r0 *1 30.4,124.1 NMOS
XM$2842 \$I4524 \$I4525 VSS VSS NMOS L=1u W=3.4u AS=6.46p AD=6.46p PS=7.2u
+ PD=7.2u
* device instance $2843 r0 *1 35.2,124.1 NMOS
XM$2843 VSS \$I4524 \$I4525 VSS NMOS L=1u W=3.4u AS=6.46p AD=6.46p PS=7.2u
+ PD=7.2u
* device instance $2844 r0 *1 40,124.1 NMOS
XM$2844 \$I4525 WL4 BLB1 VSS NMOS L=1u W=3.4u AS=6.46p AD=10.88p PS=7.2u
+ PD=13.2u
* device instance $2845 r0 *1 53.6,144.5 PMOS
XM$2845 \$I4526 \$I4527 VDD VDD PMOS L=1u W=3.4u AS=10.88p AD=6.46p PS=13.2u
+ PD=7.2u
* device instance $2846 r0 *1 58.4,144.5 PMOS
XM$2846 VDD \$I4526 \$I4527 VDD PMOS L=1u W=3.4u AS=6.46p AD=10.88p PS=7.2u
+ PD=13.2u
* device instance $2847 r0 *1 48.8,124.1 NMOS
XM$2847 BL2 WL4 \$I4526 VSS NMOS L=1u W=3.4u AS=10.88p AD=6.46p PS=13.2u PD=7.2u
* device instance $2848 r0 *1 53.6,124.1 NMOS
XM$2848 \$I4526 \$I4527 VSS VSS NMOS L=1u W=3.4u AS=6.46p AD=6.46p PS=7.2u
+ PD=7.2u
* device instance $2849 r0 *1 58.4,124.1 NMOS
XM$2849 VSS \$I4526 \$I4527 VSS NMOS L=1u W=3.4u AS=6.46p AD=6.46p PS=7.2u
+ PD=7.2u
* device instance $2850 r0 *1 63.2,124.1 NMOS
XM$2850 \$I4527 WL4 BLB2 VSS NMOS L=1u W=3.4u AS=6.46p AD=10.88p PS=7.2u
+ PD=13.2u
* device instance $2851 r0 *1 76.8,144.5 PMOS
XM$2851 \$I4528 \$I4529 VDD VDD PMOS L=1u W=3.4u AS=10.88p AD=6.46p PS=13.2u
+ PD=7.2u
* device instance $2852 r0 *1 81.6,144.5 PMOS
XM$2852 VDD \$I4528 \$I4529 VDD PMOS L=1u W=3.4u AS=6.46p AD=10.88p PS=7.2u
+ PD=13.2u
* device instance $2853 r0 *1 72,124.1 NMOS
XM$2853 BL3 WL4 \$I4528 VSS NMOS L=1u W=3.4u AS=10.88p AD=6.46p PS=13.2u PD=7.2u
* device instance $2854 r0 *1 76.8,124.1 NMOS
XM$2854 \$I4528 \$I4529 VSS VSS NMOS L=1u W=3.4u AS=6.46p AD=6.46p PS=7.2u
+ PD=7.2u
* device instance $2855 r0 *1 81.6,124.1 NMOS
XM$2855 VSS \$I4528 \$I4529 VSS NMOS L=1u W=3.4u AS=6.46p AD=6.46p PS=7.2u
+ PD=7.2u
* device instance $2856 r0 *1 86.4,124.1 NMOS
XM$2856 \$I4529 WL4 BLB3 VSS NMOS L=1u W=3.4u AS=6.46p AD=10.88p PS=7.2u
+ PD=13.2u
* device instance $2857 r0 *1 100,144.5 PMOS
XM$2857 \$I4530 \$I4531 VDD VDD PMOS L=1u W=3.4u AS=10.88p AD=6.46p PS=13.2u
+ PD=7.2u
* device instance $2858 r0 *1 104.8,144.5 PMOS
XM$2858 VDD \$I4530 \$I4531 VDD PMOS L=1u W=3.4u AS=6.46p AD=10.88p PS=7.2u
+ PD=13.2u
* device instance $2859 r0 *1 95.2,124.1 NMOS
XM$2859 BL4 WL4 \$I4530 VSS NMOS L=1u W=3.4u AS=10.88p AD=6.46p PS=13.2u PD=7.2u
* device instance $2860 r0 *1 100,124.1 NMOS
XM$2860 \$I4530 \$I4531 VSS VSS NMOS L=1u W=3.4u AS=6.46p AD=6.46p PS=7.2u
+ PD=7.2u
* device instance $2861 r0 *1 104.8,124.1 NMOS
XM$2861 VSS \$I4530 \$I4531 VSS NMOS L=1u W=3.4u AS=6.46p AD=6.46p PS=7.2u
+ PD=7.2u
* device instance $2862 r0 *1 109.6,124.1 NMOS
XM$2862 \$I4531 WL4 BLB4 VSS NMOS L=1u W=3.4u AS=6.46p AD=10.88p PS=7.2u
+ PD=13.2u
* device instance $2863 r0 *1 123.2,144.5 PMOS
XM$2863 \$I4532 \$I4533 VDD VDD PMOS L=1u W=3.4u AS=10.88p AD=6.46p PS=13.2u
+ PD=7.2u
* device instance $2864 r0 *1 128,144.5 PMOS
XM$2864 VDD \$I4532 \$I4533 VDD PMOS L=1u W=3.4u AS=6.46p AD=10.88p PS=7.2u
+ PD=13.2u
* device instance $2865 r0 *1 118.4,124.1 NMOS
XM$2865 BL5 WL4 \$I4532 VSS NMOS L=1u W=3.4u AS=10.88p AD=6.46p PS=13.2u PD=7.2u
* device instance $2866 r0 *1 123.2,124.1 NMOS
XM$2866 \$I4532 \$I4533 VSS VSS NMOS L=1u W=3.4u AS=6.46p AD=6.46p PS=7.2u
+ PD=7.2u
* device instance $2867 r0 *1 128,124.1 NMOS
XM$2867 VSS \$I4532 \$I4533 VSS NMOS L=1u W=3.4u AS=6.46p AD=6.46p PS=7.2u
+ PD=7.2u
* device instance $2868 r0 *1 132.8,124.1 NMOS
XM$2868 \$I4533 WL4 BLB5 VSS NMOS L=1u W=3.4u AS=6.46p AD=10.88p PS=7.2u
+ PD=13.2u
* device instance $2869 r0 *1 146.4,144.5 PMOS
XM$2869 \$I4534 \$I4535 VDD VDD PMOS L=1u W=3.4u AS=10.88p AD=6.46p PS=13.2u
+ PD=7.2u
* device instance $2870 r0 *1 151.2,144.5 PMOS
XM$2870 VDD \$I4534 \$I4535 VDD PMOS L=1u W=3.4u AS=6.46p AD=10.88p PS=7.2u
+ PD=13.2u
* device instance $2871 r0 *1 141.6,124.1 NMOS
XM$2871 BL6 WL4 \$I4534 VSS NMOS L=1u W=3.4u AS=10.88p AD=6.46p PS=13.2u PD=7.2u
* device instance $2872 r0 *1 146.4,124.1 NMOS
XM$2872 \$I4534 \$I4535 VSS VSS NMOS L=1u W=3.4u AS=6.46p AD=6.46p PS=7.2u
+ PD=7.2u
* device instance $2873 r0 *1 151.2,124.1 NMOS
XM$2873 VSS \$I4534 \$I4535 VSS NMOS L=1u W=3.4u AS=6.46p AD=6.46p PS=7.2u
+ PD=7.2u
* device instance $2874 r0 *1 156,124.1 NMOS
XM$2874 \$I4535 WL4 BLB6 VSS NMOS L=1u W=3.4u AS=6.46p AD=10.88p PS=7.2u
+ PD=13.2u
* device instance $2875 r0 *1 169.6,144.5 PMOS
XM$2875 \$I4536 \$I4537 VDD VDD PMOS L=1u W=3.4u AS=10.88p AD=6.46p PS=13.2u
+ PD=7.2u
* device instance $2876 r0 *1 174.4,144.5 PMOS
XM$2876 VDD \$I4536 \$I4537 VDD PMOS L=1u W=3.4u AS=6.46p AD=10.88p PS=7.2u
+ PD=13.2u
* device instance $2877 r0 *1 164.8,124.1 NMOS
XM$2877 BL7 WL4 \$I4536 VSS NMOS L=1u W=3.4u AS=10.88p AD=6.46p PS=13.2u PD=7.2u
* device instance $2878 r0 *1 169.6,124.1 NMOS
XM$2878 \$I4536 \$I4537 VSS VSS NMOS L=1u W=3.4u AS=6.46p AD=6.46p PS=7.2u
+ PD=7.2u
* device instance $2879 r0 *1 174.4,124.1 NMOS
XM$2879 VSS \$I4536 \$I4537 VSS NMOS L=1u W=3.4u AS=6.46p AD=6.46p PS=7.2u
+ PD=7.2u
* device instance $2880 r0 *1 179.2,124.1 NMOS
XM$2880 \$I4537 WL4 BLB7 VSS NMOS L=1u W=3.4u AS=6.46p AD=10.88p PS=7.2u
+ PD=13.2u
* device instance $2881 r0 *1 7.2,203.7 PMOS
XM$2881 \$I4538 \$I4539 VDD VDD PMOS L=1u W=3.4u AS=10.88p AD=6.46p PS=13.2u
+ PD=7.2u
* device instance $2882 r0 *1 12,203.7 PMOS
XM$2882 VDD \$I4538 \$I4539 VDD PMOS L=1u W=3.4u AS=6.46p AD=10.88p PS=7.2u
+ PD=13.2u
* device instance $2883 r0 *1 2.4,183.3 NMOS
XM$2883 BL0 WL6 \$I4538 VSS NMOS L=1u W=3.4u AS=10.88p AD=6.46p PS=13.2u PD=7.2u
* device instance $2884 r0 *1 7.2,183.3 NMOS
XM$2884 \$I4538 \$I4539 VSS VSS NMOS L=1u W=3.4u AS=6.46p AD=6.46p PS=7.2u
+ PD=7.2u
* device instance $2885 r0 *1 12,183.3 NMOS
XM$2885 VSS \$I4538 \$I4539 VSS NMOS L=1u W=3.4u AS=6.46p AD=6.46p PS=7.2u
+ PD=7.2u
* device instance $2886 r0 *1 16.8,183.3 NMOS
XM$2886 \$I4539 WL6 BLB0 VSS NMOS L=1u W=3.4u AS=6.46p AD=10.88p PS=7.2u
+ PD=13.2u
* device instance $2887 r0 *1 332,262.9 PMOS
XM$2887 \$I4540 \$I4541 VDD VDD PMOS L=1u W=3.4u AS=10.88p AD=6.46p PS=13.2u
+ PD=7.2u
* device instance $2888 r0 *1 336.8,262.9 PMOS
XM$2888 VDD \$I4540 \$I4541 VDD PMOS L=1u W=3.4u AS=6.46p AD=10.88p PS=7.2u
+ PD=13.2u
* device instance $2889 r0 *1 327.2,242.5 NMOS
XM$2889 BL14 WL8 \$I4540 VSS NMOS L=1u W=3.4u AS=10.88p AD=6.46p PS=13.2u
+ PD=7.2u
* device instance $2890 r0 *1 332,242.5 NMOS
XM$2890 \$I4540 \$I4541 VSS VSS NMOS L=1u W=3.4u AS=6.46p AD=6.46p PS=7.2u
+ PD=7.2u
* device instance $2891 r0 *1 336.8,242.5 NMOS
XM$2891 VSS \$I4540 \$I4541 VSS NMOS L=1u W=3.4u AS=6.46p AD=6.46p PS=7.2u
+ PD=7.2u
* device instance $2892 r0 *1 341.6,242.5 NMOS
XM$2892 \$I4541 WL8 BLB14 VSS NMOS L=1u W=3.4u AS=6.46p AD=10.88p PS=7.2u
+ PD=13.2u
* device instance $2893 r0 *1 53.6,203.7 PMOS
XM$2893 \$I4542 \$I4543 VDD VDD PMOS L=1u W=3.4u AS=10.88p AD=6.46p PS=13.2u
+ PD=7.2u
* device instance $2894 r0 *1 58.4,203.7 PMOS
XM$2894 VDD \$I4542 \$I4543 VDD PMOS L=1u W=3.4u AS=6.46p AD=10.88p PS=7.2u
+ PD=13.2u
* device instance $2895 r0 *1 48.8,183.3 NMOS
XM$2895 BL2 WL6 \$I4542 VSS NMOS L=1u W=3.4u AS=10.88p AD=6.46p PS=13.2u PD=7.2u
* device instance $2896 r0 *1 53.6,183.3 NMOS
XM$2896 \$I4542 \$I4543 VSS VSS NMOS L=1u W=3.4u AS=6.46p AD=6.46p PS=7.2u
+ PD=7.2u
* device instance $2897 r0 *1 58.4,183.3 NMOS
XM$2897 VSS \$I4542 \$I4543 VSS NMOS L=1u W=3.4u AS=6.46p AD=6.46p PS=7.2u
+ PD=7.2u
* device instance $2898 r0 *1 63.2,183.3 NMOS
XM$2898 \$I4543 WL6 BLB2 VSS NMOS L=1u W=3.4u AS=6.46p AD=10.88p PS=7.2u
+ PD=13.2u
* device instance $2899 r0 *1 76.8,203.7 PMOS
XM$2899 \$I4544 \$I4545 VDD VDD PMOS L=1u W=3.4u AS=10.88p AD=6.46p PS=13.2u
+ PD=7.2u
* device instance $2900 r0 *1 81.6,203.7 PMOS
XM$2900 VDD \$I4544 \$I4545 VDD PMOS L=1u W=3.4u AS=6.46p AD=10.88p PS=7.2u
+ PD=13.2u
* device instance $2901 r0 *1 72,183.3 NMOS
XM$2901 BL3 WL6 \$I4544 VSS NMOS L=1u W=3.4u AS=10.88p AD=6.46p PS=13.2u PD=7.2u
* device instance $2902 r0 *1 76.8,183.3 NMOS
XM$2902 \$I4544 \$I4545 VSS VSS NMOS L=1u W=3.4u AS=6.46p AD=6.46p PS=7.2u
+ PD=7.2u
* device instance $2903 r0 *1 81.6,183.3 NMOS
XM$2903 VSS \$I4544 \$I4545 VSS NMOS L=1u W=3.4u AS=6.46p AD=6.46p PS=7.2u
+ PD=7.2u
* device instance $2904 r0 *1 86.4,183.3 NMOS
XM$2904 \$I4545 WL6 BLB3 VSS NMOS L=1u W=3.4u AS=6.46p AD=10.88p PS=7.2u
+ PD=13.2u
* device instance $2905 r0 *1 7.2,85.3 PMOS
XM$2905 \$I4546 \$I4547 VDD VDD PMOS L=1u W=3.4u AS=10.88p AD=6.46p PS=13.2u
+ PD=7.2u
* device instance $2906 r0 *1 12,85.3 PMOS
XM$2906 VDD \$I4546 \$I4547 VDD PMOS L=1u W=3.4u AS=6.46p AD=10.88p PS=7.2u
+ PD=13.2u
* device instance $2907 r0 *1 2.4,64.9 NMOS
XM$2907 BL0 WL2 \$I4546 VSS NMOS L=1u W=3.4u AS=10.88p AD=6.46p PS=13.2u PD=7.2u
* device instance $2908 r0 *1 7.2,64.9 NMOS
XM$2908 \$I4546 \$I4547 VSS VSS NMOS L=1u W=3.4u AS=6.46p AD=6.46p PS=7.2u
+ PD=7.2u
* device instance $2909 r0 *1 12,64.9 NMOS
XM$2909 VSS \$I4546 \$I4547 VSS NMOS L=1u W=3.4u AS=6.46p AD=6.46p PS=7.2u
+ PD=7.2u
* device instance $2910 r0 *1 16.8,64.9 NMOS
XM$2910 \$I4547 WL2 BLB0 VSS NMOS L=1u W=3.4u AS=6.46p AD=10.88p PS=7.2u
+ PD=13.2u
* device instance $2911 r0 *1 30.4,85.3 PMOS
XM$2911 \$I4548 \$I4549 VDD VDD PMOS L=1u W=3.4u AS=10.88p AD=6.46p PS=13.2u
+ PD=7.2u
* device instance $2912 r0 *1 35.2,85.3 PMOS
XM$2912 VDD \$I4548 \$I4549 VDD PMOS L=1u W=3.4u AS=6.46p AD=10.88p PS=7.2u
+ PD=13.2u
* device instance $2913 r0 *1 25.6,64.9 NMOS
XM$2913 BL1 WL2 \$I4548 VSS NMOS L=1u W=3.4u AS=10.88p AD=6.46p PS=13.2u PD=7.2u
* device instance $2914 r0 *1 30.4,64.9 NMOS
XM$2914 \$I4548 \$I4549 VSS VSS NMOS L=1u W=3.4u AS=6.46p AD=6.46p PS=7.2u
+ PD=7.2u
* device instance $2915 r0 *1 35.2,64.9 NMOS
XM$2915 VSS \$I4548 \$I4549 VSS NMOS L=1u W=3.4u AS=6.46p AD=6.46p PS=7.2u
+ PD=7.2u
* device instance $2916 r0 *1 40,64.9 NMOS
XM$2916 \$I4549 WL2 BLB1 VSS NMOS L=1u W=3.4u AS=6.46p AD=10.88p PS=7.2u
+ PD=13.2u
* device instance $2917 r0 *1 53.6,85.3 PMOS
XM$2917 \$I4550 \$I4551 VDD VDD PMOS L=1u W=3.4u AS=10.88p AD=6.46p PS=13.2u
+ PD=7.2u
* device instance $2918 r0 *1 58.4,85.3 PMOS
XM$2918 VDD \$I4550 \$I4551 VDD PMOS L=1u W=3.4u AS=6.46p AD=10.88p PS=7.2u
+ PD=13.2u
* device instance $2919 r0 *1 48.8,64.9 NMOS
XM$2919 BL2 WL2 \$I4550 VSS NMOS L=1u W=3.4u AS=10.88p AD=6.46p PS=13.2u PD=7.2u
* device instance $2920 r0 *1 53.6,64.9 NMOS
XM$2920 \$I4550 \$I4551 VSS VSS NMOS L=1u W=3.4u AS=6.46p AD=6.46p PS=7.2u
+ PD=7.2u
* device instance $2921 r0 *1 58.4,64.9 NMOS
XM$2921 VSS \$I4550 \$I4551 VSS NMOS L=1u W=3.4u AS=6.46p AD=6.46p PS=7.2u
+ PD=7.2u
* device instance $2922 r0 *1 63.2,64.9 NMOS
XM$2922 \$I4551 WL2 BLB2 VSS NMOS L=1u W=3.4u AS=6.46p AD=10.88p PS=7.2u
+ PD=13.2u
* device instance $2923 r0 *1 76.8,85.3 PMOS
XM$2923 \$I4552 \$I4553 VDD VDD PMOS L=1u W=3.4u AS=10.88p AD=6.46p PS=13.2u
+ PD=7.2u
* device instance $2924 r0 *1 81.6,85.3 PMOS
XM$2924 VDD \$I4552 \$I4553 VDD PMOS L=1u W=3.4u AS=6.46p AD=10.88p PS=7.2u
+ PD=13.2u
* device instance $2925 r0 *1 72,64.9 NMOS
XM$2925 BL3 WL2 \$I4552 VSS NMOS L=1u W=3.4u AS=10.88p AD=6.46p PS=13.2u PD=7.2u
* device instance $2926 r0 *1 76.8,64.9 NMOS
XM$2926 \$I4552 \$I4553 VSS VSS NMOS L=1u W=3.4u AS=6.46p AD=6.46p PS=7.2u
+ PD=7.2u
* device instance $2927 r0 *1 81.6,64.9 NMOS
XM$2927 VSS \$I4552 \$I4553 VSS NMOS L=1u W=3.4u AS=6.46p AD=6.46p PS=7.2u
+ PD=7.2u
* device instance $2928 r0 *1 86.4,64.9 NMOS
XM$2928 \$I4553 WL2 BLB3 VSS NMOS L=1u W=3.4u AS=6.46p AD=10.88p PS=7.2u
+ PD=13.2u
* device instance $2929 r0 *1 100,85.3 PMOS
XM$2929 \$I4554 \$I4555 VDD VDD PMOS L=1u W=3.4u AS=10.88p AD=6.46p PS=13.2u
+ PD=7.2u
* device instance $2930 r0 *1 104.8,85.3 PMOS
XM$2930 VDD \$I4554 \$I4555 VDD PMOS L=1u W=3.4u AS=6.46p AD=10.88p PS=7.2u
+ PD=13.2u
* device instance $2931 r0 *1 95.2,64.9 NMOS
XM$2931 BL4 WL2 \$I4554 VSS NMOS L=1u W=3.4u AS=10.88p AD=6.46p PS=13.2u PD=7.2u
* device instance $2932 r0 *1 100,64.9 NMOS
XM$2932 \$I4554 \$I4555 VSS VSS NMOS L=1u W=3.4u AS=6.46p AD=6.46p PS=7.2u
+ PD=7.2u
* device instance $2933 r0 *1 104.8,64.9 NMOS
XM$2933 VSS \$I4554 \$I4555 VSS NMOS L=1u W=3.4u AS=6.46p AD=6.46p PS=7.2u
+ PD=7.2u
* device instance $2934 r0 *1 109.6,64.9 NMOS
XM$2934 \$I4555 WL2 BLB4 VSS NMOS L=1u W=3.4u AS=6.46p AD=10.88p PS=7.2u
+ PD=13.2u
* device instance $2935 r0 *1 123.2,85.3 PMOS
XM$2935 \$I4556 \$I4557 VDD VDD PMOS L=1u W=3.4u AS=10.88p AD=6.46p PS=13.2u
+ PD=7.2u
* device instance $2936 r0 *1 128,85.3 PMOS
XM$2936 VDD \$I4556 \$I4557 VDD PMOS L=1u W=3.4u AS=6.46p AD=10.88p PS=7.2u
+ PD=13.2u
* device instance $2937 r0 *1 118.4,64.9 NMOS
XM$2937 BL5 WL2 \$I4556 VSS NMOS L=1u W=3.4u AS=10.88p AD=6.46p PS=13.2u PD=7.2u
* device instance $2938 r0 *1 123.2,64.9 NMOS
XM$2938 \$I4556 \$I4557 VSS VSS NMOS L=1u W=3.4u AS=6.46p AD=6.46p PS=7.2u
+ PD=7.2u
* device instance $2939 r0 *1 128,64.9 NMOS
XM$2939 VSS \$I4556 \$I4557 VSS NMOS L=1u W=3.4u AS=6.46p AD=6.46p PS=7.2u
+ PD=7.2u
* device instance $2940 r0 *1 132.8,64.9 NMOS
XM$2940 \$I4557 WL2 BLB5 VSS NMOS L=1u W=3.4u AS=6.46p AD=10.88p PS=7.2u
+ PD=13.2u
* device instance $2941 r0 *1 30.4,203.7 PMOS
XM$2941 \$I4558 \$I4559 VDD VDD PMOS L=1u W=3.4u AS=10.88p AD=6.46p PS=13.2u
+ PD=7.2u
* device instance $2942 r0 *1 35.2,203.7 PMOS
XM$2942 VDD \$I4558 \$I4559 VDD PMOS L=1u W=3.4u AS=6.46p AD=10.88p PS=7.2u
+ PD=13.2u
* device instance $2943 r0 *1 25.6,183.3 NMOS
XM$2943 BL1 WL6 \$I4558 VSS NMOS L=1u W=3.4u AS=10.88p AD=6.46p PS=13.2u PD=7.2u
* device instance $2944 r0 *1 30.4,183.3 NMOS
XM$2944 \$I4558 \$I4559 VSS VSS NMOS L=1u W=3.4u AS=6.46p AD=6.46p PS=7.2u
+ PD=7.2u
* device instance $2945 r0 *1 35.2,183.3 NMOS
XM$2945 VSS \$I4558 \$I4559 VSS NMOS L=1u W=3.4u AS=6.46p AD=6.46p PS=7.2u
+ PD=7.2u
* device instance $2946 r0 *1 40,183.3 NMOS
XM$2946 \$I4559 WL6 BLB1 VSS NMOS L=1u W=3.4u AS=6.46p AD=10.88p PS=7.2u
+ PD=13.2u
* device instance $2947 r0 *1 355.2,262.9 PMOS
XM$2947 \$I4560 \$I4561 VDD VDD PMOS L=1u W=3.4u AS=10.88p AD=6.46p PS=13.2u
+ PD=7.2u
* device instance $2948 r0 *1 360,262.9 PMOS
XM$2948 VDD \$I4560 \$I4561 VDD PMOS L=1u W=3.4u AS=6.46p AD=10.88p PS=7.2u
+ PD=13.2u
* device instance $2949 r0 *1 350.4,242.5 NMOS
XM$2949 BL15 WL8 \$I4560 VSS NMOS L=1u W=3.4u AS=10.88p AD=6.46p PS=13.2u
+ PD=7.2u
* device instance $2950 r0 *1 355.2,242.5 NMOS
XM$2950 \$I4560 \$I4561 VSS VSS NMOS L=1u W=3.4u AS=6.46p AD=6.46p PS=7.2u
+ PD=7.2u
* device instance $2951 r0 *1 360,242.5 NMOS
XM$2951 VSS \$I4560 \$I4561 VSS NMOS L=1u W=3.4u AS=6.46p AD=6.46p PS=7.2u
+ PD=7.2u
* device instance $2952 r0 *1 364.8,242.5 NMOS
XM$2952 \$I4561 WL8 BLB15 VSS NMOS L=1u W=3.4u AS=6.46p AD=10.88p PS=7.2u
+ PD=13.2u
* device instance $2953 r0 *1 562,381.3 PMOS
XM$2953 \$I4562 \$I4563 VDD VDD PMOS L=1u W=3.4u AS=10.88p AD=6.46p PS=13.2u
+ PD=7.2u
* device instance $2954 r0 *1 566.8,381.3 PMOS
XM$2954 VDD \$I4562 \$I4563 VDD PMOS L=1u W=3.4u AS=6.46p AD=10.88p PS=7.2u
+ PD=13.2u
* device instance $2955 r0 *1 557.2,360.9 NMOS
XM$2955 BL23 WL12 \$I4562 VSS NMOS L=1u W=3.4u AS=10.88p AD=6.46p PS=13.2u
+ PD=7.2u
* device instance $2956 r0 *1 562,360.9 NMOS
XM$2956 \$I4562 \$I4563 VSS VSS NMOS L=1u W=3.4u AS=6.46p AD=6.46p PS=7.2u
+ PD=7.2u
* device instance $2957 r0 *1 566.8,360.9 NMOS
XM$2957 VSS \$I4562 \$I4563 VSS NMOS L=1u W=3.4u AS=6.46p AD=6.46p PS=7.2u
+ PD=7.2u
* device instance $2958 r0 *1 571.6,360.9 NMOS
XM$2958 \$I4563 WL12 BLB23 VSS NMOS L=1u W=3.4u AS=6.46p AD=10.88p PS=7.2u
+ PD=13.2u
* device instance $2959 r0 *1 192.8,203.7 PMOS
XM$2959 \$I4564 \$I4565 VDD VDD PMOS L=1u W=3.4u AS=10.88p AD=6.46p PS=13.2u
+ PD=7.2u
* device instance $2960 r0 *1 197.6,203.7 PMOS
XM$2960 VDD \$I4564 \$I4565 VDD PMOS L=1u W=3.4u AS=6.46p AD=10.88p PS=7.2u
+ PD=13.2u
* device instance $2961 r0 *1 188,183.3 NMOS
XM$2961 BL8 WL6 \$I4564 VSS NMOS L=1u W=3.4u AS=10.88p AD=6.46p PS=13.2u PD=7.2u
* device instance $2962 r0 *1 192.8,183.3 NMOS
XM$2962 \$I4564 \$I4565 VSS VSS NMOS L=1u W=3.4u AS=6.46p AD=6.46p PS=7.2u
+ PD=7.2u
* device instance $2963 r0 *1 197.6,183.3 NMOS
XM$2963 VSS \$I4564 \$I4565 VSS NMOS L=1u W=3.4u AS=6.46p AD=6.46p PS=7.2u
+ PD=7.2u
* device instance $2964 r0 *1 202.4,183.3 NMOS
XM$2964 \$I4565 WL6 BLB8 VSS NMOS L=1u W=3.4u AS=6.46p AD=10.88p PS=7.2u
+ PD=13.2u
* device instance $2965 r0 *1 192.8,85.3 PMOS
XM$2965 \$I4566 \$I4567 VDD VDD PMOS L=1u W=3.4u AS=10.88p AD=6.46p PS=13.2u
+ PD=7.2u
* device instance $2966 r0 *1 197.6,85.3 PMOS
XM$2966 VDD \$I4566 \$I4567 VDD PMOS L=1u W=3.4u AS=6.46p AD=10.88p PS=7.2u
+ PD=13.2u
* device instance $2967 r0 *1 188,64.9 NMOS
XM$2967 BL8 WL2 \$I4566 VSS NMOS L=1u W=3.4u AS=10.88p AD=6.46p PS=13.2u PD=7.2u
* device instance $2968 r0 *1 192.8,64.9 NMOS
XM$2968 \$I4566 \$I4567 VSS VSS NMOS L=1u W=3.4u AS=6.46p AD=6.46p PS=7.2u
+ PD=7.2u
* device instance $2969 r0 *1 197.6,64.9 NMOS
XM$2969 VSS \$I4566 \$I4567 VSS NMOS L=1u W=3.4u AS=6.46p AD=6.46p PS=7.2u
+ PD=7.2u
* device instance $2970 r0 *1 202.4,64.9 NMOS
XM$2970 \$I4567 WL2 BLB8 VSS NMOS L=1u W=3.4u AS=6.46p AD=10.88p PS=7.2u
+ PD=13.2u
* device instance $2971 r0 *1 216,144.5 PMOS
XM$2971 \$I4568 \$I4569 VDD VDD PMOS L=1u W=3.4u AS=10.88p AD=6.46p PS=13.2u
+ PD=7.2u
* device instance $2972 r0 *1 220.8,144.5 PMOS
XM$2972 VDD \$I4568 \$I4569 VDD PMOS L=1u W=3.4u AS=6.46p AD=10.88p PS=7.2u
+ PD=13.2u
* device instance $2973 r0 *1 211.2,124.1 NMOS
XM$2973 BL9 WL4 \$I4568 VSS NMOS L=1u W=3.4u AS=10.88p AD=6.46p PS=13.2u PD=7.2u
* device instance $2974 r0 *1 216,124.1 NMOS
XM$2974 \$I4568 \$I4569 VSS VSS NMOS L=1u W=3.4u AS=6.46p AD=6.46p PS=7.2u
+ PD=7.2u
* device instance $2975 r0 *1 220.8,124.1 NMOS
XM$2975 VSS \$I4568 \$I4569 VSS NMOS L=1u W=3.4u AS=6.46p AD=6.46p PS=7.2u
+ PD=7.2u
* device instance $2976 r0 *1 225.6,124.1 NMOS
XM$2976 \$I4569 WL4 BLB9 VSS NMOS L=1u W=3.4u AS=6.46p AD=10.88p PS=7.2u
+ PD=13.2u
* device instance $2977 r0 *1 239.2,144.5 PMOS
XM$2977 \$I4570 \$I4571 VDD VDD PMOS L=1u W=3.4u AS=10.88p AD=6.46p PS=13.2u
+ PD=7.2u
* device instance $2978 r0 *1 244,144.5 PMOS
XM$2978 VDD \$I4570 \$I4571 VDD PMOS L=1u W=3.4u AS=6.46p AD=10.88p PS=7.2u
+ PD=13.2u
* device instance $2979 r0 *1 234.4,124.1 NMOS
XM$2979 BL10 WL4 \$I4570 VSS NMOS L=1u W=3.4u AS=10.88p AD=6.46p PS=13.2u
+ PD=7.2u
* device instance $2980 r0 *1 239.2,124.1 NMOS
XM$2980 \$I4570 \$I4571 VSS VSS NMOS L=1u W=3.4u AS=6.46p AD=6.46p PS=7.2u
+ PD=7.2u
* device instance $2981 r0 *1 244,124.1 NMOS
XM$2981 VSS \$I4570 \$I4571 VSS NMOS L=1u W=3.4u AS=6.46p AD=6.46p PS=7.2u
+ PD=7.2u
* device instance $2982 r0 *1 248.8,124.1 NMOS
XM$2982 \$I4571 WL4 BLB10 VSS NMOS L=1u W=3.4u AS=6.46p AD=10.88p PS=7.2u
+ PD=13.2u
* device instance $2983 r0 *1 216,203.7 PMOS
XM$2983 \$I4572 \$I4573 VDD VDD PMOS L=1u W=3.4u AS=10.88p AD=6.46p PS=13.2u
+ PD=7.2u
* device instance $2984 r0 *1 220.8,203.7 PMOS
XM$2984 VDD \$I4572 \$I4573 VDD PMOS L=1u W=3.4u AS=6.46p AD=10.88p PS=7.2u
+ PD=13.2u
* device instance $2985 r0 *1 211.2,183.3 NMOS
XM$2985 BL9 WL6 \$I4572 VSS NMOS L=1u W=3.4u AS=10.88p AD=6.46p PS=13.2u PD=7.2u
* device instance $2986 r0 *1 216,183.3 NMOS
XM$2986 \$I4572 \$I4573 VSS VSS NMOS L=1u W=3.4u AS=6.46p AD=6.46p PS=7.2u
+ PD=7.2u
* device instance $2987 r0 *1 220.8,183.3 NMOS
XM$2987 VSS \$I4572 \$I4573 VSS NMOS L=1u W=3.4u AS=6.46p AD=6.46p PS=7.2u
+ PD=7.2u
* device instance $2988 r0 *1 225.6,183.3 NMOS
XM$2988 \$I4573 WL6 BLB9 VSS NMOS L=1u W=3.4u AS=6.46p AD=10.88p PS=7.2u
+ PD=13.2u
* device instance $2989 r0 *1 239.2,203.7 PMOS
XM$2989 \$I4574 \$I4575 VDD VDD PMOS L=1u W=3.4u AS=10.88p AD=6.46p PS=13.2u
+ PD=7.2u
* device instance $2990 r0 *1 244,203.7 PMOS
XM$2990 VDD \$I4574 \$I4575 VDD PMOS L=1u W=3.4u AS=6.46p AD=10.88p PS=7.2u
+ PD=13.2u
* device instance $2991 r0 *1 234.4,183.3 NMOS
XM$2991 BL10 WL6 \$I4574 VSS NMOS L=1u W=3.4u AS=10.88p AD=6.46p PS=13.2u
+ PD=7.2u
* device instance $2992 r0 *1 239.2,183.3 NMOS
XM$2992 \$I4574 \$I4575 VSS VSS NMOS L=1u W=3.4u AS=6.46p AD=6.46p PS=7.2u
+ PD=7.2u
* device instance $2993 r0 *1 244,183.3 NMOS
XM$2993 VSS \$I4574 \$I4575 VSS NMOS L=1u W=3.4u AS=6.46p AD=6.46p PS=7.2u
+ PD=7.2u
* device instance $2994 r0 *1 248.8,183.3 NMOS
XM$2994 \$I4575 WL6 BLB10 VSS NMOS L=1u W=3.4u AS=6.46p AD=10.88p PS=7.2u
+ PD=13.2u
* device instance $2995 r0 *1 262.4,203.7 PMOS
XM$2995 \$I4576 \$I4577 VDD VDD PMOS L=1u W=3.4u AS=10.88p AD=6.46p PS=13.2u
+ PD=7.2u
* device instance $2996 r0 *1 267.2,203.7 PMOS
XM$2996 VDD \$I4576 \$I4577 VDD PMOS L=1u W=3.4u AS=6.46p AD=10.88p PS=7.2u
+ PD=13.2u
* device instance $2997 r0 *1 257.6,183.3 NMOS
XM$2997 BL11 WL6 \$I4576 VSS NMOS L=1u W=3.4u AS=10.88p AD=6.46p PS=13.2u
+ PD=7.2u
* device instance $2998 r0 *1 262.4,183.3 NMOS
XM$2998 \$I4576 \$I4577 VSS VSS NMOS L=1u W=3.4u AS=6.46p AD=6.46p PS=7.2u
+ PD=7.2u
* device instance $2999 r0 *1 267.2,183.3 NMOS
XM$2999 VSS \$I4576 \$I4577 VSS NMOS L=1u W=3.4u AS=6.46p AD=6.46p PS=7.2u
+ PD=7.2u
* device instance $3000 r0 *1 272,183.3 NMOS
XM$3000 \$I4577 WL6 BLB11 VSS NMOS L=1u W=3.4u AS=6.46p AD=10.88p PS=7.2u
+ PD=13.2u
* device instance $3001 r0 *1 146.4,203.7 PMOS
XM$3001 \$I4578 \$I4579 VDD VDD PMOS L=1u W=3.4u AS=10.88p AD=6.46p PS=13.2u
+ PD=7.2u
* device instance $3002 r0 *1 151.2,203.7 PMOS
XM$3002 VDD \$I4578 \$I4579 VDD PMOS L=1u W=3.4u AS=6.46p AD=10.88p PS=7.2u
+ PD=13.2u
* device instance $3003 r0 *1 141.6,183.3 NMOS
XM$3003 BL6 WL6 \$I4578 VSS NMOS L=1u W=3.4u AS=10.88p AD=6.46p PS=13.2u PD=7.2u
* device instance $3004 r0 *1 146.4,183.3 NMOS
XM$3004 \$I4578 \$I4579 VSS VSS NMOS L=1u W=3.4u AS=6.46p AD=6.46p PS=7.2u
+ PD=7.2u
* device instance $3005 r0 *1 151.2,183.3 NMOS
XM$3005 VSS \$I4578 \$I4579 VSS NMOS L=1u W=3.4u AS=6.46p AD=6.46p PS=7.2u
+ PD=7.2u
* device instance $3006 r0 *1 156,183.3 NMOS
XM$3006 \$I4579 WL6 BLB6 VSS NMOS L=1u W=3.4u AS=6.46p AD=10.88p PS=7.2u
+ PD=13.2u
* device instance $3007 r0 *1 308.8,203.7 PMOS
XM$3007 \$I4580 \$I4581 VDD VDD PMOS L=1u W=3.4u AS=10.88p AD=6.46p PS=13.2u
+ PD=7.2u
* device instance $3008 r0 *1 313.6,203.7 PMOS
XM$3008 VDD \$I4580 \$I4581 VDD PMOS L=1u W=3.4u AS=6.46p AD=10.88p PS=7.2u
+ PD=13.2u
* device instance $3009 r0 *1 304,183.3 NMOS
XM$3009 BL13 WL6 \$I4580 VSS NMOS L=1u W=3.4u AS=10.88p AD=6.46p PS=13.2u
+ PD=7.2u
* device instance $3010 r0 *1 308.8,183.3 NMOS
XM$3010 \$I4580 \$I4581 VSS VSS NMOS L=1u W=3.4u AS=6.46p AD=6.46p PS=7.2u
+ PD=7.2u
* device instance $3011 r0 *1 313.6,183.3 NMOS
XM$3011 VSS \$I4580 \$I4581 VSS NMOS L=1u W=3.4u AS=6.46p AD=6.46p PS=7.2u
+ PD=7.2u
* device instance $3012 r0 *1 318.4,183.3 NMOS
XM$3012 \$I4581 WL6 BLB13 VSS NMOS L=1u W=3.4u AS=6.46p AD=10.88p PS=7.2u
+ PD=13.2u
* device instance $3013 r0 *1 332,203.7 PMOS
XM$3013 \$I4582 \$I4583 VDD VDD PMOS L=1u W=3.4u AS=10.88p AD=6.46p PS=13.2u
+ PD=7.2u
* device instance $3014 r0 *1 336.8,203.7 PMOS
XM$3014 VDD \$I4582 \$I4583 VDD PMOS L=1u W=3.4u AS=6.46p AD=10.88p PS=7.2u
+ PD=13.2u
* device instance $3015 r0 *1 327.2,183.3 NMOS
XM$3015 BL14 WL6 \$I4582 VSS NMOS L=1u W=3.4u AS=10.88p AD=6.46p PS=13.2u
+ PD=7.2u
* device instance $3016 r0 *1 332,183.3 NMOS
XM$3016 \$I4582 \$I4583 VSS VSS NMOS L=1u W=3.4u AS=6.46p AD=6.46p PS=7.2u
+ PD=7.2u
* device instance $3017 r0 *1 336.8,183.3 NMOS
XM$3017 VSS \$I4582 \$I4583 VSS NMOS L=1u W=3.4u AS=6.46p AD=6.46p PS=7.2u
+ PD=7.2u
* device instance $3018 r0 *1 341.6,183.3 NMOS
XM$3018 \$I4583 WL6 BLB14 VSS NMOS L=1u W=3.4u AS=6.46p AD=10.88p PS=7.2u
+ PD=13.2u
* device instance $3019 r0 *1 355.2,203.7 PMOS
XM$3019 \$I4584 \$I4585 VDD VDD PMOS L=1u W=3.4u AS=10.88p AD=6.46p PS=13.2u
+ PD=7.2u
* device instance $3020 r0 *1 360,203.7 PMOS
XM$3020 VDD \$I4584 \$I4585 VDD PMOS L=1u W=3.4u AS=6.46p AD=10.88p PS=7.2u
+ PD=13.2u
* device instance $3021 r0 *1 350.4,183.3 NMOS
XM$3021 BL15 WL6 \$I4584 VSS NMOS L=1u W=3.4u AS=10.88p AD=6.46p PS=13.2u
+ PD=7.2u
* device instance $3022 r0 *1 355.2,183.3 NMOS
XM$3022 \$I4584 \$I4585 VSS VSS NMOS L=1u W=3.4u AS=6.46p AD=6.46p PS=7.2u
+ PD=7.2u
* device instance $3023 r0 *1 360,183.3 NMOS
XM$3023 VSS \$I4584 \$I4585 VSS NMOS L=1u W=3.4u AS=6.46p AD=6.46p PS=7.2u
+ PD=7.2u
* device instance $3024 r0 *1 364.8,183.3 NMOS
XM$3024 \$I4585 WL6 BLB15 VSS NMOS L=1u W=3.4u AS=6.46p AD=10.88p PS=7.2u
+ PD=13.2u
* device instance $3025 r0 *1 262.4,144.5 PMOS
XM$3025 \$I4586 \$I4587 VDD VDD PMOS L=1u W=3.4u AS=10.88p AD=6.46p PS=13.2u
+ PD=7.2u
* device instance $3026 r0 *1 267.2,144.5 PMOS
XM$3026 VDD \$I4586 \$I4587 VDD PMOS L=1u W=3.4u AS=6.46p AD=10.88p PS=7.2u
+ PD=13.2u
* device instance $3027 r0 *1 257.6,124.1 NMOS
XM$3027 BL11 WL4 \$I4586 VSS NMOS L=1u W=3.4u AS=10.88p AD=6.46p PS=13.2u
+ PD=7.2u
* device instance $3028 r0 *1 262.4,124.1 NMOS
XM$3028 \$I4586 \$I4587 VSS VSS NMOS L=1u W=3.4u AS=6.46p AD=6.46p PS=7.2u
+ PD=7.2u
* device instance $3029 r0 *1 267.2,124.1 NMOS
XM$3029 VSS \$I4586 \$I4587 VSS NMOS L=1u W=3.4u AS=6.46p AD=6.46p PS=7.2u
+ PD=7.2u
* device instance $3030 r0 *1 272,124.1 NMOS
XM$3030 \$I4587 WL4 BLB11 VSS NMOS L=1u W=3.4u AS=6.46p AD=10.88p PS=7.2u
+ PD=13.2u
* device instance $3031 r0 *1 285.6,144.5 PMOS
XM$3031 \$I4588 \$I4589 VDD VDD PMOS L=1u W=3.4u AS=10.88p AD=6.46p PS=13.2u
+ PD=7.2u
* device instance $3032 r0 *1 290.4,144.5 PMOS
XM$3032 VDD \$I4588 \$I4589 VDD PMOS L=1u W=3.4u AS=6.46p AD=10.88p PS=7.2u
+ PD=13.2u
* device instance $3033 r0 *1 280.8,124.1 NMOS
XM$3033 BL12 WL4 \$I4588 VSS NMOS L=1u W=3.4u AS=10.88p AD=6.46p PS=13.2u
+ PD=7.2u
* device instance $3034 r0 *1 285.6,124.1 NMOS
XM$3034 \$I4588 \$I4589 VSS VSS NMOS L=1u W=3.4u AS=6.46p AD=6.46p PS=7.2u
+ PD=7.2u
* device instance $3035 r0 *1 290.4,124.1 NMOS
XM$3035 VSS \$I4588 \$I4589 VSS NMOS L=1u W=3.4u AS=6.46p AD=6.46p PS=7.2u
+ PD=7.2u
* device instance $3036 r0 *1 295.2,124.1 NMOS
XM$3036 \$I4589 WL4 BLB12 VSS NMOS L=1u W=3.4u AS=6.46p AD=10.88p PS=7.2u
+ PD=13.2u
* device instance $3037 r0 *1 308.8,144.5 PMOS
XM$3037 \$I4590 \$I4591 VDD VDD PMOS L=1u W=3.4u AS=10.88p AD=6.46p PS=13.2u
+ PD=7.2u
* device instance $3038 r0 *1 313.6,144.5 PMOS
XM$3038 VDD \$I4590 \$I4591 VDD PMOS L=1u W=3.4u AS=6.46p AD=10.88p PS=7.2u
+ PD=13.2u
* device instance $3039 r0 *1 304,124.1 NMOS
XM$3039 BL13 WL4 \$I4590 VSS NMOS L=1u W=3.4u AS=10.88p AD=6.46p PS=13.2u
+ PD=7.2u
* device instance $3040 r0 *1 308.8,124.1 NMOS
XM$3040 \$I4590 \$I4591 VSS VSS NMOS L=1u W=3.4u AS=6.46p AD=6.46p PS=7.2u
+ PD=7.2u
* device instance $3041 r0 *1 313.6,124.1 NMOS
XM$3041 VSS \$I4590 \$I4591 VSS NMOS L=1u W=3.4u AS=6.46p AD=6.46p PS=7.2u
+ PD=7.2u
* device instance $3042 r0 *1 318.4,124.1 NMOS
XM$3042 \$I4591 WL4 BLB13 VSS NMOS L=1u W=3.4u AS=6.46p AD=10.88p PS=7.2u
+ PD=13.2u
* device instance $3043 r0 *1 332,144.5 PMOS
XM$3043 \$I4592 \$I4593 VDD VDD PMOS L=1u W=3.4u AS=10.88p AD=6.46p PS=13.2u
+ PD=7.2u
* device instance $3044 r0 *1 336.8,144.5 PMOS
XM$3044 VDD \$I4592 \$I4593 VDD PMOS L=1u W=3.4u AS=6.46p AD=10.88p PS=7.2u
+ PD=13.2u
* device instance $3045 r0 *1 327.2,124.1 NMOS
XM$3045 BL14 WL4 \$I4592 VSS NMOS L=1u W=3.4u AS=10.88p AD=6.46p PS=13.2u
+ PD=7.2u
* device instance $3046 r0 *1 332,124.1 NMOS
XM$3046 \$I4592 \$I4593 VSS VSS NMOS L=1u W=3.4u AS=6.46p AD=6.46p PS=7.2u
+ PD=7.2u
* device instance $3047 r0 *1 336.8,124.1 NMOS
XM$3047 VSS \$I4592 \$I4593 VSS NMOS L=1u W=3.4u AS=6.46p AD=6.46p PS=7.2u
+ PD=7.2u
* device instance $3048 r0 *1 341.6,124.1 NMOS
XM$3048 \$I4593 WL4 BLB14 VSS NMOS L=1u W=3.4u AS=6.46p AD=10.88p PS=7.2u
+ PD=13.2u
* device instance $3049 r0 *1 355.2,144.5 PMOS
XM$3049 \$I4594 \$I4595 VDD VDD PMOS L=1u W=3.4u AS=10.88p AD=6.46p PS=13.2u
+ PD=7.2u
* device instance $3050 r0 *1 360,144.5 PMOS
XM$3050 VDD \$I4594 \$I4595 VDD PMOS L=1u W=3.4u AS=6.46p AD=10.88p PS=7.2u
+ PD=13.2u
* device instance $3051 r0 *1 350.4,124.1 NMOS
XM$3051 BL15 WL4 \$I4594 VSS NMOS L=1u W=3.4u AS=10.88p AD=6.46p PS=13.2u
+ PD=7.2u
* device instance $3052 r0 *1 355.2,124.1 NMOS
XM$3052 \$I4594 \$I4595 VSS VSS NMOS L=1u W=3.4u AS=6.46p AD=6.46p PS=7.2u
+ PD=7.2u
* device instance $3053 r0 *1 360,124.1 NMOS
XM$3053 VSS \$I4594 \$I4595 VSS NMOS L=1u W=3.4u AS=6.46p AD=6.46p PS=7.2u
+ PD=7.2u
* device instance $3054 r0 *1 364.8,124.1 NMOS
XM$3054 \$I4595 WL4 BLB15 VSS NMOS L=1u W=3.4u AS=6.46p AD=10.88p PS=7.2u
+ PD=13.2u
* device instance $3055 r0 *1 100,203.7 PMOS
XM$3055 \$I4596 \$I4597 VDD VDD PMOS L=1u W=3.4u AS=10.88p AD=6.46p PS=13.2u
+ PD=7.2u
* device instance $3056 r0 *1 104.8,203.7 PMOS
XM$3056 VDD \$I4596 \$I4597 VDD PMOS L=1u W=3.4u AS=6.46p AD=10.88p PS=7.2u
+ PD=13.2u
* device instance $3057 r0 *1 95.2,183.3 NMOS
XM$3057 BL4 WL6 \$I4596 VSS NMOS L=1u W=3.4u AS=10.88p AD=6.46p PS=13.2u PD=7.2u
* device instance $3058 r0 *1 100,183.3 NMOS
XM$3058 \$I4596 \$I4597 VSS VSS NMOS L=1u W=3.4u AS=6.46p AD=6.46p PS=7.2u
+ PD=7.2u
* device instance $3059 r0 *1 104.8,183.3 NMOS
XM$3059 VSS \$I4596 \$I4597 VSS NMOS L=1u W=3.4u AS=6.46p AD=6.46p PS=7.2u
+ PD=7.2u
* device instance $3060 r0 *1 109.6,183.3 NMOS
XM$3060 \$I4597 WL6 BLB4 VSS NMOS L=1u W=3.4u AS=6.46p AD=10.88p PS=7.2u
+ PD=13.2u
* device instance $3061 r0 *1 123.2,203.7 PMOS
XM$3061 \$I4598 \$I4599 VDD VDD PMOS L=1u W=3.4u AS=10.88p AD=6.46p PS=13.2u
+ PD=7.2u
* device instance $3062 r0 *1 128,203.7 PMOS
XM$3062 VDD \$I4598 \$I4599 VDD PMOS L=1u W=3.4u AS=6.46p AD=10.88p PS=7.2u
+ PD=13.2u
* device instance $3063 r0 *1 118.4,183.3 NMOS
XM$3063 BL5 WL6 \$I4598 VSS NMOS L=1u W=3.4u AS=10.88p AD=6.46p PS=13.2u PD=7.2u
* device instance $3064 r0 *1 123.2,183.3 NMOS
XM$3064 \$I4598 \$I4599 VSS VSS NMOS L=1u W=3.4u AS=6.46p AD=6.46p PS=7.2u
+ PD=7.2u
* device instance $3065 r0 *1 128,183.3 NMOS
XM$3065 VSS \$I4598 \$I4599 VSS NMOS L=1u W=3.4u AS=6.46p AD=6.46p PS=7.2u
+ PD=7.2u
* device instance $3066 r0 *1 132.8,183.3 NMOS
XM$3066 \$I4599 WL6 BLB5 VSS NMOS L=1u W=3.4u AS=6.46p AD=10.88p PS=7.2u
+ PD=13.2u
* device instance $3067 r0 *1 285.6,203.7 PMOS
XM$3067 \$I4600 \$I4601 VDD VDD PMOS L=1u W=3.4u AS=10.88p AD=6.46p PS=13.2u
+ PD=7.2u
* device instance $3068 r0 *1 290.4,203.7 PMOS
XM$3068 VDD \$I4600 \$I4601 VDD PMOS L=1u W=3.4u AS=6.46p AD=10.88p PS=7.2u
+ PD=13.2u
* device instance $3069 r0 *1 280.8,183.3 NMOS
XM$3069 BL12 WL6 \$I4600 VSS NMOS L=1u W=3.4u AS=10.88p AD=6.46p PS=13.2u
+ PD=7.2u
* device instance $3070 r0 *1 285.6,183.3 NMOS
XM$3070 \$I4600 \$I4601 VSS VSS NMOS L=1u W=3.4u AS=6.46p AD=6.46p PS=7.2u
+ PD=7.2u
* device instance $3071 r0 *1 290.4,183.3 NMOS
XM$3071 VSS \$I4600 \$I4601 VSS NMOS L=1u W=3.4u AS=6.46p AD=6.46p PS=7.2u
+ PD=7.2u
* device instance $3072 r0 *1 295.2,183.3 NMOS
XM$3072 \$I4601 WL6 BLB12 VSS NMOS L=1u W=3.4u AS=6.46p AD=10.88p PS=7.2u
+ PD=13.2u
.ENDS wlstrap16_16x32

.subckt sense_amp_7t BL BLB SAE SOUT SOUTB VDD VSS
*.ipin BL
*.ipin BLB
*.opin SOUT
*.opin SOUTB
*.iopin VSS
*.iopin VDD
*.ipin SAE
XXP_ISO_L SOUT SAE BL VDD PMOS w=3.4u l=1u nrd=0 nrs=0
XXP_ISO_R SOUTB SAE BLB VDD PMOS w=3.4u l=1u nrd=0 nrs=0
XXP_L SOUT SOUTB VDD VDD PMOS w=3.4u l=1u nrd=0 nrs=0
XXN_L SOUT SOUTB net1 VSS NMOS w=3.4u l=1u nrd=0 nrs=0
XXP_R SOUTB SOUT VDD VDD PMOS w=3.4u l=1u nrd=0 nrs=0
XXN_R SOUTB SOUT net1 VSS NMOS w=3.4u l=1u nrd=0 nrs=0
XXN_TAIL net1 SAE VSS VSS NMOS w=3.4u l=1u nrd=0 nrs=0
.ends
.subckt write_control DIN WRITE_EN PD_Y PD_YB VDD VSS
*.ipin DIN
*.ipin WRITE_EN
*.opin PD_Y
*.opin PD_YB
*.iopin VDD
*.iopin VSS
xdin_inv VDD DIN DIN_B VSS INV_X1
xdec0 VDD PD_Y_B DIN_B WRITE_EN VSS NAND2
xdrv0 VDD PD_Y_B PD_Y VSS INV_X1
xdec1 VDD PD_YB_B DIN WRITE_EN VSS NAND2
xdrv1 VDD PD_YB_B PD_YB VSS INV_X1
.ends
.subckt INV_X1 VDD A Y GND
*.ipin A
*.opin Y
*.iopin GND
*.iopin VDD
XM7 Y A VDD VDD PMOS w=10.2u l=1u nrd=0 nrs=0
XM2 Y A GND GND NMOS w=3.4u l=1u nrd=0 nrs=0
.ends
.subckt NAND2 VDD Y A B GND
*.ipin B
*.ipin A
*.opin Y
*.iopin GND
*.iopin VDD
XM7 Y A VDD VDD PMOS w=10.2u l=1u nrd=0 nrs=0
XM1 Y B VDD VDD PMOS w=10.2u l=1u nrd=0 nrs=0
XM2 Y B net1 GND NMOS w=3.4u l=1u nrd=0 nrs=0
XM3 net1 A GND GND NMOS w=3.4u l=1u nrd=0 nrs=0
.ends
.subckt AND2_X1 VDD Y A B GND
*.opin Y
*.ipin A
*.ipin B
*.iopin VDD
*.iopin GND
XM7 net1 B VDD VDD PMOS w=10.2u l=1u nrd=0 nrs=0
XM1 net1 A VDD VDD PMOS w=10.2u l=1u nrd=0 nrs=0
XM2 Y net1 VDD VDD PMOS w=10.2u l=1u nrd=0 nrs=0
XM3 Y net1 GND GND NMOS w=3.4u l=1u nrd=0 nrs=0
XM4 net1 A net2 GND NMOS w=3.4u l=1u nrd=0 nrs=0
XM5 net2 B GND GND NMOS w=3.4u l=1u nrd=0 nrs=0
.ends
.subckt DFFR VDD QB D Q RST GND CK
*.iopin VDD
*.iopin GND
*.ipin CK
*.ipin D
*.opin Q
*.opin QB
*.ipin RST
XM2 net2 D VDD VDD PMOS w=10.2u l=1u nrd=0 nrs=0
XM1 net3 CLK net2 VDD PMOS w=10.2u l=1u nrd=0 nrs=0
XM11 net5 net8 VDD VDD PMOS w=10.2u l=1u nrd=0 nrs=0
XM12 net3 CKB net5 VDD PMOS w=10.2u l=1u nrd=0 nrs=0
XM15 net7 net3 VDD VDD PMOS w=10.2u l=1u nrd=0 nrs=0
XM16 net8 RST net7 VDD PMOS w=10.2u l=1u nrd=0 nrs=0
XM18 net9 net8 VDD VDD PMOS w=10.2u l=1u nrd=0 nrs=0
XM19 net10 CKB net9 VDD PMOS w=10.2u l=1u nrd=0 nrs=0
XM23 net12 net14 VDD VDD PMOS w=10.2u l=1u nrd=0 nrs=0
XM24 net10 CLK net12 VDD PMOS w=10.2u l=1u nrd=0 nrs=0
XM27 net15 net10 VDD VDD PMOS w=10.2u l=1u nrd=0 nrs=0
XM28 net14 RST net15 VDD PMOS w=10.2u l=1u nrd=0 nrs=0
XM31 QB net14 VDD VDD PMOS w=10.2u l=1u nrd=0 nrs=0
XM33 Q QB VDD VDD PMOS w=10.2u l=1u nrd=0 nrs=0
XM35 QB net14 GND GND NMOS w=3.4u l=1u nrd=0 nrs=0
XM32 Q QB GND GND NMOS w=3.4u l=1u nrd=0 nrs=0
XM29 net14 RST GND GND NMOS w=3.4u l=1u nrd=0 nrs=0
XM30 net14 net10 GND GND NMOS w=3.4u l=1u nrd=0 nrs=0
XM25 net10 CKB net13 GND NMOS w=3.4u l=1u nrd=0 nrs=0
XM26 net13 net14 GND GND NMOS w=3.4u l=1u nrd=0 nrs=0
XM20 net10 CLK net11 GND NMOS w=3.4u l=1u nrd=0 nrs=0
XM21 net11 net8 GND GND NMOS w=3.4u l=1u nrd=0 nrs=0
XM17 net8 net3 GND GND NMOS w=3.4u l=1u nrd=0 nrs=0
XM22 net8 RST GND GND NMOS w=3.4u l=1u nrd=0 nrs=0
XM13 net3 CLK net6 GND NMOS w=3.4u l=1u nrd=0 nrs=0
XM14 net6 net8 GND GND NMOS w=3.4u l=1u nrd=0 nrs=0
XM7 net3 CKB net4 GND NMOS w=3.4u l=1u nrd=0 nrs=0
XM8 net4 D GND GND NMOS w=3.4u l=1u nrd=0 nrs=0
XM3 net1 CK VDD VDD PMOS w=10.2u l=1u nrd=0 nrs=0
XM4 CLK net1 VDD VDD PMOS w=10.2u l=1u nrd=0 nrs=0
XM5 CKB CLK VDD VDD PMOS w=10.2u l=1u nrd=0 nrs=0
XM34 net1 CK GND GND NMOS w=3.4u l=1u nrd=0 nrs=0
XM6 CLK net1 GND GND NMOS w=3.4u l=1u nrd=0 nrs=0
XM9 CKB CLK GND GND NMOS w=3.4u l=1u nrd=0 nrs=0
.ends
.subckt XOR2 VDD Y A B GND
*.iopin VDD
*.iopin GND
*.ipin A
*.ipin B
*.opin Y
XM10 net1 A VDD VDD PMOS w=10.2u l=1u nrd=0 nrs=0
XM1 net2 B net1 VDD PMOS w=10.2u l=1u nrd=0 nrs=0
XM8 net3 B VDD VDD PMOS w=10.2u l=1u nrd=0 nrs=0
XM2 net3 A VDD VDD PMOS w=10.2u l=1u nrd=0 nrs=0
XM9 Y net2 net3 VDD PMOS w=10.2u l=1u nrd=0 nrs=0
XM3 net2 A GND GND NMOS w=3.4u l=1u nrd=0 nrs=0
XM4 net2 B GND GND NMOS w=3.4u l=1u nrd=0 nrs=0
XM5 Y net2 GND GND NMOS w=3.4u l=1u nrd=0 nrs=0
XM7 net4 B GND GND NMOS w=3.4u l=1u nrd=0 nrs=0
XM6 Y A net4 GND NMOS w=3.4u l=1u nrd=0 nrs=0
.ends
.subckt AND3_X1 C VDD Y A B GND
*.opin Y
*.ipin A
*.ipin B
*.iopin VDD
*.iopin GND
*.ipin C
XM4 net1 C VDD VDD PMOS w=10.2u l=1u nrd=0 nrs=0
XM2 net1 B VDD VDD PMOS w=10.2u l=1u nrd=0 nrs=0
XM3 Y net1 VDD VDD PMOS w=10.2u l=1u nrd=0 nrs=0
XM1 VDD A net1 VDD PMOS w=10.2u l=1u nrd=0 nrs=0
XM8 Y net1 GND GND NMOS w=3.4u l=1u nrd=0 nrs=0
XM5 net1 A net3 GND NMOS w=3.4u l=1u nrd=0 nrs=0
XM6 net3 B net2 GND NMOS w=3.4u l=1u nrd=0 nrs=0
XM7 net2 C GND GND NMOS w=3.4u l=1u nrd=0 nrs=0
.ends
.subckt OR2 VDD Y A B GND
*.ipin A
*.ipin B
*.opin Y
*.iopin VDD
*.iopin GND
XM7 net2 B VDD VDD PMOS w=10.2u l=1u nrd=0 nrs=0
XM2 net1 A net2 VDD PMOS w=10.2u l=1u nrd=0 nrs=0
XM4 Y net1 VDD VDD PMOS w=10.2u l=1u nrd=0 nrs=0
XM1 net1 B GND GND NMOS w=3.4u l=1u nrd=0 nrs=0
XM3 net1 A GND GND NMOS w=3.4u l=1u nrd=0 nrs=0
XM5 Y net1 GND GND NMOS w=3.4u l=1u nrd=0 nrs=0
.ends
.subckt AND4_X1 D C VDD Y A B GND
*.opin Y
*.ipin A
*.ipin B
*.iopin VDD
*.iopin GND
*.ipin C
*.ipin D
XM7 net1 A net4 GND NMOS w=3.4u l=1u nrd=0 nrs=0
XM5 net3 C net2 GND NMOS w=3.4u l=1u nrd=0 nrs=0
XM8 Y net1 GND GND NMOS w=3.4u l=1u nrd=0 nrs=0
XM10 net2 D GND GND NMOS w=3.4u l=1u nrd=0 nrs=0
XM6 net4 B net3 GND NMOS w=3.4u l=1u nrd=0 nrs=0
XM11 net1 A VDD VDD PMOS w=10.2u l=1u nrd=0 nrs=0
XM1 net1 D VDD VDD PMOS w=10.2u l=1u nrd=0 nrs=0
XM3 net1 C VDD VDD PMOS w=10.2u l=1u nrd=0 nrs=0
XM4 Y net1 VDD VDD PMOS w=10.2u l=1u nrd=0 nrs=0
XM2 net1 B VDD VDD PMOS w=10.2u l=1u nrd=0 nrs=0
.ends
.subckt OR4 A B C D VDD Y GND
*.ipin B
*.ipin A
*.opin Y
*.iopin VDD
*.iopin GND
*.ipin C
*.ipin D
XM10 net1 B VDD VDD PMOS w=10.2u l=1u nrd=0 nrs=0
XM2 net2 A net1 VDD PMOS w=10.2u l=1u nrd=0 nrs=0
XM3 net4 C net2 VDD PMOS w=10.2u l=1u nrd=0 nrs=0
XM7 Y net3 VDD VDD PMOS w=10.2u l=1u nrd=0 nrs=0
XM9 net4 D net3 VDD PMOS w=10.2u l=1u nrd=0 nrs=0
XM11 net3 A GND GND NMOS w=3.4u l=1u nrd=0 nrs=0
XM1 net3 B GND GND NMOS w=3.4u l=1u nrd=0 nrs=0
XM4 net3 C GND GND NMOS w=3.4u l=1u nrd=0 nrs=0
XM5 net3 D GND GND NMOS w=3.4u l=1u nrd=0 nrs=0
XM6 Y net3 GND GND NMOS w=3.4u l=1u nrd=0 nrs=0
.ends
.subckt OR3 C VDD Y A B GND
*.ipin A
*.ipin B
*.opin Y
*.iopin VDD
*.iopin GND
*.ipin C
XM8 net1 B VDD VDD PMOS w=10.2u l=1u nrd=0 nrs=0
XM2 net2 A net1 VDD PMOS w=10.2u l=1u nrd=0 nrs=0
XM3 net3 C net2 VDD PMOS w=10.2u l=1u nrd=0 nrs=0
XM7 Y net3 VDD VDD PMOS w=10.2u l=1u nrd=0 nrs=0
XM9 Y net3 GND GND NMOS w=3.4u l=1u nrd=0 nrs=0
XM1 net3 C GND GND NMOS w=3.4u l=1u nrd=0 nrs=0
XM4 net3 A GND GND NMOS w=3.4u l=1u nrd=0 nrs=0
XM5 net3 B GND GND NMOS w=3.4u l=1u nrd=0 nrs=0
.ends
.subckt MUX2 A B S VDD Y GND
*.ipin B
*.ipin S
*.opin Y
*.iopin VDD
*.iopin GND
*.ipin A
XM13 net1 S VDD VDD PMOS w=6.8u l=1u nrd=0 nrs=0
XM9 net2 B VDD VDD PMOS w=6.8u l=1u nrd=0 nrs=0
XM8 net4 net1 net2 VDD PMOS w=6.8u l=1u nrd=0 nrs=0
XM10 Y net4 VDD VDD PMOS w=5.1u l=1u nrd=0 nrs=0 m=2
XM2 net4 S net3 VDD PMOS w=6.8u l=1u nrd=0 nrs=0
XM12 net1 S GND GND NMOS w=3.4u l=1u nrd=0 nrs=0
XM3 net2 B GND GND NMOS w=3.4u l=1u nrd=0 nrs=0
XM1 Y net4 GND GND NMOS w=3.4u l=1u nrd=0 nrs=0
XM5 net3 A GND GND NMOS w=3.4u l=1u nrd=0 nrs=0
XM6 net4 S net2 GND NMOS w=3.4u l=1u nrd=0 nrs=0 m=2
XM4 net4 net1 net3 GND NMOS w=3.4u l=1u nrd=0 nrs=0 m=2
XM7 net3 A VDD VDD PMOS w=6.8u l=1u nrd=0 nrs=0
.ends
