.subckt serial_macro_16x16 CLK RESET SDI WE SDO VDD VSS
Xg1 VDD logic1 C0B C4B VSS AND2_X1
Xff_C0 VDD C0B logic1 C0 RESET VSS CLK DFFR
Xg3 VDD toggle1 C1 C0 VSS XOR2
Xg4 VDD logic4 toggle1 C4B VSS AND2_X1
Xff_C1 VDD C1B logic4 C1 RESET VSS CLK DFFR
Xg6 VDD logic6 C0 C1 VSS AND2_X1
Xg7 VDD toggle2 C2 logic6 VSS XOR2
Xg8 VDD logic8 toggle2 C4B VSS AND2_X1
Xff_C2 VDD C2B logic8 C2 RESET VSS CLK DFFR
Xg10 C2 VDD logic10 C0 C1 VSS AND3_X1
Xg11 VDD toggle3 C3 logic10 VSS XOR2
Xg12 VDD logic12 toggle3 C4B VSS AND2_X1
Xff_C3 VDD C3B logic12 C3 RESET VSS CLK DFFR
Xg14 C3 C2 VDD logic14 C0 C1 VSS AND4_X1
Xg15 VDD toggle4 C4 logic14 VSS XOR2
Xg16 VDD logic16 toggle4 C4B VSS AND2_X1
Xff_C4 VDD C4B logic16 C4 RESET VSS CLK DFFR
Xg18 C3 C2B VDD logic18 C0B C1B VSS AND4_X1
Xg19 VDD logic19 logic18 C4B VSS AND2_X1
Xg20 VDD logic20 C3B C4B VSS AND2_X1
Xg21 VDD logic21 logic19 logic20 VSS OR2
Xg22 C3 C2B VDD logic22 C0 C1B VSS AND4_X1
Xg23 VDD logic23 logic22 C4B VSS AND2_X1
Xg24 C3 C2B VDD logic24 C0B C1 VSS AND4_X1
Xg25 VDD logic25 logic24 C4B VSS AND2_X1
Xg26 C3 C2B VDD logic26 C0 C1 VSS AND4_X1
Xg27 VDD logic27 logic26 C4B VSS AND2_X1
Xg28 C3 C2 VDD logic28 C0B C1B VSS AND4_X1
Xg29 VDD logic29 logic28 C4B VSS AND2_X1
Xg30 C3 C2 VDD logic30 C0 C1B VSS AND4_X1
Xg31 VDD logic31 logic30 C4B VSS AND2_X1
Xg32 C3 C2 VDD logic32 C0B C1 VSS AND4_X1
Xg33 VDD logic33 logic32 C4B VSS AND2_X1
Xg34 C3 C2 VDD logic34 C0 C1 VSS AND4_X1
Xg35 VDD logic35 logic34 C4B VSS AND2_X1
Xg36 C3B C2B VDD logic36 C0B C1B VSS AND4_X1
Xg37 VDD logic37 logic36 C4 VSS AND2_X1
Xff_PC_ON VDD PREB logic23 PC_ON RESET VSS CLK DFFR
Xg39 VDD logic39 logic29 logic31 VSS OR2
Xff_WL_EN VDD WL_ENB logic39 WL_EN RESET VSS CLK DFFR
Xg41 logic27 logic29 logic31 logic33 VDD logic41 VSS OR4
Xg42 VDD logic42 logic41 W VSS AND2_X1
Xff_WRITE_EN VDD WRITE_ENB logic42 WRITE_EN RESET VSS CLK DFFR
Xg44 VDD WE WE_B VSS INV_X1
Xg45 VDD logic45 WE_B logic23 VSS AND2_X1
Xg46 logic29 VDD logic46 logic25 logic27 VSS OR3
Xg47 VDD logic47 logic46 WB VSS AND2_X1
Xg48 VDD logic48 logic45 logic47 VSS OR2
Xff_TRACK VDD SAE logic48 TRACK RESET VSS CLK DFFR
Xg50 SR0 SDI logic21 VDD SR0_next VSS MUX2
Xff_SR0 VDD SR0B SR0_next SR0 RESET VSS CLK DFFR
Xg52 SR1 SR0 logic21 VDD SR1_next VSS MUX2
Xff_SR1 VDD SR1B SR1_next SR1 RESET VSS CLK DFFR
Xg54 SR2 SR1 logic21 VDD SR2_next VSS MUX2
Xff_SR2 VDD SR2B SR2_next SR2 RESET VSS CLK DFFR
Xg56 SR3 SR2 logic21 VDD SR3_next VSS MUX2
Xff_SR3 VDD SR3B SR3_next SR3 RESET VSS CLK DFFR
Xg58 SR4 SR3 logic21 VDD SR4_next VSS MUX2
Xff_SR4 VDD SR4B SR4_next SR4 RESET VSS CLK DFFR
Xg60 SR5 SR4 logic21 VDD SR5_next VSS MUX2
Xff_SR5 VDD SR5B SR5_next SR5 RESET VSS CLK DFFR
Xg62 SR6 SR5 logic21 VDD SR6_next VSS MUX2
Xff_SR6 VDD SR6B SR6_next SR6 RESET VSS CLK DFFR
Xg64 SR7 SR6 logic21 VDD SR7_next VSS MUX2
Xff_SR7 VDD SR7B SR7_next SR7 RESET VSS CLK DFFR
Xg66 SR8 SR7 logic21 VDD SR8_next VSS MUX2
Xff_SR8 VDD SR8B SR8_next SR8 RESET VSS CLK DFFR
Xg68 DIN SR0 logic23 VDD DIN_next VSS MUX2
Xff_DIN VDD DINB DIN_next DIN RESET VSS CLK DFFR
Xg70 CA0 SR1 logic23 VDD CA0_next VSS MUX2
Xff_CA0 VDD CA0B CA0_next CA0 RESET VSS CLK DFFR
Xg72 CA1 SR2 logic23 VDD CA1_next VSS MUX2
Xff_CA1 VDD CA1B CA1_next CA1 RESET VSS CLK DFFR
Xg74 CA2 SR3 logic23 VDD CA2_next VSS MUX2
Xff_CA2 VDD CA2B CA2_next CA2 RESET VSS CLK DFFR
Xg76 CA3 SR4 logic23 VDD CA3_next VSS MUX2
Xff_CA3 VDD CA3B CA3_next CA3 RESET VSS CLK DFFR
Xg78 RA0 SR5 logic23 VDD RA0_next VSS MUX2
Xff_RA0 VDD RA0B RA0_next RA0 RESET VSS CLK DFFR
Xg80 RA1 SR6 logic23 VDD RA1_next VSS MUX2
Xff_RA1 VDD RA1B RA1_next RA1 RESET VSS CLK DFFR
Xg82 RA2 SR7 logic23 VDD RA2_next VSS MUX2
Xff_RA2 VDD RA2B RA2_next RA2 RESET VSS CLK DFFR
Xg84 RA3 SR8 logic23 VDD RA3_next VSS MUX2
Xff_RA3 VDD RA3B RA3_next RA3 RESET VSS CLK DFFR
Xg86 W WE logic23 VDD W_next VSS MUX2
Xff_W VDD WB W_next W RESET VSS CLK DFFR
Xg88 VDD logic88 logic35 WB VSS AND2_X1
Xg89 SDO SOUT logic88 VDD SDO_next VSS MUX2
Xff_SDO VDD SDOB SDO_next SDO RESET VSS CLK DFFR
Xg91 VDD logic91 RA0B RA1B VSS AND2_X1
Xg92 VDD logic92 RA0 RA1B VSS AND2_X1
Xg93 VDD logic93 RA0B RA1 VSS AND2_X1
Xg94 VDD logic94 RA0 RA1 VSS AND2_X1
Xg95 VDD logic95 RA2B RA3B VSS AND2_X1
Xg96 VDD logic96 RA2 RA3B VSS AND2_X1
Xg97 VDD logic97 RA2B RA3 VSS AND2_X1
Xg98 VDD logic98 RA2 RA3 VSS AND2_X1
Xg99 WL_EN VDD WL0 logic91 logic95 VSS AND3_X1
Xg100 WL_EN VDD WL1 logic92 logic95 VSS AND3_X1
Xg101 WL_EN VDD WL2 logic93 logic95 VSS AND3_X1
Xg102 WL_EN VDD WL3 logic94 logic95 VSS AND3_X1
Xg103 WL_EN VDD WL4 logic91 logic96 VSS AND3_X1
Xg104 WL_EN VDD WL5 logic92 logic96 VSS AND3_X1
Xg105 WL_EN VDD WL6 logic93 logic96 VSS AND3_X1
Xg106 WL_EN VDD WL7 logic94 logic96 VSS AND3_X1
Xg107 WL_EN VDD WL8 logic91 logic97 VSS AND3_X1
Xg108 WL_EN VDD WL9 logic92 logic97 VSS AND3_X1
Xg109 WL_EN VDD WL10 logic93 logic97 VSS AND3_X1
Xg110 WL_EN VDD WL11 logic94 logic97 VSS AND3_X1
Xg111 WL_EN VDD WL12 logic91 logic98 VSS AND3_X1
Xg112 WL_EN VDD WL13 logic92 logic98 VSS AND3_X1
Xg113 WL_EN VDD WL14 logic93 logic98 VSS AND3_X1
Xg114 WL_EN VDD WL15 logic94 logic98 VSS AND3_X1
Xg115 VDD logic115 CA0B CA1B VSS AND2_X1
Xg116 VDD logic116 CA0 CA1B VSS AND2_X1
Xg117 VDD logic117 CA0B CA1 VSS AND2_X1
Xg118 VDD logic118 CA0 CA1 VSS AND2_X1
Xg119 VDD logic119 CA2B CA3B VSS AND2_X1
Xg120 VDD logic120 CA2 CA3B VSS AND2_X1
Xg121 VDD logic121 CA2B CA3 VSS AND2_X1
Xg122 VDD logic122 CA2 CA3 VSS AND2_X1
Xg123 VDD COL0 logic115 logic119 VSS AND2_X1
Xg124 VDD COL1 logic116 logic119 VSS AND2_X1
Xg125 VDD COL2 logic117 logic119 VSS AND2_X1
Xg126 VDD COL3 logic118 logic119 VSS AND2_X1
Xg127 VDD COL4 logic115 logic120 VSS AND2_X1
Xg128 VDD COL5 logic116 logic120 VSS AND2_X1
Xg129 VDD COL6 logic117 logic120 VSS AND2_X1
Xg130 VDD COL7 logic118 logic120 VSS AND2_X1
Xg131 VDD COL8 logic115 logic121 VSS AND2_X1
Xg132 VDD COL9 logic116 logic121 VSS AND2_X1
Xg133 VDD COL10 logic117 logic121 VSS AND2_X1
Xg134 VDD COL11 logic118 logic121 VSS AND2_X1
Xg135 VDD COL12 logic115 logic122 VSS AND2_X1
Xg136 VDD COL13 logic116 logic122 VSS AND2_X1
Xg137 VDD COL14 logic117 logic122 VSS AND2_X1
Xg138 VDD COL15 logic118 logic122 VSS AND2_X1
Xg139 DIN WRITE_EN PD_Y PD_YB VDD VSS write_control
Xmemory BL0 BL1 BL10 BL11 BL12 BL13 BL14 BL15 BL2 BL3 BL4 BL5 BL6 BL7 BL8 BL9 BLB0 BLB1 BLB10 BLB11 BLB12 BLB13 BLB14 BLB15 BLB2 BLB3 BLB4 BLB5 BLB6 BLB7 BLB8 BLB9 VDD VSS WL0 WL1 WL10 WL11 WL12 WL13 WL14 WL15 WL2 WL3 WL4 WL5 WL6 WL7 WL8 WL9 wlstrap16_16x16
XP_BL0 BL0 PREB VDD VDD PMOS W=10.2u L=1u
XM_BL0 BL0 COL0 Y VSS NMOS W=3.4u L=1u
XP_BLB0 BLB0 PREB VDD VDD PMOS W=10.2u L=1u
XM_BLB0 BLB0 COL0 YB VSS NMOS W=3.4u L=1u
XP_BL1 BL1 PREB VDD VDD PMOS W=10.2u L=1u
XM_BL1 BL1 COL1 Y VSS NMOS W=3.4u L=1u
XP_BLB1 BLB1 PREB VDD VDD PMOS W=10.2u L=1u
XM_BLB1 BLB1 COL1 YB VSS NMOS W=3.4u L=1u
XP_BL2 BL2 PREB VDD VDD PMOS W=10.2u L=1u
XM_BL2 BL2 COL2 Y VSS NMOS W=3.4u L=1u
XP_BLB2 BLB2 PREB VDD VDD PMOS W=10.2u L=1u
XM_BLB2 BLB2 COL2 YB VSS NMOS W=3.4u L=1u
XP_BL3 BL3 PREB VDD VDD PMOS W=10.2u L=1u
XM_BL3 BL3 COL3 Y VSS NMOS W=3.4u L=1u
XP_BLB3 BLB3 PREB VDD VDD PMOS W=10.2u L=1u
XM_BLB3 BLB3 COL3 YB VSS NMOS W=3.4u L=1u
XP_BL4 BL4 PREB VDD VDD PMOS W=10.2u L=1u
XM_BL4 BL4 COL4 Y VSS NMOS W=3.4u L=1u
XP_BLB4 BLB4 PREB VDD VDD PMOS W=10.2u L=1u
XM_BLB4 BLB4 COL4 YB VSS NMOS W=3.4u L=1u
XP_BL5 BL5 PREB VDD VDD PMOS W=10.2u L=1u
XM_BL5 BL5 COL5 Y VSS NMOS W=3.4u L=1u
XP_BLB5 BLB5 PREB VDD VDD PMOS W=10.2u L=1u
XM_BLB5 BLB5 COL5 YB VSS NMOS W=3.4u L=1u
XP_BL6 BL6 PREB VDD VDD PMOS W=10.2u L=1u
XM_BL6 BL6 COL6 Y VSS NMOS W=3.4u L=1u
XP_BLB6 BLB6 PREB VDD VDD PMOS W=10.2u L=1u
XM_BLB6 BLB6 COL6 YB VSS NMOS W=3.4u L=1u
XP_BL7 BL7 PREB VDD VDD PMOS W=10.2u L=1u
XM_BL7 BL7 COL7 Y VSS NMOS W=3.4u L=1u
XP_BLB7 BLB7 PREB VDD VDD PMOS W=10.2u L=1u
XM_BLB7 BLB7 COL7 YB VSS NMOS W=3.4u L=1u
XP_BL8 BL8 PREB VDD VDD PMOS W=10.2u L=1u
XM_BL8 BL8 COL8 Y VSS NMOS W=3.4u L=1u
XP_BLB8 BLB8 PREB VDD VDD PMOS W=10.2u L=1u
XM_BLB8 BLB8 COL8 YB VSS NMOS W=3.4u L=1u
XP_BL9 BL9 PREB VDD VDD PMOS W=10.2u L=1u
XM_BL9 BL9 COL9 Y VSS NMOS W=3.4u L=1u
XP_BLB9 BLB9 PREB VDD VDD PMOS W=10.2u L=1u
XM_BLB9 BLB9 COL9 YB VSS NMOS W=3.4u L=1u
XP_BL10 BL10 PREB VDD VDD PMOS W=10.2u L=1u
XM_BL10 BL10 COL10 Y VSS NMOS W=3.4u L=1u
XP_BLB10 BLB10 PREB VDD VDD PMOS W=10.2u L=1u
XM_BLB10 BLB10 COL10 YB VSS NMOS W=3.4u L=1u
XP_BL11 BL11 PREB VDD VDD PMOS W=10.2u L=1u
XM_BL11 BL11 COL11 Y VSS NMOS W=3.4u L=1u
XP_BLB11 BLB11 PREB VDD VDD PMOS W=10.2u L=1u
XM_BLB11 BLB11 COL11 YB VSS NMOS W=3.4u L=1u
XP_BL12 BL12 PREB VDD VDD PMOS W=10.2u L=1u
XM_BL12 BL12 COL12 Y VSS NMOS W=3.4u L=1u
XP_BLB12 BLB12 PREB VDD VDD PMOS W=10.2u L=1u
XM_BLB12 BLB12 COL12 YB VSS NMOS W=3.4u L=1u
XP_BL13 BL13 PREB VDD VDD PMOS W=10.2u L=1u
XM_BL13 BL13 COL13 Y VSS NMOS W=3.4u L=1u
XP_BLB13 BLB13 PREB VDD VDD PMOS W=10.2u L=1u
XM_BLB13 BLB13 COL13 YB VSS NMOS W=3.4u L=1u
XP_BL14 BL14 PREB VDD VDD PMOS W=10.2u L=1u
XM_BL14 BL14 COL14 Y VSS NMOS W=3.4u L=1u
XP_BLB14 BLB14 PREB VDD VDD PMOS W=10.2u L=1u
XM_BLB14 BLB14 COL14 YB VSS NMOS W=3.4u L=1u
XP_BL15 BL15 PREB VDD VDD PMOS W=10.2u L=1u
XM_BL15 BL15 COL15 Y VSS NMOS W=3.4u L=1u
XP_BLB15 BLB15 PREB VDD VDD PMOS W=10.2u L=1u
XM_BLB15 BLB15 COL15 YB VSS NMOS W=3.4u L=1u
XP_Y Y PREB VDD VDD PMOS W=10.2u L=1u
XW_Y Y PD_Y VSS VSS NMOS W=3.4u L=1u
XP_YB YB PREB VDD VDD PMOS W=10.2u L=1u
XW_YB YB PD_YB VSS VSS NMOS W=3.4u L=1u
Xg140 Y YB SAE SOUT SOUTB VDD VSS sense_amp_7t
.ends
* Created by KLayout
*** My special header ***

* cell wlstrap16_16x16
* pin BL0
* pin BL1
* pin BL10
* pin BL11
* pin BL12
* pin BL13
* pin BL14
* pin BL15
* pin BL2
* pin BL3
* pin BL4
* pin BL5
* pin BL6
* pin BL7
* pin BL8
* pin BL9
* pin BLB0
* pin BLB1
* pin BLB10
* pin BLB11
* pin BLB12
* pin BLB13
* pin BLB14
* pin BLB15
* pin BLB2
* pin BLB3
* pin BLB4
* pin BLB5
* pin BLB6
* pin BLB7
* pin BLB8
* pin BLB9
* pin VDD
* pin VSS
* pin WL0
* pin WL1
* pin WL10
* pin WL11
* pin WL12
* pin WL13
* pin WL14
* pin WL15
* pin WL2
* pin WL3
* pin WL4
* pin WL5
* pin WL6
* pin WL7
* pin WL8
* pin WL9
.SUBCKT wlstrap16_16x16 BL0 BL1 BL10 BL11 BL12 BL13 BL14 BL15 BL2 BL3 BL4 BL5
+ BL6 BL7 BL8 BL9 BLB0 BLB1 BLB10 BLB11 BLB12 BLB13 BLB14 BLB15 BLB2 BLB3 BLB4
+ BLB5 BLB6 BLB7 BLB8 BLB9 VDD VSS WL0 WL1 WL10 WL11 WL12 WL13 WL14 WL15 WL2
+ WL3 WL4 WL5 WL6 WL7 WL8 WL9
* device instance $1 r0 *1 239.2,26.1 PMOS
XM$1 \$I1786 \$I1787 VDD VDD PMOS L=1u W=3.4u AS=10.88p AD=6.46p PS=13.2u
+ PD=7.2u
* device instance $2 r0 *1 244,26.1 PMOS
XM$2 VDD \$I1786 \$I1787 VDD PMOS L=1u W=3.4u AS=6.46p AD=10.88p PS=7.2u
+ PD=13.2u
* device instance $3 r0 *1 234.4,5.7 NMOS
XM$3 BL10 WL0 \$I1786 VSS NMOS L=1u W=3.4u AS=10.88p AD=6.46p PS=13.2u PD=7.2u
* device instance $4 r0 *1 239.2,5.7 NMOS
XM$4 \$I1786 \$I1787 VSS VSS NMOS L=1u W=3.4u AS=6.46p AD=6.46p PS=7.2u PD=7.2u
* device instance $5 r0 *1 244,5.7 NMOS
XM$5 VSS \$I1786 \$I1787 VSS NMOS L=1u W=3.4u AS=6.46p AD=6.46p PS=7.2u PD=7.2u
* device instance $6 r0 *1 248.8,5.7 NMOS
XM$6 \$I1787 WL0 BLB10 VSS NMOS L=1u W=3.4u AS=6.46p AD=10.88p PS=7.2u PD=13.2u
* device instance $7 r0 *1 216,26.1 PMOS
XM$7 \$I1788 \$I1789 VDD VDD PMOS L=1u W=3.4u AS=10.88p AD=6.46p PS=13.2u
+ PD=7.2u
* device instance $8 r0 *1 220.8,26.1 PMOS
XM$8 VDD \$I1788 \$I1789 VDD PMOS L=1u W=3.4u AS=6.46p AD=10.88p PS=7.2u
+ PD=13.2u
* device instance $9 r0 *1 211.2,5.7 NMOS
XM$9 BL9 WL0 \$I1788 VSS NMOS L=1u W=3.4u AS=10.88p AD=6.46p PS=13.2u PD=7.2u
* device instance $10 r0 *1 216,5.7 NMOS
XM$10 \$I1788 \$I1789 VSS VSS NMOS L=1u W=3.4u AS=6.46p AD=6.46p PS=7.2u PD=7.2u
* device instance $11 r0 *1 220.8,5.7 NMOS
XM$11 VSS \$I1788 \$I1789 VSS NMOS L=1u W=3.4u AS=6.46p AD=6.46p PS=7.2u PD=7.2u
* device instance $12 r0 *1 225.6,5.7 NMOS
XM$12 \$I1789 WL0 BLB9 VSS NMOS L=1u W=3.4u AS=6.46p AD=10.88p PS=7.2u PD=13.2u
* device instance $13 r0 *1 355.2,26.1 PMOS
XM$13 \$I1790 \$I1791 VDD VDD PMOS L=1u W=3.4u AS=10.88p AD=6.46p PS=13.2u
+ PD=7.2u
* device instance $14 r0 *1 360,26.1 PMOS
XM$14 VDD \$I1790 \$I1791 VDD PMOS L=1u W=3.4u AS=6.46p AD=10.88p PS=7.2u
+ PD=13.2u
* device instance $15 r0 *1 350.4,5.7 NMOS
XM$15 BL15 WL0 \$I1790 VSS NMOS L=1u W=3.4u AS=10.88p AD=6.46p PS=13.2u PD=7.2u
* device instance $16 r0 *1 355.2,5.7 NMOS
XM$16 \$I1790 \$I1791 VSS VSS NMOS L=1u W=3.4u AS=6.46p AD=6.46p PS=7.2u PD=7.2u
* device instance $17 r0 *1 360,5.7 NMOS
XM$17 VSS \$I1790 \$I1791 VSS NMOS L=1u W=3.4u AS=6.46p AD=6.46p PS=7.2u PD=7.2u
* device instance $18 r0 *1 364.8,5.7 NMOS
XM$18 \$I1791 WL0 BLB15 VSS NMOS L=1u W=3.4u AS=6.46p AD=10.88p PS=7.2u PD=13.2u
* device instance $19 r0 *1 169.6,26.1 PMOS
XM$19 \$I1792 \$I1793 VDD VDD PMOS L=1u W=3.4u AS=10.88p AD=6.46p PS=13.2u
+ PD=7.2u
* device instance $20 r0 *1 174.4,26.1 PMOS
XM$20 VDD \$I1792 \$I1793 VDD PMOS L=1u W=3.4u AS=6.46p AD=10.88p PS=7.2u
+ PD=13.2u
* device instance $21 r0 *1 164.8,5.7 NMOS
XM$21 BL7 WL0 \$I1792 VSS NMOS L=1u W=3.4u AS=10.88p AD=6.46p PS=13.2u PD=7.2u
* device instance $22 r0 *1 169.6,5.7 NMOS
XM$22 \$I1792 \$I1793 VSS VSS NMOS L=1u W=3.4u AS=6.46p AD=6.46p PS=7.2u PD=7.2u
* device instance $23 r0 *1 174.4,5.7 NMOS
XM$23 VSS \$I1792 \$I1793 VSS NMOS L=1u W=3.4u AS=6.46p AD=6.46p PS=7.2u PD=7.2u
* device instance $24 r0 *1 179.2,5.7 NMOS
XM$24 \$I1793 WL0 BLB7 VSS NMOS L=1u W=3.4u AS=6.46p AD=10.88p PS=7.2u PD=13.2u
* device instance $25 r0 *1 192.8,26.1 PMOS
XM$25 \$I1794 \$I1795 VDD VDD PMOS L=1u W=3.4u AS=10.88p AD=6.46p PS=13.2u
+ PD=7.2u
* device instance $26 r0 *1 197.6,26.1 PMOS
XM$26 VDD \$I1794 \$I1795 VDD PMOS L=1u W=3.4u AS=6.46p AD=10.88p PS=7.2u
+ PD=13.2u
* device instance $27 r0 *1 188,5.7 NMOS
XM$27 BL8 WL0 \$I1794 VSS NMOS L=1u W=3.4u AS=10.88p AD=6.46p PS=13.2u PD=7.2u
* device instance $28 r0 *1 192.8,5.7 NMOS
XM$28 \$I1794 \$I1795 VSS VSS NMOS L=1u W=3.4u AS=6.46p AD=6.46p PS=7.2u PD=7.2u
* device instance $29 r0 *1 197.6,5.7 NMOS
XM$29 VSS \$I1794 \$I1795 VSS NMOS L=1u W=3.4u AS=6.46p AD=6.46p PS=7.2u PD=7.2u
* device instance $30 r0 *1 202.4,5.7 NMOS
XM$30 \$I1795 WL0 BLB8 VSS NMOS L=1u W=3.4u AS=6.46p AD=10.88p PS=7.2u PD=13.2u
* device instance $31 r0 *1 100,26.1 PMOS
XM$31 \$I1796 \$I1797 VDD VDD PMOS L=1u W=3.4u AS=10.88p AD=6.46p PS=13.2u
+ PD=7.2u
* device instance $32 r0 *1 104.8,26.1 PMOS
XM$32 VDD \$I1796 \$I1797 VDD PMOS L=1u W=3.4u AS=6.46p AD=10.88p PS=7.2u
+ PD=13.2u
* device instance $33 r0 *1 95.2,5.7 NMOS
XM$33 BL4 WL0 \$I1796 VSS NMOS L=1u W=3.4u AS=10.88p AD=6.46p PS=13.2u PD=7.2u
* device instance $34 r0 *1 100,5.7 NMOS
XM$34 \$I1796 \$I1797 VSS VSS NMOS L=1u W=3.4u AS=6.46p AD=6.46p PS=7.2u PD=7.2u
* device instance $35 r0 *1 104.8,5.7 NMOS
XM$35 VSS \$I1796 \$I1797 VSS NMOS L=1u W=3.4u AS=6.46p AD=6.46p PS=7.2u PD=7.2u
* device instance $36 r0 *1 109.6,5.7 NMOS
XM$36 \$I1797 WL0 BLB4 VSS NMOS L=1u W=3.4u AS=6.46p AD=10.88p PS=7.2u PD=13.2u
* device instance $37 r0 *1 123.2,26.1 PMOS
XM$37 \$I1798 \$I1799 VDD VDD PMOS L=1u W=3.4u AS=10.88p AD=6.46p PS=13.2u
+ PD=7.2u
* device instance $38 r0 *1 128,26.1 PMOS
XM$38 VDD \$I1798 \$I1799 VDD PMOS L=1u W=3.4u AS=6.46p AD=10.88p PS=7.2u
+ PD=13.2u
* device instance $39 r0 *1 118.4,5.7 NMOS
XM$39 BL5 WL0 \$I1798 VSS NMOS L=1u W=3.4u AS=10.88p AD=6.46p PS=13.2u PD=7.2u
* device instance $40 r0 *1 123.2,5.7 NMOS
XM$40 \$I1798 \$I1799 VSS VSS NMOS L=1u W=3.4u AS=6.46p AD=6.46p PS=7.2u PD=7.2u
* device instance $41 r0 *1 128,5.7 NMOS
XM$41 VSS \$I1798 \$I1799 VSS NMOS L=1u W=3.4u AS=6.46p AD=6.46p PS=7.2u PD=7.2u
* device instance $42 r0 *1 132.8,5.7 NMOS
XM$42 \$I1799 WL0 BLB5 VSS NMOS L=1u W=3.4u AS=6.46p AD=10.88p PS=7.2u PD=13.2u
* device instance $43 r0 *1 146.4,26.1 PMOS
XM$43 \$I1800 \$I1801 VDD VDD PMOS L=1u W=3.4u AS=10.88p AD=6.46p PS=13.2u
+ PD=7.2u
* device instance $44 r0 *1 151.2,26.1 PMOS
XM$44 VDD \$I1800 \$I1801 VDD PMOS L=1u W=3.4u AS=6.46p AD=10.88p PS=7.2u
+ PD=13.2u
* device instance $45 r0 *1 141.6,5.7 NMOS
XM$45 BL6 WL0 \$I1800 VSS NMOS L=1u W=3.4u AS=10.88p AD=6.46p PS=13.2u PD=7.2u
* device instance $46 r0 *1 146.4,5.7 NMOS
XM$46 \$I1800 \$I1801 VSS VSS NMOS L=1u W=3.4u AS=6.46p AD=6.46p PS=7.2u PD=7.2u
* device instance $47 r0 *1 151.2,5.7 NMOS
XM$47 VSS \$I1800 \$I1801 VSS NMOS L=1u W=3.4u AS=6.46p AD=6.46p PS=7.2u PD=7.2u
* device instance $48 r0 *1 156,5.7 NMOS
XM$48 \$I1801 WL0 BLB6 VSS NMOS L=1u W=3.4u AS=6.46p AD=10.88p PS=7.2u PD=13.2u
* device instance $49 r0 *1 7.2,26.1 PMOS
XM$49 \$I1802 \$I1803 VDD VDD PMOS L=1u W=3.4u AS=10.88p AD=6.46p PS=13.2u
+ PD=7.2u
* device instance $50 r0 *1 12,26.1 PMOS
XM$50 VDD \$I1802 \$I1803 VDD PMOS L=1u W=3.4u AS=6.46p AD=10.88p PS=7.2u
+ PD=13.2u
* device instance $51 r0 *1 2.4,5.7 NMOS
XM$51 BL0 WL0 \$I1802 VSS NMOS L=1u W=3.4u AS=10.88p AD=6.46p PS=13.2u PD=7.2u
* device instance $52 r0 *1 7.2,5.7 NMOS
XM$52 \$I1802 \$I1803 VSS VSS NMOS L=1u W=3.4u AS=6.46p AD=6.46p PS=7.2u PD=7.2u
* device instance $53 r0 *1 12,5.7 NMOS
XM$53 VSS \$I1802 \$I1803 VSS NMOS L=1u W=3.4u AS=6.46p AD=6.46p PS=7.2u PD=7.2u
* device instance $54 r0 *1 16.8,5.7 NMOS
XM$54 \$I1803 WL0 BLB0 VSS NMOS L=1u W=3.4u AS=6.46p AD=10.88p PS=7.2u PD=13.2u
* device instance $55 r0 *1 30.4,26.1 PMOS
XM$55 \$I1804 \$I1805 VDD VDD PMOS L=1u W=3.4u AS=10.88p AD=6.46p PS=13.2u
+ PD=7.2u
* device instance $56 r0 *1 35.2,26.1 PMOS
XM$56 VDD \$I1804 \$I1805 VDD PMOS L=1u W=3.4u AS=6.46p AD=10.88p PS=7.2u
+ PD=13.2u
* device instance $57 r0 *1 25.6,5.7 NMOS
XM$57 BL1 WL0 \$I1804 VSS NMOS L=1u W=3.4u AS=10.88p AD=6.46p PS=13.2u PD=7.2u
* device instance $58 r0 *1 30.4,5.7 NMOS
XM$58 \$I1804 \$I1805 VSS VSS NMOS L=1u W=3.4u AS=6.46p AD=6.46p PS=7.2u PD=7.2u
* device instance $59 r0 *1 35.2,5.7 NMOS
XM$59 VSS \$I1804 \$I1805 VSS NMOS L=1u W=3.4u AS=6.46p AD=6.46p PS=7.2u PD=7.2u
* device instance $60 r0 *1 40,5.7 NMOS
XM$60 \$I1805 WL0 BLB1 VSS NMOS L=1u W=3.4u AS=6.46p AD=10.88p PS=7.2u PD=13.2u
* device instance $61 r0 *1 53.6,26.1 PMOS
XM$61 \$I1806 \$I1807 VDD VDD PMOS L=1u W=3.4u AS=10.88p AD=6.46p PS=13.2u
+ PD=7.2u
* device instance $62 r0 *1 58.4,26.1 PMOS
XM$62 VDD \$I1806 \$I1807 VDD PMOS L=1u W=3.4u AS=6.46p AD=10.88p PS=7.2u
+ PD=13.2u
* device instance $63 r0 *1 48.8,5.7 NMOS
XM$63 BL2 WL0 \$I1806 VSS NMOS L=1u W=3.4u AS=10.88p AD=6.46p PS=13.2u PD=7.2u
* device instance $64 r0 *1 53.6,5.7 NMOS
XM$64 \$I1806 \$I1807 VSS VSS NMOS L=1u W=3.4u AS=6.46p AD=6.46p PS=7.2u PD=7.2u
* device instance $65 r0 *1 58.4,5.7 NMOS
XM$65 VSS \$I1806 \$I1807 VSS NMOS L=1u W=3.4u AS=6.46p AD=6.46p PS=7.2u PD=7.2u
* device instance $66 r0 *1 63.2,5.7 NMOS
XM$66 \$I1807 WL0 BLB2 VSS NMOS L=1u W=3.4u AS=6.46p AD=10.88p PS=7.2u PD=13.2u
* device instance $67 r0 *1 76.8,26.1 PMOS
XM$67 \$I1808 \$I1809 VDD VDD PMOS L=1u W=3.4u AS=10.88p AD=6.46p PS=13.2u
+ PD=7.2u
* device instance $68 r0 *1 81.6,26.1 PMOS
XM$68 VDD \$I1808 \$I1809 VDD PMOS L=1u W=3.4u AS=6.46p AD=10.88p PS=7.2u
+ PD=13.2u
* device instance $69 r0 *1 72,5.7 NMOS
XM$69 BL3 WL0 \$I1808 VSS NMOS L=1u W=3.4u AS=10.88p AD=6.46p PS=13.2u PD=7.2u
* device instance $70 r0 *1 76.8,5.7 NMOS
XM$70 \$I1808 \$I1809 VSS VSS NMOS L=1u W=3.4u AS=6.46p AD=6.46p PS=7.2u PD=7.2u
* device instance $71 r0 *1 81.6,5.7 NMOS
XM$71 VSS \$I1808 \$I1809 VSS NMOS L=1u W=3.4u AS=6.46p AD=6.46p PS=7.2u PD=7.2u
* device instance $72 r0 *1 86.4,5.7 NMOS
XM$72 \$I1809 WL0 BLB3 VSS NMOS L=1u W=3.4u AS=6.46p AD=10.88p PS=7.2u PD=13.2u
* device instance $73 r0 *1 285.6,26.1 PMOS
XM$73 \$I1810 \$I1811 VDD VDD PMOS L=1u W=3.4u AS=10.88p AD=6.46p PS=13.2u
+ PD=7.2u
* device instance $74 r0 *1 290.4,26.1 PMOS
XM$74 VDD \$I1810 \$I1811 VDD PMOS L=1u W=3.4u AS=6.46p AD=10.88p PS=7.2u
+ PD=13.2u
* device instance $75 r0 *1 280.8,5.7 NMOS
XM$75 BL12 WL0 \$I1810 VSS NMOS L=1u W=3.4u AS=10.88p AD=6.46p PS=13.2u PD=7.2u
* device instance $76 r0 *1 285.6,5.7 NMOS
XM$76 \$I1810 \$I1811 VSS VSS NMOS L=1u W=3.4u AS=6.46p AD=6.46p PS=7.2u PD=7.2u
* device instance $77 r0 *1 290.4,5.7 NMOS
XM$77 VSS \$I1810 \$I1811 VSS NMOS L=1u W=3.4u AS=6.46p AD=6.46p PS=7.2u PD=7.2u
* device instance $78 r0 *1 295.2,5.7 NMOS
XM$78 \$I1811 WL0 BLB12 VSS NMOS L=1u W=3.4u AS=6.46p AD=10.88p PS=7.2u PD=13.2u
* device instance $79 r0 *1 308.8,26.1 PMOS
XM$79 \$I1812 \$I1813 VDD VDD PMOS L=1u W=3.4u AS=10.88p AD=6.46p PS=13.2u
+ PD=7.2u
* device instance $80 r0 *1 313.6,26.1 PMOS
XM$80 VDD \$I1812 \$I1813 VDD PMOS L=1u W=3.4u AS=6.46p AD=10.88p PS=7.2u
+ PD=13.2u
* device instance $81 r0 *1 304,5.7 NMOS
XM$81 BL13 WL0 \$I1812 VSS NMOS L=1u W=3.4u AS=10.88p AD=6.46p PS=13.2u PD=7.2u
* device instance $82 r0 *1 308.8,5.7 NMOS
XM$82 \$I1812 \$I1813 VSS VSS NMOS L=1u W=3.4u AS=6.46p AD=6.46p PS=7.2u PD=7.2u
* device instance $83 r0 *1 313.6,5.7 NMOS
XM$83 VSS \$I1812 \$I1813 VSS NMOS L=1u W=3.4u AS=6.46p AD=6.46p PS=7.2u PD=7.2u
* device instance $84 r0 *1 318.4,5.7 NMOS
XM$84 \$I1813 WL0 BLB13 VSS NMOS L=1u W=3.4u AS=6.46p AD=10.88p PS=7.2u PD=13.2u
* device instance $85 r0 *1 332,26.1 PMOS
XM$85 \$I1814 \$I1815 VDD VDD PMOS L=1u W=3.4u AS=10.88p AD=6.46p PS=13.2u
+ PD=7.2u
* device instance $86 r0 *1 336.8,26.1 PMOS
XM$86 VDD \$I1814 \$I1815 VDD PMOS L=1u W=3.4u AS=6.46p AD=10.88p PS=7.2u
+ PD=13.2u
* device instance $87 r0 *1 327.2,5.7 NMOS
XM$87 BL14 WL0 \$I1814 VSS NMOS L=1u W=3.4u AS=10.88p AD=6.46p PS=13.2u PD=7.2u
* device instance $88 r0 *1 332,5.7 NMOS
XM$88 \$I1814 \$I1815 VSS VSS NMOS L=1u W=3.4u AS=6.46p AD=6.46p PS=7.2u PD=7.2u
* device instance $89 r0 *1 336.8,5.7 NMOS
XM$89 VSS \$I1814 \$I1815 VSS NMOS L=1u W=3.4u AS=6.46p AD=6.46p PS=7.2u PD=7.2u
* device instance $90 r0 *1 341.6,5.7 NMOS
XM$90 \$I1815 WL0 BLB14 VSS NMOS L=1u W=3.4u AS=6.46p AD=10.88p PS=7.2u PD=13.2u
* device instance $91 r0 *1 262.4,26.1 PMOS
XM$91 \$I1816 \$I1817 VDD VDD PMOS L=1u W=3.4u AS=10.88p AD=6.46p PS=13.2u
+ PD=7.2u
* device instance $92 r0 *1 267.2,26.1 PMOS
XM$92 VDD \$I1816 \$I1817 VDD PMOS L=1u W=3.4u AS=6.46p AD=10.88p PS=7.2u
+ PD=13.2u
* device instance $93 r0 *1 257.6,5.7 NMOS
XM$93 BL11 WL0 \$I1816 VSS NMOS L=1u W=3.4u AS=10.88p AD=6.46p PS=13.2u PD=7.2u
* device instance $94 r0 *1 262.4,5.7 NMOS
XM$94 \$I1816 \$I1817 VSS VSS NMOS L=1u W=3.4u AS=6.46p AD=6.46p PS=7.2u PD=7.2u
* device instance $95 r0 *1 267.2,5.7 NMOS
XM$95 VSS \$I1816 \$I1817 VSS NMOS L=1u W=3.4u AS=6.46p AD=6.46p PS=7.2u PD=7.2u
* device instance $96 r0 *1 272,5.7 NMOS
XM$96 \$I1817 WL0 BLB11 VSS NMOS L=1u W=3.4u AS=6.46p AD=10.88p PS=7.2u PD=13.2u
* device instance $97 m0 *1 7.2,447.5 PMOS
XM$97 \$I1818 \$I1819 VDD VDD PMOS L=1u W=3.4u AS=10.88p AD=6.46p PS=13.2u
+ PD=7.2u
* device instance $98 m0 *1 12,447.5 PMOS
XM$98 VDD \$I1818 \$I1819 VDD PMOS L=1u W=3.4u AS=6.46p AD=10.88p PS=7.2u
+ PD=13.2u
* device instance $99 m0 *1 2.4,467.9 NMOS
XM$99 BL0 WL15 \$I1818 VSS NMOS L=1u W=3.4u AS=10.88p AD=6.46p PS=13.2u PD=7.2u
* device instance $100 m0 *1 7.2,467.9 NMOS
XM$100 \$I1818 \$I1819 VSS VSS NMOS L=1u W=3.4u AS=6.46p AD=6.46p PS=7.2u
+ PD=7.2u
* device instance $101 m0 *1 12,467.9 NMOS
XM$101 VSS \$I1818 \$I1819 VSS NMOS L=1u W=3.4u AS=6.46p AD=6.46p PS=7.2u
+ PD=7.2u
* device instance $102 m0 *1 16.8,467.9 NMOS
XM$102 \$I1819 WL15 BLB0 VSS NMOS L=1u W=3.4u AS=6.46p AD=10.88p PS=7.2u
+ PD=13.2u
* device instance $103 m0 *1 7.2,269.9 PMOS
XM$103 \$I1820 \$I1821 VDD VDD PMOS L=1u W=3.4u AS=10.88p AD=6.46p PS=13.2u
+ PD=7.2u
* device instance $104 m0 *1 12,269.9 PMOS
XM$104 VDD \$I1820 \$I1821 VDD PMOS L=1u W=3.4u AS=6.46p AD=10.88p PS=7.2u
+ PD=13.2u
* device instance $105 m0 *1 2.4,290.3 NMOS
XM$105 BL0 WL9 \$I1820 VSS NMOS L=1u W=3.4u AS=10.88p AD=6.46p PS=13.2u PD=7.2u
* device instance $106 m0 *1 7.2,290.3 NMOS
XM$106 \$I1820 \$I1821 VSS VSS NMOS L=1u W=3.4u AS=6.46p AD=6.46p PS=7.2u
+ PD=7.2u
* device instance $107 m0 *1 12,290.3 NMOS
XM$107 VSS \$I1820 \$I1821 VSS NMOS L=1u W=3.4u AS=6.46p AD=6.46p PS=7.2u
+ PD=7.2u
* device instance $108 m0 *1 16.8,290.3 NMOS
XM$108 \$I1821 WL9 BLB0 VSS NMOS L=1u W=3.4u AS=6.46p AD=10.88p PS=7.2u PD=13.2u
* device instance $109 m0 *1 7.2,329.1 PMOS
XM$109 \$I1822 \$I1823 VDD VDD PMOS L=1u W=3.4u AS=10.88p AD=6.46p PS=13.2u
+ PD=7.2u
* device instance $110 m0 *1 12,329.1 PMOS
XM$110 VDD \$I1822 \$I1823 VDD PMOS L=1u W=3.4u AS=6.46p AD=10.88p PS=7.2u
+ PD=13.2u
* device instance $111 m0 *1 2.4,349.5 NMOS
XM$111 BL0 WL11 \$I1822 VSS NMOS L=1u W=3.4u AS=10.88p AD=6.46p PS=13.2u PD=7.2u
* device instance $112 m0 *1 7.2,349.5 NMOS
XM$112 \$I1822 \$I1823 VSS VSS NMOS L=1u W=3.4u AS=6.46p AD=6.46p PS=7.2u
+ PD=7.2u
* device instance $113 m0 *1 12,349.5 NMOS
XM$113 VSS \$I1822 \$I1823 VSS NMOS L=1u W=3.4u AS=6.46p AD=6.46p PS=7.2u
+ PD=7.2u
* device instance $114 m0 *1 16.8,349.5 NMOS
XM$114 \$I1823 WL11 BLB0 VSS NMOS L=1u W=3.4u AS=6.46p AD=10.88p PS=7.2u
+ PD=13.2u
* device instance $115 m0 *1 7.2,210.7 PMOS
XM$115 \$I1824 \$I1825 VDD VDD PMOS L=1u W=3.4u AS=10.88p AD=6.46p PS=13.2u
+ PD=7.2u
* device instance $116 m0 *1 12,210.7 PMOS
XM$116 VDD \$I1824 \$I1825 VDD PMOS L=1u W=3.4u AS=6.46p AD=10.88p PS=7.2u
+ PD=13.2u
* device instance $117 m0 *1 2.4,231.1 NMOS
XM$117 BL0 WL7 \$I1824 VSS NMOS L=1u W=3.4u AS=10.88p AD=6.46p PS=13.2u PD=7.2u
* device instance $118 m0 *1 7.2,231.1 NMOS
XM$118 \$I1824 \$I1825 VSS VSS NMOS L=1u W=3.4u AS=6.46p AD=6.46p PS=7.2u
+ PD=7.2u
* device instance $119 m0 *1 12,231.1 NMOS
XM$119 VSS \$I1824 \$I1825 VSS NMOS L=1u W=3.4u AS=6.46p AD=6.46p PS=7.2u
+ PD=7.2u
* device instance $120 m0 *1 16.8,231.1 NMOS
XM$120 \$I1825 WL7 BLB0 VSS NMOS L=1u W=3.4u AS=6.46p AD=10.88p PS=7.2u PD=13.2u
* device instance $121 m0 *1 7.2,151.5 PMOS
XM$121 \$I1826 \$I1827 VDD VDD PMOS L=1u W=3.4u AS=10.88p AD=6.46p PS=13.2u
+ PD=7.2u
* device instance $122 m0 *1 12,151.5 PMOS
XM$122 VDD \$I1826 \$I1827 VDD PMOS L=1u W=3.4u AS=6.46p AD=10.88p PS=7.2u
+ PD=13.2u
* device instance $123 m0 *1 2.4,171.9 NMOS
XM$123 BL0 WL5 \$I1826 VSS NMOS L=1u W=3.4u AS=10.88p AD=6.46p PS=13.2u PD=7.2u
* device instance $124 m0 *1 7.2,171.9 NMOS
XM$124 \$I1826 \$I1827 VSS VSS NMOS L=1u W=3.4u AS=6.46p AD=6.46p PS=7.2u
+ PD=7.2u
* device instance $125 m0 *1 12,171.9 NMOS
XM$125 VSS \$I1826 \$I1827 VSS NMOS L=1u W=3.4u AS=6.46p AD=6.46p PS=7.2u
+ PD=7.2u
* device instance $126 m0 *1 16.8,171.9 NMOS
XM$126 \$I1827 WL5 BLB0 VSS NMOS L=1u W=3.4u AS=6.46p AD=10.88p PS=7.2u PD=13.2u
* device instance $127 m0 *1 7.2,33.1 PMOS
XM$127 \$I1828 \$I1829 VDD VDD PMOS L=1u W=3.4u AS=10.88p AD=6.46p PS=13.2u
+ PD=7.2u
* device instance $128 m0 *1 12,33.1 PMOS
XM$128 VDD \$I1828 \$I1829 VDD PMOS L=1u W=3.4u AS=6.46p AD=10.88p PS=7.2u
+ PD=13.2u
* device instance $129 m0 *1 2.4,53.5 NMOS
XM$129 BL0 WL1 \$I1828 VSS NMOS L=1u W=3.4u AS=10.88p AD=6.46p PS=13.2u PD=7.2u
* device instance $130 m0 *1 7.2,53.5 NMOS
XM$130 \$I1828 \$I1829 VSS VSS NMOS L=1u W=3.4u AS=6.46p AD=6.46p PS=7.2u
+ PD=7.2u
* device instance $131 m0 *1 12,53.5 NMOS
XM$131 VSS \$I1828 \$I1829 VSS NMOS L=1u W=3.4u AS=6.46p AD=6.46p PS=7.2u
+ PD=7.2u
* device instance $132 m0 *1 16.8,53.5 NMOS
XM$132 \$I1829 WL1 BLB0 VSS NMOS L=1u W=3.4u AS=6.46p AD=10.88p PS=7.2u PD=13.2u
* device instance $133 m0 *1 7.2,388.3 PMOS
XM$133 \$I1830 \$I1831 VDD VDD PMOS L=1u W=3.4u AS=10.88p AD=6.46p PS=13.2u
+ PD=7.2u
* device instance $134 m0 *1 12,388.3 PMOS
XM$134 VDD \$I1830 \$I1831 VDD PMOS L=1u W=3.4u AS=6.46p AD=10.88p PS=7.2u
+ PD=13.2u
* device instance $135 m0 *1 2.4,408.7 NMOS
XM$135 BL0 WL13 \$I1830 VSS NMOS L=1u W=3.4u AS=10.88p AD=6.46p PS=13.2u PD=7.2u
* device instance $136 m0 *1 7.2,408.7 NMOS
XM$136 \$I1830 \$I1831 VSS VSS NMOS L=1u W=3.4u AS=6.46p AD=6.46p PS=7.2u
+ PD=7.2u
* device instance $137 m0 *1 12,408.7 NMOS
XM$137 VSS \$I1830 \$I1831 VSS NMOS L=1u W=3.4u AS=6.46p AD=6.46p PS=7.2u
+ PD=7.2u
* device instance $138 m0 *1 16.8,408.7 NMOS
XM$138 \$I1831 WL13 BLB0 VSS NMOS L=1u W=3.4u AS=6.46p AD=10.88p PS=7.2u
+ PD=13.2u
* device instance $139 m0 *1 7.2,92.3 PMOS
XM$139 \$I1832 \$I1833 VDD VDD PMOS L=1u W=3.4u AS=10.88p AD=6.46p PS=13.2u
+ PD=7.2u
* device instance $140 m0 *1 12,92.3 PMOS
XM$140 VDD \$I1832 \$I1833 VDD PMOS L=1u W=3.4u AS=6.46p AD=10.88p PS=7.2u
+ PD=13.2u
* device instance $141 m0 *1 2.4,112.7 NMOS
XM$141 BL0 WL3 \$I1832 VSS NMOS L=1u W=3.4u AS=10.88p AD=6.46p PS=13.2u PD=7.2u
* device instance $142 m0 *1 7.2,112.7 NMOS
XM$142 \$I1832 \$I1833 VSS VSS NMOS L=1u W=3.4u AS=6.46p AD=6.46p PS=7.2u
+ PD=7.2u
* device instance $143 m0 *1 12,112.7 NMOS
XM$143 VSS \$I1832 \$I1833 VSS NMOS L=1u W=3.4u AS=6.46p AD=6.46p PS=7.2u
+ PD=7.2u
* device instance $144 m0 *1 16.8,112.7 NMOS
XM$144 \$I1833 WL3 BLB0 VSS NMOS L=1u W=3.4u AS=6.46p AD=10.88p PS=7.2u PD=13.2u
* device instance $145 r0 *1 7.2,203.7 PMOS
XM$145 \$I1834 \$I1835 VDD VDD PMOS L=1u W=3.4u AS=10.88p AD=6.46p PS=13.2u
+ PD=7.2u
* device instance $146 r0 *1 12,203.7 PMOS
XM$146 VDD \$I1834 \$I1835 VDD PMOS L=1u W=3.4u AS=6.46p AD=10.88p PS=7.2u
+ PD=13.2u
* device instance $147 r0 *1 2.4,183.3 NMOS
XM$147 BL0 WL6 \$I1834 VSS NMOS L=1u W=3.4u AS=10.88p AD=6.46p PS=13.2u PD=7.2u
* device instance $148 r0 *1 7.2,183.3 NMOS
XM$148 \$I1834 \$I1835 VSS VSS NMOS L=1u W=3.4u AS=6.46p AD=6.46p PS=7.2u
+ PD=7.2u
* device instance $149 r0 *1 12,183.3 NMOS
XM$149 VSS \$I1834 \$I1835 VSS NMOS L=1u W=3.4u AS=6.46p AD=6.46p PS=7.2u
+ PD=7.2u
* device instance $150 r0 *1 16.8,183.3 NMOS
XM$150 \$I1835 WL6 BLB0 VSS NMOS L=1u W=3.4u AS=6.46p AD=10.88p PS=7.2u PD=13.2u
* device instance $151 r0 *1 7.2,85.3 PMOS
XM$151 \$I1836 \$I1837 VDD VDD PMOS L=1u W=3.4u AS=10.88p AD=6.46p PS=13.2u
+ PD=7.2u
* device instance $152 r0 *1 12,85.3 PMOS
XM$152 VDD \$I1836 \$I1837 VDD PMOS L=1u W=3.4u AS=6.46p AD=10.88p PS=7.2u
+ PD=13.2u
* device instance $153 r0 *1 2.4,64.9 NMOS
XM$153 BL0 WL2 \$I1836 VSS NMOS L=1u W=3.4u AS=10.88p AD=6.46p PS=13.2u PD=7.2u
* device instance $154 r0 *1 7.2,64.9 NMOS
XM$154 \$I1836 \$I1837 VSS VSS NMOS L=1u W=3.4u AS=6.46p AD=6.46p PS=7.2u
+ PD=7.2u
* device instance $155 r0 *1 12,64.9 NMOS
XM$155 VSS \$I1836 \$I1837 VSS NMOS L=1u W=3.4u AS=6.46p AD=6.46p PS=7.2u
+ PD=7.2u
* device instance $156 r0 *1 16.8,64.9 NMOS
XM$156 \$I1837 WL2 BLB0 VSS NMOS L=1u W=3.4u AS=6.46p AD=10.88p PS=7.2u PD=13.2u
* device instance $157 r0 *1 7.2,440.5 PMOS
XM$157 \$I1838 \$I1839 VDD VDD PMOS L=1u W=3.4u AS=10.88p AD=6.46p PS=13.2u
+ PD=7.2u
* device instance $158 r0 *1 12,440.5 PMOS
XM$158 VDD \$I1838 \$I1839 VDD PMOS L=1u W=3.4u AS=6.46p AD=10.88p PS=7.2u
+ PD=13.2u
* device instance $159 r0 *1 2.4,420.1 NMOS
XM$159 BL0 WL14 \$I1838 VSS NMOS L=1u W=3.4u AS=10.88p AD=6.46p PS=13.2u PD=7.2u
* device instance $160 r0 *1 7.2,420.1 NMOS
XM$160 \$I1838 \$I1839 VSS VSS NMOS L=1u W=3.4u AS=6.46p AD=6.46p PS=7.2u
+ PD=7.2u
* device instance $161 r0 *1 12,420.1 NMOS
XM$161 VSS \$I1838 \$I1839 VSS NMOS L=1u W=3.4u AS=6.46p AD=6.46p PS=7.2u
+ PD=7.2u
* device instance $162 r0 *1 16.8,420.1 NMOS
XM$162 \$I1839 WL14 BLB0 VSS NMOS L=1u W=3.4u AS=6.46p AD=10.88p PS=7.2u
+ PD=13.2u
* device instance $163 r0 *1 7.2,381.3 PMOS
XM$163 \$I1840 \$I1841 VDD VDD PMOS L=1u W=3.4u AS=10.88p AD=6.46p PS=13.2u
+ PD=7.2u
* device instance $164 r0 *1 12,381.3 PMOS
XM$164 VDD \$I1840 \$I1841 VDD PMOS L=1u W=3.4u AS=6.46p AD=10.88p PS=7.2u
+ PD=13.2u
* device instance $165 r0 *1 2.4,360.9 NMOS
XM$165 BL0 WL12 \$I1840 VSS NMOS L=1u W=3.4u AS=10.88p AD=6.46p PS=13.2u PD=7.2u
* device instance $166 r0 *1 7.2,360.9 NMOS
XM$166 \$I1840 \$I1841 VSS VSS NMOS L=1u W=3.4u AS=6.46p AD=6.46p PS=7.2u
+ PD=7.2u
* device instance $167 r0 *1 12,360.9 NMOS
XM$167 VSS \$I1840 \$I1841 VSS NMOS L=1u W=3.4u AS=6.46p AD=6.46p PS=7.2u
+ PD=7.2u
* device instance $168 r0 *1 16.8,360.9 NMOS
XM$168 \$I1841 WL12 BLB0 VSS NMOS L=1u W=3.4u AS=6.46p AD=10.88p PS=7.2u
+ PD=13.2u
* device instance $169 r0 *1 7.2,144.5 PMOS
XM$169 \$I1842 \$I1843 VDD VDD PMOS L=1u W=3.4u AS=10.88p AD=6.46p PS=13.2u
+ PD=7.2u
* device instance $170 r0 *1 12,144.5 PMOS
XM$170 VDD \$I1842 \$I1843 VDD PMOS L=1u W=3.4u AS=6.46p AD=10.88p PS=7.2u
+ PD=13.2u
* device instance $171 r0 *1 2.4,124.1 NMOS
XM$171 BL0 WL4 \$I1842 VSS NMOS L=1u W=3.4u AS=10.88p AD=6.46p PS=13.2u PD=7.2u
* device instance $172 r0 *1 7.2,124.1 NMOS
XM$172 \$I1842 \$I1843 VSS VSS NMOS L=1u W=3.4u AS=6.46p AD=6.46p PS=7.2u
+ PD=7.2u
* device instance $173 r0 *1 12,124.1 NMOS
XM$173 VSS \$I1842 \$I1843 VSS NMOS L=1u W=3.4u AS=6.46p AD=6.46p PS=7.2u
+ PD=7.2u
* device instance $174 r0 *1 16.8,124.1 NMOS
XM$174 \$I1843 WL4 BLB0 VSS NMOS L=1u W=3.4u AS=6.46p AD=10.88p PS=7.2u PD=13.2u
* device instance $175 r0 *1 7.2,262.9 PMOS
XM$175 \$I1844 \$I1845 VDD VDD PMOS L=1u W=3.4u AS=10.88p AD=6.46p PS=13.2u
+ PD=7.2u
* device instance $176 r0 *1 12,262.9 PMOS
XM$176 VDD \$I1844 \$I1845 VDD PMOS L=1u W=3.4u AS=6.46p AD=10.88p PS=7.2u
+ PD=13.2u
* device instance $177 r0 *1 2.4,242.5 NMOS
XM$177 BL0 WL8 \$I1844 VSS NMOS L=1u W=3.4u AS=10.88p AD=6.46p PS=13.2u PD=7.2u
* device instance $178 r0 *1 7.2,242.5 NMOS
XM$178 \$I1844 \$I1845 VSS VSS NMOS L=1u W=3.4u AS=6.46p AD=6.46p PS=7.2u
+ PD=7.2u
* device instance $179 r0 *1 12,242.5 NMOS
XM$179 VSS \$I1844 \$I1845 VSS NMOS L=1u W=3.4u AS=6.46p AD=6.46p PS=7.2u
+ PD=7.2u
* device instance $180 r0 *1 16.8,242.5 NMOS
XM$180 \$I1845 WL8 BLB0 VSS NMOS L=1u W=3.4u AS=6.46p AD=10.88p PS=7.2u PD=13.2u
* device instance $181 r0 *1 7.2,322.1 PMOS
XM$181 \$I1846 \$I1847 VDD VDD PMOS L=1u W=3.4u AS=10.88p AD=6.46p PS=13.2u
+ PD=7.2u
* device instance $182 r0 *1 12,322.1 PMOS
XM$182 VDD \$I1846 \$I1847 VDD PMOS L=1u W=3.4u AS=6.46p AD=10.88p PS=7.2u
+ PD=13.2u
* device instance $183 r0 *1 2.4,301.7 NMOS
XM$183 BL0 WL10 \$I1846 VSS NMOS L=1u W=3.4u AS=10.88p AD=6.46p PS=13.2u PD=7.2u
* device instance $184 r0 *1 7.2,301.7 NMOS
XM$184 \$I1846 \$I1847 VSS VSS NMOS L=1u W=3.4u AS=6.46p AD=6.46p PS=7.2u
+ PD=7.2u
* device instance $185 r0 *1 12,301.7 NMOS
XM$185 VSS \$I1846 \$I1847 VSS NMOS L=1u W=3.4u AS=6.46p AD=6.46p PS=7.2u
+ PD=7.2u
* device instance $186 r0 *1 16.8,301.7 NMOS
XM$186 \$I1847 WL10 BLB0 VSS NMOS L=1u W=3.4u AS=6.46p AD=10.88p PS=7.2u
+ PD=13.2u
* device instance $187 m0 *1 76.8,269.9 PMOS
XM$187 \$I1848 \$I1849 VDD VDD PMOS L=1u W=3.4u AS=10.88p AD=6.46p PS=13.2u
+ PD=7.2u
* device instance $188 m0 *1 81.6,269.9 PMOS
XM$188 VDD \$I1848 \$I1849 VDD PMOS L=1u W=3.4u AS=6.46p AD=10.88p PS=7.2u
+ PD=13.2u
* device instance $189 m0 *1 72,290.3 NMOS
XM$189 BL3 WL9 \$I1848 VSS NMOS L=1u W=3.4u AS=10.88p AD=6.46p PS=13.2u PD=7.2u
* device instance $190 m0 *1 76.8,290.3 NMOS
XM$190 \$I1848 \$I1849 VSS VSS NMOS L=1u W=3.4u AS=6.46p AD=6.46p PS=7.2u
+ PD=7.2u
* device instance $191 m0 *1 81.6,290.3 NMOS
XM$191 VSS \$I1848 \$I1849 VSS NMOS L=1u W=3.4u AS=6.46p AD=6.46p PS=7.2u
+ PD=7.2u
* device instance $192 m0 *1 86.4,290.3 NMOS
XM$192 \$I1849 WL9 BLB3 VSS NMOS L=1u W=3.4u AS=6.46p AD=10.88p PS=7.2u PD=13.2u
* device instance $193 m0 *1 76.8,447.5 PMOS
XM$193 \$I1850 \$I1851 VDD VDD PMOS L=1u W=3.4u AS=10.88p AD=6.46p PS=13.2u
+ PD=7.2u
* device instance $194 m0 *1 81.6,447.5 PMOS
XM$194 VDD \$I1850 \$I1851 VDD PMOS L=1u W=3.4u AS=6.46p AD=10.88p PS=7.2u
+ PD=13.2u
* device instance $195 m0 *1 72,467.9 NMOS
XM$195 BL3 WL15 \$I1850 VSS NMOS L=1u W=3.4u AS=10.88p AD=6.46p PS=13.2u PD=7.2u
* device instance $196 m0 *1 76.8,467.9 NMOS
XM$196 \$I1850 \$I1851 VSS VSS NMOS L=1u W=3.4u AS=6.46p AD=6.46p PS=7.2u
+ PD=7.2u
* device instance $197 m0 *1 81.6,467.9 NMOS
XM$197 VSS \$I1850 \$I1851 VSS NMOS L=1u W=3.4u AS=6.46p AD=6.46p PS=7.2u
+ PD=7.2u
* device instance $198 m0 *1 86.4,467.9 NMOS
XM$198 \$I1851 WL15 BLB3 VSS NMOS L=1u W=3.4u AS=6.46p AD=10.88p PS=7.2u
+ PD=13.2u
* device instance $199 m0 *1 76.8,329.1 PMOS
XM$199 \$I1852 \$I1853 VDD VDD PMOS L=1u W=3.4u AS=10.88p AD=6.46p PS=13.2u
+ PD=7.2u
* device instance $200 m0 *1 81.6,329.1 PMOS
XM$200 VDD \$I1852 \$I1853 VDD PMOS L=1u W=3.4u AS=6.46p AD=10.88p PS=7.2u
+ PD=13.2u
* device instance $201 m0 *1 72,349.5 NMOS
XM$201 BL3 WL11 \$I1852 VSS NMOS L=1u W=3.4u AS=10.88p AD=6.46p PS=13.2u PD=7.2u
* device instance $202 m0 *1 76.8,349.5 NMOS
XM$202 \$I1852 \$I1853 VSS VSS NMOS L=1u W=3.4u AS=6.46p AD=6.46p PS=7.2u
+ PD=7.2u
* device instance $203 m0 *1 81.6,349.5 NMOS
XM$203 VSS \$I1852 \$I1853 VSS NMOS L=1u W=3.4u AS=6.46p AD=6.46p PS=7.2u
+ PD=7.2u
* device instance $204 m0 *1 86.4,349.5 NMOS
XM$204 \$I1853 WL11 BLB3 VSS NMOS L=1u W=3.4u AS=6.46p AD=10.88p PS=7.2u
+ PD=13.2u
* device instance $205 m0 *1 76.8,33.1 PMOS
XM$205 \$I1854 \$I1855 VDD VDD PMOS L=1u W=3.4u AS=10.88p AD=6.46p PS=13.2u
+ PD=7.2u
* device instance $206 m0 *1 81.6,33.1 PMOS
XM$206 VDD \$I1854 \$I1855 VDD PMOS L=1u W=3.4u AS=6.46p AD=10.88p PS=7.2u
+ PD=13.2u
* device instance $207 m0 *1 72,53.5 NMOS
XM$207 BL3 WL1 \$I1854 VSS NMOS L=1u W=3.4u AS=10.88p AD=6.46p PS=13.2u PD=7.2u
* device instance $208 m0 *1 76.8,53.5 NMOS
XM$208 \$I1854 \$I1855 VSS VSS NMOS L=1u W=3.4u AS=6.46p AD=6.46p PS=7.2u
+ PD=7.2u
* device instance $209 m0 *1 81.6,53.5 NMOS
XM$209 VSS \$I1854 \$I1855 VSS NMOS L=1u W=3.4u AS=6.46p AD=6.46p PS=7.2u
+ PD=7.2u
* device instance $210 m0 *1 86.4,53.5 NMOS
XM$210 \$I1855 WL1 BLB3 VSS NMOS L=1u W=3.4u AS=6.46p AD=10.88p PS=7.2u PD=13.2u
* device instance $211 m0 *1 76.8,151.5 PMOS
XM$211 \$I1856 \$I1857 VDD VDD PMOS L=1u W=3.4u AS=10.88p AD=6.46p PS=13.2u
+ PD=7.2u
* device instance $212 m0 *1 81.6,151.5 PMOS
XM$212 VDD \$I1856 \$I1857 VDD PMOS L=1u W=3.4u AS=6.46p AD=10.88p PS=7.2u
+ PD=13.2u
* device instance $213 m0 *1 72,171.9 NMOS
XM$213 BL3 WL5 \$I1856 VSS NMOS L=1u W=3.4u AS=10.88p AD=6.46p PS=13.2u PD=7.2u
* device instance $214 m0 *1 76.8,171.9 NMOS
XM$214 \$I1856 \$I1857 VSS VSS NMOS L=1u W=3.4u AS=6.46p AD=6.46p PS=7.2u
+ PD=7.2u
* device instance $215 m0 *1 81.6,171.9 NMOS
XM$215 VSS \$I1856 \$I1857 VSS NMOS L=1u W=3.4u AS=6.46p AD=6.46p PS=7.2u
+ PD=7.2u
* device instance $216 m0 *1 86.4,171.9 NMOS
XM$216 \$I1857 WL5 BLB3 VSS NMOS L=1u W=3.4u AS=6.46p AD=10.88p PS=7.2u PD=13.2u
* device instance $217 m0 *1 76.8,388.3 PMOS
XM$217 \$I1858 \$I1859 VDD VDD PMOS L=1u W=3.4u AS=10.88p AD=6.46p PS=13.2u
+ PD=7.2u
* device instance $218 m0 *1 81.6,388.3 PMOS
XM$218 VDD \$I1858 \$I1859 VDD PMOS L=1u W=3.4u AS=6.46p AD=10.88p PS=7.2u
+ PD=13.2u
* device instance $219 m0 *1 72,408.7 NMOS
XM$219 BL3 WL13 \$I1858 VSS NMOS L=1u W=3.4u AS=10.88p AD=6.46p PS=13.2u PD=7.2u
* device instance $220 m0 *1 76.8,408.7 NMOS
XM$220 \$I1858 \$I1859 VSS VSS NMOS L=1u W=3.4u AS=6.46p AD=6.46p PS=7.2u
+ PD=7.2u
* device instance $221 m0 *1 81.6,408.7 NMOS
XM$221 VSS \$I1858 \$I1859 VSS NMOS L=1u W=3.4u AS=6.46p AD=6.46p PS=7.2u
+ PD=7.2u
* device instance $222 m0 *1 86.4,408.7 NMOS
XM$222 \$I1859 WL13 BLB3 VSS NMOS L=1u W=3.4u AS=6.46p AD=10.88p PS=7.2u
+ PD=13.2u
* device instance $223 m0 *1 76.8,92.3 PMOS
XM$223 \$I1860 \$I1861 VDD VDD PMOS L=1u W=3.4u AS=10.88p AD=6.46p PS=13.2u
+ PD=7.2u
* device instance $224 m0 *1 81.6,92.3 PMOS
XM$224 VDD \$I1860 \$I1861 VDD PMOS L=1u W=3.4u AS=6.46p AD=10.88p PS=7.2u
+ PD=13.2u
* device instance $225 m0 *1 72,112.7 NMOS
XM$225 BL3 WL3 \$I1860 VSS NMOS L=1u W=3.4u AS=10.88p AD=6.46p PS=13.2u PD=7.2u
* device instance $226 m0 *1 76.8,112.7 NMOS
XM$226 \$I1860 \$I1861 VSS VSS NMOS L=1u W=3.4u AS=6.46p AD=6.46p PS=7.2u
+ PD=7.2u
* device instance $227 m0 *1 81.6,112.7 NMOS
XM$227 VSS \$I1860 \$I1861 VSS NMOS L=1u W=3.4u AS=6.46p AD=6.46p PS=7.2u
+ PD=7.2u
* device instance $228 m0 *1 86.4,112.7 NMOS
XM$228 \$I1861 WL3 BLB3 VSS NMOS L=1u W=3.4u AS=6.46p AD=10.88p PS=7.2u PD=13.2u
* device instance $229 m0 *1 76.8,210.7 PMOS
XM$229 \$I1862 \$I1863 VDD VDD PMOS L=1u W=3.4u AS=10.88p AD=6.46p PS=13.2u
+ PD=7.2u
* device instance $230 m0 *1 81.6,210.7 PMOS
XM$230 VDD \$I1862 \$I1863 VDD PMOS L=1u W=3.4u AS=6.46p AD=10.88p PS=7.2u
+ PD=13.2u
* device instance $231 m0 *1 72,231.1 NMOS
XM$231 BL3 WL7 \$I1862 VSS NMOS L=1u W=3.4u AS=10.88p AD=6.46p PS=13.2u PD=7.2u
* device instance $232 m0 *1 76.8,231.1 NMOS
XM$232 \$I1862 \$I1863 VSS VSS NMOS L=1u W=3.4u AS=6.46p AD=6.46p PS=7.2u
+ PD=7.2u
* device instance $233 m0 *1 81.6,231.1 NMOS
XM$233 VSS \$I1862 \$I1863 VSS NMOS L=1u W=3.4u AS=6.46p AD=6.46p PS=7.2u
+ PD=7.2u
* device instance $234 m0 *1 86.4,231.1 NMOS
XM$234 \$I1863 WL7 BLB3 VSS NMOS L=1u W=3.4u AS=6.46p AD=10.88p PS=7.2u PD=13.2u
* device instance $235 r0 *1 76.8,262.9 PMOS
XM$235 \$I1864 \$I1865 VDD VDD PMOS L=1u W=3.4u AS=10.88p AD=6.46p PS=13.2u
+ PD=7.2u
* device instance $236 r0 *1 81.6,262.9 PMOS
XM$236 VDD \$I1864 \$I1865 VDD PMOS L=1u W=3.4u AS=6.46p AD=10.88p PS=7.2u
+ PD=13.2u
* device instance $237 r0 *1 72,242.5 NMOS
XM$237 BL3 WL8 \$I1864 VSS NMOS L=1u W=3.4u AS=10.88p AD=6.46p PS=13.2u PD=7.2u
* device instance $238 r0 *1 76.8,242.5 NMOS
XM$238 \$I1864 \$I1865 VSS VSS NMOS L=1u W=3.4u AS=6.46p AD=6.46p PS=7.2u
+ PD=7.2u
* device instance $239 r0 *1 81.6,242.5 NMOS
XM$239 VSS \$I1864 \$I1865 VSS NMOS L=1u W=3.4u AS=6.46p AD=6.46p PS=7.2u
+ PD=7.2u
* device instance $240 r0 *1 86.4,242.5 NMOS
XM$240 \$I1865 WL8 BLB3 VSS NMOS L=1u W=3.4u AS=6.46p AD=10.88p PS=7.2u PD=13.2u
* device instance $241 r0 *1 76.8,381.3 PMOS
XM$241 \$I1866 \$I1867 VDD VDD PMOS L=1u W=3.4u AS=10.88p AD=6.46p PS=13.2u
+ PD=7.2u
* device instance $242 r0 *1 81.6,381.3 PMOS
XM$242 VDD \$I1866 \$I1867 VDD PMOS L=1u W=3.4u AS=6.46p AD=10.88p PS=7.2u
+ PD=13.2u
* device instance $243 r0 *1 72,360.9 NMOS
XM$243 BL3 WL12 \$I1866 VSS NMOS L=1u W=3.4u AS=10.88p AD=6.46p PS=13.2u PD=7.2u
* device instance $244 r0 *1 76.8,360.9 NMOS
XM$244 \$I1866 \$I1867 VSS VSS NMOS L=1u W=3.4u AS=6.46p AD=6.46p PS=7.2u
+ PD=7.2u
* device instance $245 r0 *1 81.6,360.9 NMOS
XM$245 VSS \$I1866 \$I1867 VSS NMOS L=1u W=3.4u AS=6.46p AD=6.46p PS=7.2u
+ PD=7.2u
* device instance $246 r0 *1 86.4,360.9 NMOS
XM$246 \$I1867 WL12 BLB3 VSS NMOS L=1u W=3.4u AS=6.46p AD=10.88p PS=7.2u
+ PD=13.2u
* device instance $247 r0 *1 76.8,203.7 PMOS
XM$247 \$I1868 \$I1869 VDD VDD PMOS L=1u W=3.4u AS=10.88p AD=6.46p PS=13.2u
+ PD=7.2u
* device instance $248 r0 *1 81.6,203.7 PMOS
XM$248 VDD \$I1868 \$I1869 VDD PMOS L=1u W=3.4u AS=6.46p AD=10.88p PS=7.2u
+ PD=13.2u
* device instance $249 r0 *1 72,183.3 NMOS
XM$249 BL3 WL6 \$I1868 VSS NMOS L=1u W=3.4u AS=10.88p AD=6.46p PS=13.2u PD=7.2u
* device instance $250 r0 *1 76.8,183.3 NMOS
XM$250 \$I1868 \$I1869 VSS VSS NMOS L=1u W=3.4u AS=6.46p AD=6.46p PS=7.2u
+ PD=7.2u
* device instance $251 r0 *1 81.6,183.3 NMOS
XM$251 VSS \$I1868 \$I1869 VSS NMOS L=1u W=3.4u AS=6.46p AD=6.46p PS=7.2u
+ PD=7.2u
* device instance $252 r0 *1 86.4,183.3 NMOS
XM$252 \$I1869 WL6 BLB3 VSS NMOS L=1u W=3.4u AS=6.46p AD=10.88p PS=7.2u PD=13.2u
* device instance $253 r0 *1 76.8,85.3 PMOS
XM$253 \$I1870 \$I1871 VDD VDD PMOS L=1u W=3.4u AS=10.88p AD=6.46p PS=13.2u
+ PD=7.2u
* device instance $254 r0 *1 81.6,85.3 PMOS
XM$254 VDD \$I1870 \$I1871 VDD PMOS L=1u W=3.4u AS=6.46p AD=10.88p PS=7.2u
+ PD=13.2u
* device instance $255 r0 *1 72,64.9 NMOS
XM$255 BL3 WL2 \$I1870 VSS NMOS L=1u W=3.4u AS=10.88p AD=6.46p PS=13.2u PD=7.2u
* device instance $256 r0 *1 76.8,64.9 NMOS
XM$256 \$I1870 \$I1871 VSS VSS NMOS L=1u W=3.4u AS=6.46p AD=6.46p PS=7.2u
+ PD=7.2u
* device instance $257 r0 *1 81.6,64.9 NMOS
XM$257 VSS \$I1870 \$I1871 VSS NMOS L=1u W=3.4u AS=6.46p AD=6.46p PS=7.2u
+ PD=7.2u
* device instance $258 r0 *1 86.4,64.9 NMOS
XM$258 \$I1871 WL2 BLB3 VSS NMOS L=1u W=3.4u AS=6.46p AD=10.88p PS=7.2u PD=13.2u
* device instance $259 r0 *1 76.8,322.1 PMOS
XM$259 \$I1872 \$I1873 VDD VDD PMOS L=1u W=3.4u AS=10.88p AD=6.46p PS=13.2u
+ PD=7.2u
* device instance $260 r0 *1 81.6,322.1 PMOS
XM$260 VDD \$I1872 \$I1873 VDD PMOS L=1u W=3.4u AS=6.46p AD=10.88p PS=7.2u
+ PD=13.2u
* device instance $261 r0 *1 72,301.7 NMOS
XM$261 BL3 WL10 \$I1872 VSS NMOS L=1u W=3.4u AS=10.88p AD=6.46p PS=13.2u PD=7.2u
* device instance $262 r0 *1 76.8,301.7 NMOS
XM$262 \$I1872 \$I1873 VSS VSS NMOS L=1u W=3.4u AS=6.46p AD=6.46p PS=7.2u
+ PD=7.2u
* device instance $263 r0 *1 81.6,301.7 NMOS
XM$263 VSS \$I1872 \$I1873 VSS NMOS L=1u W=3.4u AS=6.46p AD=6.46p PS=7.2u
+ PD=7.2u
* device instance $264 r0 *1 86.4,301.7 NMOS
XM$264 \$I1873 WL10 BLB3 VSS NMOS L=1u W=3.4u AS=6.46p AD=10.88p PS=7.2u
+ PD=13.2u
* device instance $265 r0 *1 76.8,144.5 PMOS
XM$265 \$I1874 \$I1875 VDD VDD PMOS L=1u W=3.4u AS=10.88p AD=6.46p PS=13.2u
+ PD=7.2u
* device instance $266 r0 *1 81.6,144.5 PMOS
XM$266 VDD \$I1874 \$I1875 VDD PMOS L=1u W=3.4u AS=6.46p AD=10.88p PS=7.2u
+ PD=13.2u
* device instance $267 r0 *1 72,124.1 NMOS
XM$267 BL3 WL4 \$I1874 VSS NMOS L=1u W=3.4u AS=10.88p AD=6.46p PS=13.2u PD=7.2u
* device instance $268 r0 *1 76.8,124.1 NMOS
XM$268 \$I1874 \$I1875 VSS VSS NMOS L=1u W=3.4u AS=6.46p AD=6.46p PS=7.2u
+ PD=7.2u
* device instance $269 r0 *1 81.6,124.1 NMOS
XM$269 VSS \$I1874 \$I1875 VSS NMOS L=1u W=3.4u AS=6.46p AD=6.46p PS=7.2u
+ PD=7.2u
* device instance $270 r0 *1 86.4,124.1 NMOS
XM$270 \$I1875 WL4 BLB3 VSS NMOS L=1u W=3.4u AS=6.46p AD=10.88p PS=7.2u PD=13.2u
* device instance $271 r0 *1 76.8,440.5 PMOS
XM$271 \$I1876 \$I1877 VDD VDD PMOS L=1u W=3.4u AS=10.88p AD=6.46p PS=13.2u
+ PD=7.2u
* device instance $272 r0 *1 81.6,440.5 PMOS
XM$272 VDD \$I1876 \$I1877 VDD PMOS L=1u W=3.4u AS=6.46p AD=10.88p PS=7.2u
+ PD=13.2u
* device instance $273 r0 *1 72,420.1 NMOS
XM$273 BL3 WL14 \$I1876 VSS NMOS L=1u W=3.4u AS=10.88p AD=6.46p PS=13.2u PD=7.2u
* device instance $274 r0 *1 76.8,420.1 NMOS
XM$274 \$I1876 \$I1877 VSS VSS NMOS L=1u W=3.4u AS=6.46p AD=6.46p PS=7.2u
+ PD=7.2u
* device instance $275 r0 *1 81.6,420.1 NMOS
XM$275 VSS \$I1876 \$I1877 VSS NMOS L=1u W=3.4u AS=6.46p AD=6.46p PS=7.2u
+ PD=7.2u
* device instance $276 r0 *1 86.4,420.1 NMOS
XM$276 \$I1877 WL14 BLB3 VSS NMOS L=1u W=3.4u AS=6.46p AD=10.88p PS=7.2u
+ PD=13.2u
* device instance $277 m0 *1 53.6,269.9 PMOS
XM$277 \$I1878 \$I1879 VDD VDD PMOS L=1u W=3.4u AS=10.88p AD=6.46p PS=13.2u
+ PD=7.2u
* device instance $278 m0 *1 58.4,269.9 PMOS
XM$278 VDD \$I1878 \$I1879 VDD PMOS L=1u W=3.4u AS=6.46p AD=10.88p PS=7.2u
+ PD=13.2u
* device instance $279 m0 *1 48.8,290.3 NMOS
XM$279 BL2 WL9 \$I1878 VSS NMOS L=1u W=3.4u AS=10.88p AD=6.46p PS=13.2u PD=7.2u
* device instance $280 m0 *1 53.6,290.3 NMOS
XM$280 \$I1878 \$I1879 VSS VSS NMOS L=1u W=3.4u AS=6.46p AD=6.46p PS=7.2u
+ PD=7.2u
* device instance $281 m0 *1 58.4,290.3 NMOS
XM$281 VSS \$I1878 \$I1879 VSS NMOS L=1u W=3.4u AS=6.46p AD=6.46p PS=7.2u
+ PD=7.2u
* device instance $282 m0 *1 63.2,290.3 NMOS
XM$282 \$I1879 WL9 BLB2 VSS NMOS L=1u W=3.4u AS=6.46p AD=10.88p PS=7.2u PD=13.2u
* device instance $283 m0 *1 53.6,447.5 PMOS
XM$283 \$I1880 \$I1881 VDD VDD PMOS L=1u W=3.4u AS=10.88p AD=6.46p PS=13.2u
+ PD=7.2u
* device instance $284 m0 *1 58.4,447.5 PMOS
XM$284 VDD \$I1880 \$I1881 VDD PMOS L=1u W=3.4u AS=6.46p AD=10.88p PS=7.2u
+ PD=13.2u
* device instance $285 m0 *1 48.8,467.9 NMOS
XM$285 BL2 WL15 \$I1880 VSS NMOS L=1u W=3.4u AS=10.88p AD=6.46p PS=13.2u PD=7.2u
* device instance $286 m0 *1 53.6,467.9 NMOS
XM$286 \$I1880 \$I1881 VSS VSS NMOS L=1u W=3.4u AS=6.46p AD=6.46p PS=7.2u
+ PD=7.2u
* device instance $287 m0 *1 58.4,467.9 NMOS
XM$287 VSS \$I1880 \$I1881 VSS NMOS L=1u W=3.4u AS=6.46p AD=6.46p PS=7.2u
+ PD=7.2u
* device instance $288 m0 *1 63.2,467.9 NMOS
XM$288 \$I1881 WL15 BLB2 VSS NMOS L=1u W=3.4u AS=6.46p AD=10.88p PS=7.2u
+ PD=13.2u
* device instance $289 m0 *1 53.6,210.7 PMOS
XM$289 \$I1882 \$I1883 VDD VDD PMOS L=1u W=3.4u AS=10.88p AD=6.46p PS=13.2u
+ PD=7.2u
* device instance $290 m0 *1 58.4,210.7 PMOS
XM$290 VDD \$I1882 \$I1883 VDD PMOS L=1u W=3.4u AS=6.46p AD=10.88p PS=7.2u
+ PD=13.2u
* device instance $291 m0 *1 48.8,231.1 NMOS
XM$291 BL2 WL7 \$I1882 VSS NMOS L=1u W=3.4u AS=10.88p AD=6.46p PS=13.2u PD=7.2u
* device instance $292 m0 *1 53.6,231.1 NMOS
XM$292 \$I1882 \$I1883 VSS VSS NMOS L=1u W=3.4u AS=6.46p AD=6.46p PS=7.2u
+ PD=7.2u
* device instance $293 m0 *1 58.4,231.1 NMOS
XM$293 VSS \$I1882 \$I1883 VSS NMOS L=1u W=3.4u AS=6.46p AD=6.46p PS=7.2u
+ PD=7.2u
* device instance $294 m0 *1 63.2,231.1 NMOS
XM$294 \$I1883 WL7 BLB2 VSS NMOS L=1u W=3.4u AS=6.46p AD=10.88p PS=7.2u PD=13.2u
* device instance $295 m0 *1 53.6,329.1 PMOS
XM$295 \$I1884 \$I1885 VDD VDD PMOS L=1u W=3.4u AS=10.88p AD=6.46p PS=13.2u
+ PD=7.2u
* device instance $296 m0 *1 58.4,329.1 PMOS
XM$296 VDD \$I1884 \$I1885 VDD PMOS L=1u W=3.4u AS=6.46p AD=10.88p PS=7.2u
+ PD=13.2u
* device instance $297 m0 *1 48.8,349.5 NMOS
XM$297 BL2 WL11 \$I1884 VSS NMOS L=1u W=3.4u AS=10.88p AD=6.46p PS=13.2u PD=7.2u
* device instance $298 m0 *1 53.6,349.5 NMOS
XM$298 \$I1884 \$I1885 VSS VSS NMOS L=1u W=3.4u AS=6.46p AD=6.46p PS=7.2u
+ PD=7.2u
* device instance $299 m0 *1 58.4,349.5 NMOS
XM$299 VSS \$I1884 \$I1885 VSS NMOS L=1u W=3.4u AS=6.46p AD=6.46p PS=7.2u
+ PD=7.2u
* device instance $300 m0 *1 63.2,349.5 NMOS
XM$300 \$I1885 WL11 BLB2 VSS NMOS L=1u W=3.4u AS=6.46p AD=10.88p PS=7.2u
+ PD=13.2u
* device instance $301 m0 *1 53.6,33.1 PMOS
XM$301 \$I1886 \$I1887 VDD VDD PMOS L=1u W=3.4u AS=10.88p AD=6.46p PS=13.2u
+ PD=7.2u
* device instance $302 m0 *1 58.4,33.1 PMOS
XM$302 VDD \$I1886 \$I1887 VDD PMOS L=1u W=3.4u AS=6.46p AD=10.88p PS=7.2u
+ PD=13.2u
* device instance $303 m0 *1 48.8,53.5 NMOS
XM$303 BL2 WL1 \$I1886 VSS NMOS L=1u W=3.4u AS=10.88p AD=6.46p PS=13.2u PD=7.2u
* device instance $304 m0 *1 53.6,53.5 NMOS
XM$304 \$I1886 \$I1887 VSS VSS NMOS L=1u W=3.4u AS=6.46p AD=6.46p PS=7.2u
+ PD=7.2u
* device instance $305 m0 *1 58.4,53.5 NMOS
XM$305 VSS \$I1886 \$I1887 VSS NMOS L=1u W=3.4u AS=6.46p AD=6.46p PS=7.2u
+ PD=7.2u
* device instance $306 m0 *1 63.2,53.5 NMOS
XM$306 \$I1887 WL1 BLB2 VSS NMOS L=1u W=3.4u AS=6.46p AD=10.88p PS=7.2u PD=13.2u
* device instance $307 m0 *1 53.6,388.3 PMOS
XM$307 \$I1888 \$I1889 VDD VDD PMOS L=1u W=3.4u AS=10.88p AD=6.46p PS=13.2u
+ PD=7.2u
* device instance $308 m0 *1 58.4,388.3 PMOS
XM$308 VDD \$I1888 \$I1889 VDD PMOS L=1u W=3.4u AS=6.46p AD=10.88p PS=7.2u
+ PD=13.2u
* device instance $309 m0 *1 48.8,408.7 NMOS
XM$309 BL2 WL13 \$I1888 VSS NMOS L=1u W=3.4u AS=10.88p AD=6.46p PS=13.2u PD=7.2u
* device instance $310 m0 *1 53.6,408.7 NMOS
XM$310 \$I1888 \$I1889 VSS VSS NMOS L=1u W=3.4u AS=6.46p AD=6.46p PS=7.2u
+ PD=7.2u
* device instance $311 m0 *1 58.4,408.7 NMOS
XM$311 VSS \$I1888 \$I1889 VSS NMOS L=1u W=3.4u AS=6.46p AD=6.46p PS=7.2u
+ PD=7.2u
* device instance $312 m0 *1 63.2,408.7 NMOS
XM$312 \$I1889 WL13 BLB2 VSS NMOS L=1u W=3.4u AS=6.46p AD=10.88p PS=7.2u
+ PD=13.2u
* device instance $313 m0 *1 53.6,151.5 PMOS
XM$313 \$I1890 \$I1891 VDD VDD PMOS L=1u W=3.4u AS=10.88p AD=6.46p PS=13.2u
+ PD=7.2u
* device instance $314 m0 *1 58.4,151.5 PMOS
XM$314 VDD \$I1890 \$I1891 VDD PMOS L=1u W=3.4u AS=6.46p AD=10.88p PS=7.2u
+ PD=13.2u
* device instance $315 m0 *1 48.8,171.9 NMOS
XM$315 BL2 WL5 \$I1890 VSS NMOS L=1u W=3.4u AS=10.88p AD=6.46p PS=13.2u PD=7.2u
* device instance $316 m0 *1 53.6,171.9 NMOS
XM$316 \$I1890 \$I1891 VSS VSS NMOS L=1u W=3.4u AS=6.46p AD=6.46p PS=7.2u
+ PD=7.2u
* device instance $317 m0 *1 58.4,171.9 NMOS
XM$317 VSS \$I1890 \$I1891 VSS NMOS L=1u W=3.4u AS=6.46p AD=6.46p PS=7.2u
+ PD=7.2u
* device instance $318 m0 *1 63.2,171.9 NMOS
XM$318 \$I1891 WL5 BLB2 VSS NMOS L=1u W=3.4u AS=6.46p AD=10.88p PS=7.2u PD=13.2u
* device instance $319 m0 *1 53.6,92.3 PMOS
XM$319 \$I1892 \$I1893 VDD VDD PMOS L=1u W=3.4u AS=10.88p AD=6.46p PS=13.2u
+ PD=7.2u
* device instance $320 m0 *1 58.4,92.3 PMOS
XM$320 VDD \$I1892 \$I1893 VDD PMOS L=1u W=3.4u AS=6.46p AD=10.88p PS=7.2u
+ PD=13.2u
* device instance $321 m0 *1 48.8,112.7 NMOS
XM$321 BL2 WL3 \$I1892 VSS NMOS L=1u W=3.4u AS=10.88p AD=6.46p PS=13.2u PD=7.2u
* device instance $322 m0 *1 53.6,112.7 NMOS
XM$322 \$I1892 \$I1893 VSS VSS NMOS L=1u W=3.4u AS=6.46p AD=6.46p PS=7.2u
+ PD=7.2u
* device instance $323 m0 *1 58.4,112.7 NMOS
XM$323 VSS \$I1892 \$I1893 VSS NMOS L=1u W=3.4u AS=6.46p AD=6.46p PS=7.2u
+ PD=7.2u
* device instance $324 m0 *1 63.2,112.7 NMOS
XM$324 \$I1893 WL3 BLB2 VSS NMOS L=1u W=3.4u AS=6.46p AD=10.88p PS=7.2u PD=13.2u
* device instance $325 r0 *1 53.6,262.9 PMOS
XM$325 \$I1894 \$I1895 VDD VDD PMOS L=1u W=3.4u AS=10.88p AD=6.46p PS=13.2u
+ PD=7.2u
* device instance $326 r0 *1 58.4,262.9 PMOS
XM$326 VDD \$I1894 \$I1895 VDD PMOS L=1u W=3.4u AS=6.46p AD=10.88p PS=7.2u
+ PD=13.2u
* device instance $327 r0 *1 48.8,242.5 NMOS
XM$327 BL2 WL8 \$I1894 VSS NMOS L=1u W=3.4u AS=10.88p AD=6.46p PS=13.2u PD=7.2u
* device instance $328 r0 *1 53.6,242.5 NMOS
XM$328 \$I1894 \$I1895 VSS VSS NMOS L=1u W=3.4u AS=6.46p AD=6.46p PS=7.2u
+ PD=7.2u
* device instance $329 r0 *1 58.4,242.5 NMOS
XM$329 VSS \$I1894 \$I1895 VSS NMOS L=1u W=3.4u AS=6.46p AD=6.46p PS=7.2u
+ PD=7.2u
* device instance $330 r0 *1 63.2,242.5 NMOS
XM$330 \$I1895 WL8 BLB2 VSS NMOS L=1u W=3.4u AS=6.46p AD=10.88p PS=7.2u PD=13.2u
* device instance $331 r0 *1 53.6,381.3 PMOS
XM$331 \$I1896 \$I1897 VDD VDD PMOS L=1u W=3.4u AS=10.88p AD=6.46p PS=13.2u
+ PD=7.2u
* device instance $332 r0 *1 58.4,381.3 PMOS
XM$332 VDD \$I1896 \$I1897 VDD PMOS L=1u W=3.4u AS=6.46p AD=10.88p PS=7.2u
+ PD=13.2u
* device instance $333 r0 *1 48.8,360.9 NMOS
XM$333 BL2 WL12 \$I1896 VSS NMOS L=1u W=3.4u AS=10.88p AD=6.46p PS=13.2u PD=7.2u
* device instance $334 r0 *1 53.6,360.9 NMOS
XM$334 \$I1896 \$I1897 VSS VSS NMOS L=1u W=3.4u AS=6.46p AD=6.46p PS=7.2u
+ PD=7.2u
* device instance $335 r0 *1 58.4,360.9 NMOS
XM$335 VSS \$I1896 \$I1897 VSS NMOS L=1u W=3.4u AS=6.46p AD=6.46p PS=7.2u
+ PD=7.2u
* device instance $336 r0 *1 63.2,360.9 NMOS
XM$336 \$I1897 WL12 BLB2 VSS NMOS L=1u W=3.4u AS=6.46p AD=10.88p PS=7.2u
+ PD=13.2u
* device instance $337 r0 *1 53.6,203.7 PMOS
XM$337 \$I1898 \$I1899 VDD VDD PMOS L=1u W=3.4u AS=10.88p AD=6.46p PS=13.2u
+ PD=7.2u
* device instance $338 r0 *1 58.4,203.7 PMOS
XM$338 VDD \$I1898 \$I1899 VDD PMOS L=1u W=3.4u AS=6.46p AD=10.88p PS=7.2u
+ PD=13.2u
* device instance $339 r0 *1 48.8,183.3 NMOS
XM$339 BL2 WL6 \$I1898 VSS NMOS L=1u W=3.4u AS=10.88p AD=6.46p PS=13.2u PD=7.2u
* device instance $340 r0 *1 53.6,183.3 NMOS
XM$340 \$I1898 \$I1899 VSS VSS NMOS L=1u W=3.4u AS=6.46p AD=6.46p PS=7.2u
+ PD=7.2u
* device instance $341 r0 *1 58.4,183.3 NMOS
XM$341 VSS \$I1898 \$I1899 VSS NMOS L=1u W=3.4u AS=6.46p AD=6.46p PS=7.2u
+ PD=7.2u
* device instance $342 r0 *1 63.2,183.3 NMOS
XM$342 \$I1899 WL6 BLB2 VSS NMOS L=1u W=3.4u AS=6.46p AD=10.88p PS=7.2u PD=13.2u
* device instance $343 r0 *1 53.6,85.3 PMOS
XM$343 \$I1900 \$I1901 VDD VDD PMOS L=1u W=3.4u AS=10.88p AD=6.46p PS=13.2u
+ PD=7.2u
* device instance $344 r0 *1 58.4,85.3 PMOS
XM$344 VDD \$I1900 \$I1901 VDD PMOS L=1u W=3.4u AS=6.46p AD=10.88p PS=7.2u
+ PD=13.2u
* device instance $345 r0 *1 48.8,64.9 NMOS
XM$345 BL2 WL2 \$I1900 VSS NMOS L=1u W=3.4u AS=10.88p AD=6.46p PS=13.2u PD=7.2u
* device instance $346 r0 *1 53.6,64.9 NMOS
XM$346 \$I1900 \$I1901 VSS VSS NMOS L=1u W=3.4u AS=6.46p AD=6.46p PS=7.2u
+ PD=7.2u
* device instance $347 r0 *1 58.4,64.9 NMOS
XM$347 VSS \$I1900 \$I1901 VSS NMOS L=1u W=3.4u AS=6.46p AD=6.46p PS=7.2u
+ PD=7.2u
* device instance $348 r0 *1 63.2,64.9 NMOS
XM$348 \$I1901 WL2 BLB2 VSS NMOS L=1u W=3.4u AS=6.46p AD=10.88p PS=7.2u PD=13.2u
* device instance $349 r0 *1 53.6,144.5 PMOS
XM$349 \$I1902 \$I1903 VDD VDD PMOS L=1u W=3.4u AS=10.88p AD=6.46p PS=13.2u
+ PD=7.2u
* device instance $350 r0 *1 58.4,144.5 PMOS
XM$350 VDD \$I1902 \$I1903 VDD PMOS L=1u W=3.4u AS=6.46p AD=10.88p PS=7.2u
+ PD=13.2u
* device instance $351 r0 *1 48.8,124.1 NMOS
XM$351 BL2 WL4 \$I1902 VSS NMOS L=1u W=3.4u AS=10.88p AD=6.46p PS=13.2u PD=7.2u
* device instance $352 r0 *1 53.6,124.1 NMOS
XM$352 \$I1902 \$I1903 VSS VSS NMOS L=1u W=3.4u AS=6.46p AD=6.46p PS=7.2u
+ PD=7.2u
* device instance $353 r0 *1 58.4,124.1 NMOS
XM$353 VSS \$I1902 \$I1903 VSS NMOS L=1u W=3.4u AS=6.46p AD=6.46p PS=7.2u
+ PD=7.2u
* device instance $354 r0 *1 63.2,124.1 NMOS
XM$354 \$I1903 WL4 BLB2 VSS NMOS L=1u W=3.4u AS=6.46p AD=10.88p PS=7.2u PD=13.2u
* device instance $355 r0 *1 53.6,322.1 PMOS
XM$355 \$I1904 \$I1905 VDD VDD PMOS L=1u W=3.4u AS=10.88p AD=6.46p PS=13.2u
+ PD=7.2u
* device instance $356 r0 *1 58.4,322.1 PMOS
XM$356 VDD \$I1904 \$I1905 VDD PMOS L=1u W=3.4u AS=6.46p AD=10.88p PS=7.2u
+ PD=13.2u
* device instance $357 r0 *1 48.8,301.7 NMOS
XM$357 BL2 WL10 \$I1904 VSS NMOS L=1u W=3.4u AS=10.88p AD=6.46p PS=13.2u PD=7.2u
* device instance $358 r0 *1 53.6,301.7 NMOS
XM$358 \$I1904 \$I1905 VSS VSS NMOS L=1u W=3.4u AS=6.46p AD=6.46p PS=7.2u
+ PD=7.2u
* device instance $359 r0 *1 58.4,301.7 NMOS
XM$359 VSS \$I1904 \$I1905 VSS NMOS L=1u W=3.4u AS=6.46p AD=6.46p PS=7.2u
+ PD=7.2u
* device instance $360 r0 *1 63.2,301.7 NMOS
XM$360 \$I1905 WL10 BLB2 VSS NMOS L=1u W=3.4u AS=6.46p AD=10.88p PS=7.2u
+ PD=13.2u
* device instance $361 r0 *1 53.6,440.5 PMOS
XM$361 \$I1906 \$I1907 VDD VDD PMOS L=1u W=3.4u AS=10.88p AD=6.46p PS=13.2u
+ PD=7.2u
* device instance $362 r0 *1 58.4,440.5 PMOS
XM$362 VDD \$I1906 \$I1907 VDD PMOS L=1u W=3.4u AS=6.46p AD=10.88p PS=7.2u
+ PD=13.2u
* device instance $363 r0 *1 48.8,420.1 NMOS
XM$363 BL2 WL14 \$I1906 VSS NMOS L=1u W=3.4u AS=10.88p AD=6.46p PS=13.2u PD=7.2u
* device instance $364 r0 *1 53.6,420.1 NMOS
XM$364 \$I1906 \$I1907 VSS VSS NMOS L=1u W=3.4u AS=6.46p AD=6.46p PS=7.2u
+ PD=7.2u
* device instance $365 r0 *1 58.4,420.1 NMOS
XM$365 VSS \$I1906 \$I1907 VSS NMOS L=1u W=3.4u AS=6.46p AD=6.46p PS=7.2u
+ PD=7.2u
* device instance $366 r0 *1 63.2,420.1 NMOS
XM$366 \$I1907 WL14 BLB2 VSS NMOS L=1u W=3.4u AS=6.46p AD=10.88p PS=7.2u
+ PD=13.2u
* device instance $367 m0 *1 30.4,269.9 PMOS
XM$367 \$I1908 \$I1909 VDD VDD PMOS L=1u W=3.4u AS=10.88p AD=6.46p PS=13.2u
+ PD=7.2u
* device instance $368 m0 *1 35.2,269.9 PMOS
XM$368 VDD \$I1908 \$I1909 VDD PMOS L=1u W=3.4u AS=6.46p AD=10.88p PS=7.2u
+ PD=13.2u
* device instance $369 m0 *1 25.6,290.3 NMOS
XM$369 BL1 WL9 \$I1908 VSS NMOS L=1u W=3.4u AS=10.88p AD=6.46p PS=13.2u PD=7.2u
* device instance $370 m0 *1 30.4,290.3 NMOS
XM$370 \$I1908 \$I1909 VSS VSS NMOS L=1u W=3.4u AS=6.46p AD=6.46p PS=7.2u
+ PD=7.2u
* device instance $371 m0 *1 35.2,290.3 NMOS
XM$371 VSS \$I1908 \$I1909 VSS NMOS L=1u W=3.4u AS=6.46p AD=6.46p PS=7.2u
+ PD=7.2u
* device instance $372 m0 *1 40,290.3 NMOS
XM$372 \$I1909 WL9 BLB1 VSS NMOS L=1u W=3.4u AS=6.46p AD=10.88p PS=7.2u PD=13.2u
* device instance $373 m0 *1 30.4,329.1 PMOS
XM$373 \$I1910 \$I1911 VDD VDD PMOS L=1u W=3.4u AS=10.88p AD=6.46p PS=13.2u
+ PD=7.2u
* device instance $374 m0 *1 35.2,329.1 PMOS
XM$374 VDD \$I1910 \$I1911 VDD PMOS L=1u W=3.4u AS=6.46p AD=10.88p PS=7.2u
+ PD=13.2u
* device instance $375 m0 *1 25.6,349.5 NMOS
XM$375 BL1 WL11 \$I1910 VSS NMOS L=1u W=3.4u AS=10.88p AD=6.46p PS=13.2u PD=7.2u
* device instance $376 m0 *1 30.4,349.5 NMOS
XM$376 \$I1910 \$I1911 VSS VSS NMOS L=1u W=3.4u AS=6.46p AD=6.46p PS=7.2u
+ PD=7.2u
* device instance $377 m0 *1 35.2,349.5 NMOS
XM$377 VSS \$I1910 \$I1911 VSS NMOS L=1u W=3.4u AS=6.46p AD=6.46p PS=7.2u
+ PD=7.2u
* device instance $378 m0 *1 40,349.5 NMOS
XM$378 \$I1911 WL11 BLB1 VSS NMOS L=1u W=3.4u AS=6.46p AD=10.88p PS=7.2u
+ PD=13.2u
* device instance $379 m0 *1 30.4,447.5 PMOS
XM$379 \$I1912 \$I1913 VDD VDD PMOS L=1u W=3.4u AS=10.88p AD=6.46p PS=13.2u
+ PD=7.2u
* device instance $380 m0 *1 35.2,447.5 PMOS
XM$380 VDD \$I1912 \$I1913 VDD PMOS L=1u W=3.4u AS=6.46p AD=10.88p PS=7.2u
+ PD=13.2u
* device instance $381 m0 *1 25.6,467.9 NMOS
XM$381 BL1 WL15 \$I1912 VSS NMOS L=1u W=3.4u AS=10.88p AD=6.46p PS=13.2u PD=7.2u
* device instance $382 m0 *1 30.4,467.9 NMOS
XM$382 \$I1912 \$I1913 VSS VSS NMOS L=1u W=3.4u AS=6.46p AD=6.46p PS=7.2u
+ PD=7.2u
* device instance $383 m0 *1 35.2,467.9 NMOS
XM$383 VSS \$I1912 \$I1913 VSS NMOS L=1u W=3.4u AS=6.46p AD=6.46p PS=7.2u
+ PD=7.2u
* device instance $384 m0 *1 40,467.9 NMOS
XM$384 \$I1913 WL15 BLB1 VSS NMOS L=1u W=3.4u AS=6.46p AD=10.88p PS=7.2u
+ PD=13.2u
* device instance $385 m0 *1 30.4,210.7 PMOS
XM$385 \$I1914 \$I1915 VDD VDD PMOS L=1u W=3.4u AS=10.88p AD=6.46p PS=13.2u
+ PD=7.2u
* device instance $386 m0 *1 35.2,210.7 PMOS
XM$386 VDD \$I1914 \$I1915 VDD PMOS L=1u W=3.4u AS=6.46p AD=10.88p PS=7.2u
+ PD=13.2u
* device instance $387 m0 *1 25.6,231.1 NMOS
XM$387 BL1 WL7 \$I1914 VSS NMOS L=1u W=3.4u AS=10.88p AD=6.46p PS=13.2u PD=7.2u
* device instance $388 m0 *1 30.4,231.1 NMOS
XM$388 \$I1914 \$I1915 VSS VSS NMOS L=1u W=3.4u AS=6.46p AD=6.46p PS=7.2u
+ PD=7.2u
* device instance $389 m0 *1 35.2,231.1 NMOS
XM$389 VSS \$I1914 \$I1915 VSS NMOS L=1u W=3.4u AS=6.46p AD=6.46p PS=7.2u
+ PD=7.2u
* device instance $390 m0 *1 40,231.1 NMOS
XM$390 \$I1915 WL7 BLB1 VSS NMOS L=1u W=3.4u AS=6.46p AD=10.88p PS=7.2u PD=13.2u
* device instance $391 m0 *1 30.4,33.1 PMOS
XM$391 \$I1916 \$I1917 VDD VDD PMOS L=1u W=3.4u AS=10.88p AD=6.46p PS=13.2u
+ PD=7.2u
* device instance $392 m0 *1 35.2,33.1 PMOS
XM$392 VDD \$I1916 \$I1917 VDD PMOS L=1u W=3.4u AS=6.46p AD=10.88p PS=7.2u
+ PD=13.2u
* device instance $393 m0 *1 25.6,53.5 NMOS
XM$393 BL1 WL1 \$I1916 VSS NMOS L=1u W=3.4u AS=10.88p AD=6.46p PS=13.2u PD=7.2u
* device instance $394 m0 *1 30.4,53.5 NMOS
XM$394 \$I1916 \$I1917 VSS VSS NMOS L=1u W=3.4u AS=6.46p AD=6.46p PS=7.2u
+ PD=7.2u
* device instance $395 m0 *1 35.2,53.5 NMOS
XM$395 VSS \$I1916 \$I1917 VSS NMOS L=1u W=3.4u AS=6.46p AD=6.46p PS=7.2u
+ PD=7.2u
* device instance $396 m0 *1 40,53.5 NMOS
XM$396 \$I1917 WL1 BLB1 VSS NMOS L=1u W=3.4u AS=6.46p AD=10.88p PS=7.2u PD=13.2u
* device instance $397 m0 *1 30.4,151.5 PMOS
XM$397 \$I1918 \$I1919 VDD VDD PMOS L=1u W=3.4u AS=10.88p AD=6.46p PS=13.2u
+ PD=7.2u
* device instance $398 m0 *1 35.2,151.5 PMOS
XM$398 VDD \$I1918 \$I1919 VDD PMOS L=1u W=3.4u AS=6.46p AD=10.88p PS=7.2u
+ PD=13.2u
* device instance $399 m0 *1 25.6,171.9 NMOS
XM$399 BL1 WL5 \$I1918 VSS NMOS L=1u W=3.4u AS=10.88p AD=6.46p PS=13.2u PD=7.2u
* device instance $400 m0 *1 30.4,171.9 NMOS
XM$400 \$I1918 \$I1919 VSS VSS NMOS L=1u W=3.4u AS=6.46p AD=6.46p PS=7.2u
+ PD=7.2u
* device instance $401 m0 *1 35.2,171.9 NMOS
XM$401 VSS \$I1918 \$I1919 VSS NMOS L=1u W=3.4u AS=6.46p AD=6.46p PS=7.2u
+ PD=7.2u
* device instance $402 m0 *1 40,171.9 NMOS
XM$402 \$I1919 WL5 BLB1 VSS NMOS L=1u W=3.4u AS=6.46p AD=10.88p PS=7.2u PD=13.2u
* device instance $403 m0 *1 30.4,388.3 PMOS
XM$403 \$I1920 \$I1921 VDD VDD PMOS L=1u W=3.4u AS=10.88p AD=6.46p PS=13.2u
+ PD=7.2u
* device instance $404 m0 *1 35.2,388.3 PMOS
XM$404 VDD \$I1920 \$I1921 VDD PMOS L=1u W=3.4u AS=6.46p AD=10.88p PS=7.2u
+ PD=13.2u
* device instance $405 m0 *1 25.6,408.7 NMOS
XM$405 BL1 WL13 \$I1920 VSS NMOS L=1u W=3.4u AS=10.88p AD=6.46p PS=13.2u PD=7.2u
* device instance $406 m0 *1 30.4,408.7 NMOS
XM$406 \$I1920 \$I1921 VSS VSS NMOS L=1u W=3.4u AS=6.46p AD=6.46p PS=7.2u
+ PD=7.2u
* device instance $407 m0 *1 35.2,408.7 NMOS
XM$407 VSS \$I1920 \$I1921 VSS NMOS L=1u W=3.4u AS=6.46p AD=6.46p PS=7.2u
+ PD=7.2u
* device instance $408 m0 *1 40,408.7 NMOS
XM$408 \$I1921 WL13 BLB1 VSS NMOS L=1u W=3.4u AS=6.46p AD=10.88p PS=7.2u
+ PD=13.2u
* device instance $409 m0 *1 30.4,92.3 PMOS
XM$409 \$I1922 \$I1923 VDD VDD PMOS L=1u W=3.4u AS=10.88p AD=6.46p PS=13.2u
+ PD=7.2u
* device instance $410 m0 *1 35.2,92.3 PMOS
XM$410 VDD \$I1922 \$I1923 VDD PMOS L=1u W=3.4u AS=6.46p AD=10.88p PS=7.2u
+ PD=13.2u
* device instance $411 m0 *1 25.6,112.7 NMOS
XM$411 BL1 WL3 \$I1922 VSS NMOS L=1u W=3.4u AS=10.88p AD=6.46p PS=13.2u PD=7.2u
* device instance $412 m0 *1 30.4,112.7 NMOS
XM$412 \$I1922 \$I1923 VSS VSS NMOS L=1u W=3.4u AS=6.46p AD=6.46p PS=7.2u
+ PD=7.2u
* device instance $413 m0 *1 35.2,112.7 NMOS
XM$413 VSS \$I1922 \$I1923 VSS NMOS L=1u W=3.4u AS=6.46p AD=6.46p PS=7.2u
+ PD=7.2u
* device instance $414 m0 *1 40,112.7 NMOS
XM$414 \$I1923 WL3 BLB1 VSS NMOS L=1u W=3.4u AS=6.46p AD=10.88p PS=7.2u PD=13.2u
* device instance $415 r0 *1 30.4,381.3 PMOS
XM$415 \$I1924 \$I1925 VDD VDD PMOS L=1u W=3.4u AS=10.88p AD=6.46p PS=13.2u
+ PD=7.2u
* device instance $416 r0 *1 35.2,381.3 PMOS
XM$416 VDD \$I1924 \$I1925 VDD PMOS L=1u W=3.4u AS=6.46p AD=10.88p PS=7.2u
+ PD=13.2u
* device instance $417 r0 *1 25.6,360.9 NMOS
XM$417 BL1 WL12 \$I1924 VSS NMOS L=1u W=3.4u AS=10.88p AD=6.46p PS=13.2u PD=7.2u
* device instance $418 r0 *1 30.4,360.9 NMOS
XM$418 \$I1924 \$I1925 VSS VSS NMOS L=1u W=3.4u AS=6.46p AD=6.46p PS=7.2u
+ PD=7.2u
* device instance $419 r0 *1 35.2,360.9 NMOS
XM$419 VSS \$I1924 \$I1925 VSS NMOS L=1u W=3.4u AS=6.46p AD=6.46p PS=7.2u
+ PD=7.2u
* device instance $420 r0 *1 40,360.9 NMOS
XM$420 \$I1925 WL12 BLB1 VSS NMOS L=1u W=3.4u AS=6.46p AD=10.88p PS=7.2u
+ PD=13.2u
* device instance $421 r0 *1 30.4,203.7 PMOS
XM$421 \$I1926 \$I1927 VDD VDD PMOS L=1u W=3.4u AS=10.88p AD=6.46p PS=13.2u
+ PD=7.2u
* device instance $422 r0 *1 35.2,203.7 PMOS
XM$422 VDD \$I1926 \$I1927 VDD PMOS L=1u W=3.4u AS=6.46p AD=10.88p PS=7.2u
+ PD=13.2u
* device instance $423 r0 *1 25.6,183.3 NMOS
XM$423 BL1 WL6 \$I1926 VSS NMOS L=1u W=3.4u AS=10.88p AD=6.46p PS=13.2u PD=7.2u
* device instance $424 r0 *1 30.4,183.3 NMOS
XM$424 \$I1926 \$I1927 VSS VSS NMOS L=1u W=3.4u AS=6.46p AD=6.46p PS=7.2u
+ PD=7.2u
* device instance $425 r0 *1 35.2,183.3 NMOS
XM$425 VSS \$I1926 \$I1927 VSS NMOS L=1u W=3.4u AS=6.46p AD=6.46p PS=7.2u
+ PD=7.2u
* device instance $426 r0 *1 40,183.3 NMOS
XM$426 \$I1927 WL6 BLB1 VSS NMOS L=1u W=3.4u AS=6.46p AD=10.88p PS=7.2u PD=13.2u
* device instance $427 r0 *1 30.4,85.3 PMOS
XM$427 \$I1928 \$I1929 VDD VDD PMOS L=1u W=3.4u AS=10.88p AD=6.46p PS=13.2u
+ PD=7.2u
* device instance $428 r0 *1 35.2,85.3 PMOS
XM$428 VDD \$I1928 \$I1929 VDD PMOS L=1u W=3.4u AS=6.46p AD=10.88p PS=7.2u
+ PD=13.2u
* device instance $429 r0 *1 25.6,64.9 NMOS
XM$429 BL1 WL2 \$I1928 VSS NMOS L=1u W=3.4u AS=10.88p AD=6.46p PS=13.2u PD=7.2u
* device instance $430 r0 *1 30.4,64.9 NMOS
XM$430 \$I1928 \$I1929 VSS VSS NMOS L=1u W=3.4u AS=6.46p AD=6.46p PS=7.2u
+ PD=7.2u
* device instance $431 r0 *1 35.2,64.9 NMOS
XM$431 VSS \$I1928 \$I1929 VSS NMOS L=1u W=3.4u AS=6.46p AD=6.46p PS=7.2u
+ PD=7.2u
* device instance $432 r0 *1 40,64.9 NMOS
XM$432 \$I1929 WL2 BLB1 VSS NMOS L=1u W=3.4u AS=6.46p AD=10.88p PS=7.2u PD=13.2u
* device instance $433 r0 *1 30.4,144.5 PMOS
XM$433 \$I1930 \$I1931 VDD VDD PMOS L=1u W=3.4u AS=10.88p AD=6.46p PS=13.2u
+ PD=7.2u
* device instance $434 r0 *1 35.2,144.5 PMOS
XM$434 VDD \$I1930 \$I1931 VDD PMOS L=1u W=3.4u AS=6.46p AD=10.88p PS=7.2u
+ PD=13.2u
* device instance $435 r0 *1 25.6,124.1 NMOS
XM$435 BL1 WL4 \$I1930 VSS NMOS L=1u W=3.4u AS=10.88p AD=6.46p PS=13.2u PD=7.2u
* device instance $436 r0 *1 30.4,124.1 NMOS
XM$436 \$I1930 \$I1931 VSS VSS NMOS L=1u W=3.4u AS=6.46p AD=6.46p PS=7.2u
+ PD=7.2u
* device instance $437 r0 *1 35.2,124.1 NMOS
XM$437 VSS \$I1930 \$I1931 VSS NMOS L=1u W=3.4u AS=6.46p AD=6.46p PS=7.2u
+ PD=7.2u
* device instance $438 r0 *1 40,124.1 NMOS
XM$438 \$I1931 WL4 BLB1 VSS NMOS L=1u W=3.4u AS=6.46p AD=10.88p PS=7.2u PD=13.2u
* device instance $439 r0 *1 30.4,322.1 PMOS
XM$439 \$I1932 \$I1933 VDD VDD PMOS L=1u W=3.4u AS=10.88p AD=6.46p PS=13.2u
+ PD=7.2u
* device instance $440 r0 *1 35.2,322.1 PMOS
XM$440 VDD \$I1932 \$I1933 VDD PMOS L=1u W=3.4u AS=6.46p AD=10.88p PS=7.2u
+ PD=13.2u
* device instance $441 r0 *1 25.6,301.7 NMOS
XM$441 BL1 WL10 \$I1932 VSS NMOS L=1u W=3.4u AS=10.88p AD=6.46p PS=13.2u PD=7.2u
* device instance $442 r0 *1 30.4,301.7 NMOS
XM$442 \$I1932 \$I1933 VSS VSS NMOS L=1u W=3.4u AS=6.46p AD=6.46p PS=7.2u
+ PD=7.2u
* device instance $443 r0 *1 35.2,301.7 NMOS
XM$443 VSS \$I1932 \$I1933 VSS NMOS L=1u W=3.4u AS=6.46p AD=6.46p PS=7.2u
+ PD=7.2u
* device instance $444 r0 *1 40,301.7 NMOS
XM$444 \$I1933 WL10 BLB1 VSS NMOS L=1u W=3.4u AS=6.46p AD=10.88p PS=7.2u
+ PD=13.2u
* device instance $445 r0 *1 30.4,440.5 PMOS
XM$445 \$I1934 \$I1935 VDD VDD PMOS L=1u W=3.4u AS=10.88p AD=6.46p PS=13.2u
+ PD=7.2u
* device instance $446 r0 *1 35.2,440.5 PMOS
XM$446 VDD \$I1934 \$I1935 VDD PMOS L=1u W=3.4u AS=6.46p AD=10.88p PS=7.2u
+ PD=13.2u
* device instance $447 r0 *1 25.6,420.1 NMOS
XM$447 BL1 WL14 \$I1934 VSS NMOS L=1u W=3.4u AS=10.88p AD=6.46p PS=13.2u PD=7.2u
* device instance $448 r0 *1 30.4,420.1 NMOS
XM$448 \$I1934 \$I1935 VSS VSS NMOS L=1u W=3.4u AS=6.46p AD=6.46p PS=7.2u
+ PD=7.2u
* device instance $449 r0 *1 35.2,420.1 NMOS
XM$449 VSS \$I1934 \$I1935 VSS NMOS L=1u W=3.4u AS=6.46p AD=6.46p PS=7.2u
+ PD=7.2u
* device instance $450 r0 *1 40,420.1 NMOS
XM$450 \$I1935 WL14 BLB1 VSS NMOS L=1u W=3.4u AS=6.46p AD=10.88p PS=7.2u
+ PD=13.2u
* device instance $451 r0 *1 30.4,262.9 PMOS
XM$451 \$I1936 \$I1937 VDD VDD PMOS L=1u W=3.4u AS=10.88p AD=6.46p PS=13.2u
+ PD=7.2u
* device instance $452 r0 *1 35.2,262.9 PMOS
XM$452 VDD \$I1936 \$I1937 VDD PMOS L=1u W=3.4u AS=6.46p AD=10.88p PS=7.2u
+ PD=13.2u
* device instance $453 r0 *1 25.6,242.5 NMOS
XM$453 BL1 WL8 \$I1936 VSS NMOS L=1u W=3.4u AS=10.88p AD=6.46p PS=13.2u PD=7.2u
* device instance $454 r0 *1 30.4,242.5 NMOS
XM$454 \$I1936 \$I1937 VSS VSS NMOS L=1u W=3.4u AS=6.46p AD=6.46p PS=7.2u
+ PD=7.2u
* device instance $455 r0 *1 35.2,242.5 NMOS
XM$455 VSS \$I1936 \$I1937 VSS NMOS L=1u W=3.4u AS=6.46p AD=6.46p PS=7.2u
+ PD=7.2u
* device instance $456 r0 *1 40,242.5 NMOS
XM$456 \$I1937 WL8 BLB1 VSS NMOS L=1u W=3.4u AS=6.46p AD=10.88p PS=7.2u PD=13.2u
* device instance $457 m0 *1 146.4,447.5 PMOS
XM$457 \$I1938 \$I1939 VDD VDD PMOS L=1u W=3.4u AS=10.88p AD=6.46p PS=13.2u
+ PD=7.2u
* device instance $458 m0 *1 151.2,447.5 PMOS
XM$458 VDD \$I1938 \$I1939 VDD PMOS L=1u W=3.4u AS=6.46p AD=10.88p PS=7.2u
+ PD=13.2u
* device instance $459 m0 *1 141.6,467.9 NMOS
XM$459 BL6 WL15 \$I1938 VSS NMOS L=1u W=3.4u AS=10.88p AD=6.46p PS=13.2u PD=7.2u
* device instance $460 m0 *1 146.4,467.9 NMOS
XM$460 \$I1938 \$I1939 VSS VSS NMOS L=1u W=3.4u AS=6.46p AD=6.46p PS=7.2u
+ PD=7.2u
* device instance $461 m0 *1 151.2,467.9 NMOS
XM$461 VSS \$I1938 \$I1939 VSS NMOS L=1u W=3.4u AS=6.46p AD=6.46p PS=7.2u
+ PD=7.2u
* device instance $462 m0 *1 156,467.9 NMOS
XM$462 \$I1939 WL15 BLB6 VSS NMOS L=1u W=3.4u AS=6.46p AD=10.88p PS=7.2u
+ PD=13.2u
* device instance $463 m0 *1 146.4,329.1 PMOS
XM$463 \$I1940 \$I1941 VDD VDD PMOS L=1u W=3.4u AS=10.88p AD=6.46p PS=13.2u
+ PD=7.2u
* device instance $464 m0 *1 151.2,329.1 PMOS
XM$464 VDD \$I1940 \$I1941 VDD PMOS L=1u W=3.4u AS=6.46p AD=10.88p PS=7.2u
+ PD=13.2u
* device instance $465 m0 *1 141.6,349.5 NMOS
XM$465 BL6 WL11 \$I1940 VSS NMOS L=1u W=3.4u AS=10.88p AD=6.46p PS=13.2u PD=7.2u
* device instance $466 m0 *1 146.4,349.5 NMOS
XM$466 \$I1940 \$I1941 VSS VSS NMOS L=1u W=3.4u AS=6.46p AD=6.46p PS=7.2u
+ PD=7.2u
* device instance $467 m0 *1 151.2,349.5 NMOS
XM$467 VSS \$I1940 \$I1941 VSS NMOS L=1u W=3.4u AS=6.46p AD=6.46p PS=7.2u
+ PD=7.2u
* device instance $468 m0 *1 156,349.5 NMOS
XM$468 \$I1941 WL11 BLB6 VSS NMOS L=1u W=3.4u AS=6.46p AD=10.88p PS=7.2u
+ PD=13.2u
* device instance $469 m0 *1 146.4,151.5 PMOS
XM$469 \$I1942 \$I1943 VDD VDD PMOS L=1u W=3.4u AS=10.88p AD=6.46p PS=13.2u
+ PD=7.2u
* device instance $470 m0 *1 151.2,151.5 PMOS
XM$470 VDD \$I1942 \$I1943 VDD PMOS L=1u W=3.4u AS=6.46p AD=10.88p PS=7.2u
+ PD=13.2u
* device instance $471 m0 *1 141.6,171.9 NMOS
XM$471 BL6 WL5 \$I1942 VSS NMOS L=1u W=3.4u AS=10.88p AD=6.46p PS=13.2u PD=7.2u
* device instance $472 m0 *1 146.4,171.9 NMOS
XM$472 \$I1942 \$I1943 VSS VSS NMOS L=1u W=3.4u AS=6.46p AD=6.46p PS=7.2u
+ PD=7.2u
* device instance $473 m0 *1 151.2,171.9 NMOS
XM$473 VSS \$I1942 \$I1943 VSS NMOS L=1u W=3.4u AS=6.46p AD=6.46p PS=7.2u
+ PD=7.2u
* device instance $474 m0 *1 156,171.9 NMOS
XM$474 \$I1943 WL5 BLB6 VSS NMOS L=1u W=3.4u AS=6.46p AD=10.88p PS=7.2u PD=13.2u
* device instance $475 m0 *1 146.4,269.9 PMOS
XM$475 \$I1944 \$I1945 VDD VDD PMOS L=1u W=3.4u AS=10.88p AD=6.46p PS=13.2u
+ PD=7.2u
* device instance $476 m0 *1 151.2,269.9 PMOS
XM$476 VDD \$I1944 \$I1945 VDD PMOS L=1u W=3.4u AS=6.46p AD=10.88p PS=7.2u
+ PD=13.2u
* device instance $477 m0 *1 141.6,290.3 NMOS
XM$477 BL6 WL9 \$I1944 VSS NMOS L=1u W=3.4u AS=10.88p AD=6.46p PS=13.2u PD=7.2u
* device instance $478 m0 *1 146.4,290.3 NMOS
XM$478 \$I1944 \$I1945 VSS VSS NMOS L=1u W=3.4u AS=6.46p AD=6.46p PS=7.2u
+ PD=7.2u
* device instance $479 m0 *1 151.2,290.3 NMOS
XM$479 VSS \$I1944 \$I1945 VSS NMOS L=1u W=3.4u AS=6.46p AD=6.46p PS=7.2u
+ PD=7.2u
* device instance $480 m0 *1 156,290.3 NMOS
XM$480 \$I1945 WL9 BLB6 VSS NMOS L=1u W=3.4u AS=6.46p AD=10.88p PS=7.2u PD=13.2u
* device instance $481 m0 *1 146.4,388.3 PMOS
XM$481 \$I1946 \$I1947 VDD VDD PMOS L=1u W=3.4u AS=10.88p AD=6.46p PS=13.2u
+ PD=7.2u
* device instance $482 m0 *1 151.2,388.3 PMOS
XM$482 VDD \$I1946 \$I1947 VDD PMOS L=1u W=3.4u AS=6.46p AD=10.88p PS=7.2u
+ PD=13.2u
* device instance $483 m0 *1 141.6,408.7 NMOS
XM$483 BL6 WL13 \$I1946 VSS NMOS L=1u W=3.4u AS=10.88p AD=6.46p PS=13.2u PD=7.2u
* device instance $484 m0 *1 146.4,408.7 NMOS
XM$484 \$I1946 \$I1947 VSS VSS NMOS L=1u W=3.4u AS=6.46p AD=6.46p PS=7.2u
+ PD=7.2u
* device instance $485 m0 *1 151.2,408.7 NMOS
XM$485 VSS \$I1946 \$I1947 VSS NMOS L=1u W=3.4u AS=6.46p AD=6.46p PS=7.2u
+ PD=7.2u
* device instance $486 m0 *1 156,408.7 NMOS
XM$486 \$I1947 WL13 BLB6 VSS NMOS L=1u W=3.4u AS=6.46p AD=10.88p PS=7.2u
+ PD=13.2u
* device instance $487 m0 *1 146.4,92.3 PMOS
XM$487 \$I1948 \$I1949 VDD VDD PMOS L=1u W=3.4u AS=10.88p AD=6.46p PS=13.2u
+ PD=7.2u
* device instance $488 m0 *1 151.2,92.3 PMOS
XM$488 VDD \$I1948 \$I1949 VDD PMOS L=1u W=3.4u AS=6.46p AD=10.88p PS=7.2u
+ PD=13.2u
* device instance $489 m0 *1 141.6,112.7 NMOS
XM$489 BL6 WL3 \$I1948 VSS NMOS L=1u W=3.4u AS=10.88p AD=6.46p PS=13.2u PD=7.2u
* device instance $490 m0 *1 146.4,112.7 NMOS
XM$490 \$I1948 \$I1949 VSS VSS NMOS L=1u W=3.4u AS=6.46p AD=6.46p PS=7.2u
+ PD=7.2u
* device instance $491 m0 *1 151.2,112.7 NMOS
XM$491 VSS \$I1948 \$I1949 VSS NMOS L=1u W=3.4u AS=6.46p AD=6.46p PS=7.2u
+ PD=7.2u
* device instance $492 m0 *1 156,112.7 NMOS
XM$492 \$I1949 WL3 BLB6 VSS NMOS L=1u W=3.4u AS=6.46p AD=10.88p PS=7.2u PD=13.2u
* device instance $493 m0 *1 146.4,33.1 PMOS
XM$493 \$I1950 \$I1951 VDD VDD PMOS L=1u W=3.4u AS=10.88p AD=6.46p PS=13.2u
+ PD=7.2u
* device instance $494 m0 *1 151.2,33.1 PMOS
XM$494 VDD \$I1950 \$I1951 VDD PMOS L=1u W=3.4u AS=6.46p AD=10.88p PS=7.2u
+ PD=13.2u
* device instance $495 m0 *1 141.6,53.5 NMOS
XM$495 BL6 WL1 \$I1950 VSS NMOS L=1u W=3.4u AS=10.88p AD=6.46p PS=13.2u PD=7.2u
* device instance $496 m0 *1 146.4,53.5 NMOS
XM$496 \$I1950 \$I1951 VSS VSS NMOS L=1u W=3.4u AS=6.46p AD=6.46p PS=7.2u
+ PD=7.2u
* device instance $497 m0 *1 151.2,53.5 NMOS
XM$497 VSS \$I1950 \$I1951 VSS NMOS L=1u W=3.4u AS=6.46p AD=6.46p PS=7.2u
+ PD=7.2u
* device instance $498 m0 *1 156,53.5 NMOS
XM$498 \$I1951 WL1 BLB6 VSS NMOS L=1u W=3.4u AS=6.46p AD=10.88p PS=7.2u PD=13.2u
* device instance $499 m0 *1 146.4,210.7 PMOS
XM$499 \$I1952 \$I1953 VDD VDD PMOS L=1u W=3.4u AS=10.88p AD=6.46p PS=13.2u
+ PD=7.2u
* device instance $500 m0 *1 151.2,210.7 PMOS
XM$500 VDD \$I1952 \$I1953 VDD PMOS L=1u W=3.4u AS=6.46p AD=10.88p PS=7.2u
+ PD=13.2u
* device instance $501 m0 *1 141.6,231.1 NMOS
XM$501 BL6 WL7 \$I1952 VSS NMOS L=1u W=3.4u AS=10.88p AD=6.46p PS=13.2u PD=7.2u
* device instance $502 m0 *1 146.4,231.1 NMOS
XM$502 \$I1952 \$I1953 VSS VSS NMOS L=1u W=3.4u AS=6.46p AD=6.46p PS=7.2u
+ PD=7.2u
* device instance $503 m0 *1 151.2,231.1 NMOS
XM$503 VSS \$I1952 \$I1953 VSS NMOS L=1u W=3.4u AS=6.46p AD=6.46p PS=7.2u
+ PD=7.2u
* device instance $504 m0 *1 156,231.1 NMOS
XM$504 \$I1953 WL7 BLB6 VSS NMOS L=1u W=3.4u AS=6.46p AD=10.88p PS=7.2u PD=13.2u
* device instance $505 r0 *1 146.4,85.3 PMOS
XM$505 \$I1954 \$I1955 VDD VDD PMOS L=1u W=3.4u AS=10.88p AD=6.46p PS=13.2u
+ PD=7.2u
* device instance $506 r0 *1 151.2,85.3 PMOS
XM$506 VDD \$I1954 \$I1955 VDD PMOS L=1u W=3.4u AS=6.46p AD=10.88p PS=7.2u
+ PD=13.2u
* device instance $507 r0 *1 141.6,64.9 NMOS
XM$507 BL6 WL2 \$I1954 VSS NMOS L=1u W=3.4u AS=10.88p AD=6.46p PS=13.2u PD=7.2u
* device instance $508 r0 *1 146.4,64.9 NMOS
XM$508 \$I1954 \$I1955 VSS VSS NMOS L=1u W=3.4u AS=6.46p AD=6.46p PS=7.2u
+ PD=7.2u
* device instance $509 r0 *1 151.2,64.9 NMOS
XM$509 VSS \$I1954 \$I1955 VSS NMOS L=1u W=3.4u AS=6.46p AD=6.46p PS=7.2u
+ PD=7.2u
* device instance $510 r0 *1 156,64.9 NMOS
XM$510 \$I1955 WL2 BLB6 VSS NMOS L=1u W=3.4u AS=6.46p AD=10.88p PS=7.2u PD=13.2u
* device instance $511 r0 *1 146.4,381.3 PMOS
XM$511 \$I1956 \$I1957 VDD VDD PMOS L=1u W=3.4u AS=10.88p AD=6.46p PS=13.2u
+ PD=7.2u
* device instance $512 r0 *1 151.2,381.3 PMOS
XM$512 VDD \$I1956 \$I1957 VDD PMOS L=1u W=3.4u AS=6.46p AD=10.88p PS=7.2u
+ PD=13.2u
* device instance $513 r0 *1 141.6,360.9 NMOS
XM$513 BL6 WL12 \$I1956 VSS NMOS L=1u W=3.4u AS=10.88p AD=6.46p PS=13.2u PD=7.2u
* device instance $514 r0 *1 146.4,360.9 NMOS
XM$514 \$I1956 \$I1957 VSS VSS NMOS L=1u W=3.4u AS=6.46p AD=6.46p PS=7.2u
+ PD=7.2u
* device instance $515 r0 *1 151.2,360.9 NMOS
XM$515 VSS \$I1956 \$I1957 VSS NMOS L=1u W=3.4u AS=6.46p AD=6.46p PS=7.2u
+ PD=7.2u
* device instance $516 r0 *1 156,360.9 NMOS
XM$516 \$I1957 WL12 BLB6 VSS NMOS L=1u W=3.4u AS=6.46p AD=10.88p PS=7.2u
+ PD=13.2u
* device instance $517 r0 *1 146.4,322.1 PMOS
XM$517 \$I1958 \$I1959 VDD VDD PMOS L=1u W=3.4u AS=10.88p AD=6.46p PS=13.2u
+ PD=7.2u
* device instance $518 r0 *1 151.2,322.1 PMOS
XM$518 VDD \$I1958 \$I1959 VDD PMOS L=1u W=3.4u AS=6.46p AD=10.88p PS=7.2u
+ PD=13.2u
* device instance $519 r0 *1 141.6,301.7 NMOS
XM$519 BL6 WL10 \$I1958 VSS NMOS L=1u W=3.4u AS=10.88p AD=6.46p PS=13.2u PD=7.2u
* device instance $520 r0 *1 146.4,301.7 NMOS
XM$520 \$I1958 \$I1959 VSS VSS NMOS L=1u W=3.4u AS=6.46p AD=6.46p PS=7.2u
+ PD=7.2u
* device instance $521 r0 *1 151.2,301.7 NMOS
XM$521 VSS \$I1958 \$I1959 VSS NMOS L=1u W=3.4u AS=6.46p AD=6.46p PS=7.2u
+ PD=7.2u
* device instance $522 r0 *1 156,301.7 NMOS
XM$522 \$I1959 WL10 BLB6 VSS NMOS L=1u W=3.4u AS=6.46p AD=10.88p PS=7.2u
+ PD=13.2u
* device instance $523 r0 *1 146.4,203.7 PMOS
XM$523 \$I1960 \$I1961 VDD VDD PMOS L=1u W=3.4u AS=10.88p AD=6.46p PS=13.2u
+ PD=7.2u
* device instance $524 r0 *1 151.2,203.7 PMOS
XM$524 VDD \$I1960 \$I1961 VDD PMOS L=1u W=3.4u AS=6.46p AD=10.88p PS=7.2u
+ PD=13.2u
* device instance $525 r0 *1 141.6,183.3 NMOS
XM$525 BL6 WL6 \$I1960 VSS NMOS L=1u W=3.4u AS=10.88p AD=6.46p PS=13.2u PD=7.2u
* device instance $526 r0 *1 146.4,183.3 NMOS
XM$526 \$I1960 \$I1961 VSS VSS NMOS L=1u W=3.4u AS=6.46p AD=6.46p PS=7.2u
+ PD=7.2u
* device instance $527 r0 *1 151.2,183.3 NMOS
XM$527 VSS \$I1960 \$I1961 VSS NMOS L=1u W=3.4u AS=6.46p AD=6.46p PS=7.2u
+ PD=7.2u
* device instance $528 r0 *1 156,183.3 NMOS
XM$528 \$I1961 WL6 BLB6 VSS NMOS L=1u W=3.4u AS=6.46p AD=10.88p PS=7.2u PD=13.2u
* device instance $529 r0 *1 146.4,144.5 PMOS
XM$529 \$I1962 \$I1963 VDD VDD PMOS L=1u W=3.4u AS=10.88p AD=6.46p PS=13.2u
+ PD=7.2u
* device instance $530 r0 *1 151.2,144.5 PMOS
XM$530 VDD \$I1962 \$I1963 VDD PMOS L=1u W=3.4u AS=6.46p AD=10.88p PS=7.2u
+ PD=13.2u
* device instance $531 r0 *1 141.6,124.1 NMOS
XM$531 BL6 WL4 \$I1962 VSS NMOS L=1u W=3.4u AS=10.88p AD=6.46p PS=13.2u PD=7.2u
* device instance $532 r0 *1 146.4,124.1 NMOS
XM$532 \$I1962 \$I1963 VSS VSS NMOS L=1u W=3.4u AS=6.46p AD=6.46p PS=7.2u
+ PD=7.2u
* device instance $533 r0 *1 151.2,124.1 NMOS
XM$533 VSS \$I1962 \$I1963 VSS NMOS L=1u W=3.4u AS=6.46p AD=6.46p PS=7.2u
+ PD=7.2u
* device instance $534 r0 *1 156,124.1 NMOS
XM$534 \$I1963 WL4 BLB6 VSS NMOS L=1u W=3.4u AS=6.46p AD=10.88p PS=7.2u PD=13.2u
* device instance $535 r0 *1 146.4,262.9 PMOS
XM$535 \$I1964 \$I1965 VDD VDD PMOS L=1u W=3.4u AS=10.88p AD=6.46p PS=13.2u
+ PD=7.2u
* device instance $536 r0 *1 151.2,262.9 PMOS
XM$536 VDD \$I1964 \$I1965 VDD PMOS L=1u W=3.4u AS=6.46p AD=10.88p PS=7.2u
+ PD=13.2u
* device instance $537 r0 *1 141.6,242.5 NMOS
XM$537 BL6 WL8 \$I1964 VSS NMOS L=1u W=3.4u AS=10.88p AD=6.46p PS=13.2u PD=7.2u
* device instance $538 r0 *1 146.4,242.5 NMOS
XM$538 \$I1964 \$I1965 VSS VSS NMOS L=1u W=3.4u AS=6.46p AD=6.46p PS=7.2u
+ PD=7.2u
* device instance $539 r0 *1 151.2,242.5 NMOS
XM$539 VSS \$I1964 \$I1965 VSS NMOS L=1u W=3.4u AS=6.46p AD=6.46p PS=7.2u
+ PD=7.2u
* device instance $540 r0 *1 156,242.5 NMOS
XM$540 \$I1965 WL8 BLB6 VSS NMOS L=1u W=3.4u AS=6.46p AD=10.88p PS=7.2u PD=13.2u
* device instance $541 r0 *1 146.4,440.5 PMOS
XM$541 \$I1966 \$I1967 VDD VDD PMOS L=1u W=3.4u AS=10.88p AD=6.46p PS=13.2u
+ PD=7.2u
* device instance $542 r0 *1 151.2,440.5 PMOS
XM$542 VDD \$I1966 \$I1967 VDD PMOS L=1u W=3.4u AS=6.46p AD=10.88p PS=7.2u
+ PD=13.2u
* device instance $543 r0 *1 141.6,420.1 NMOS
XM$543 BL6 WL14 \$I1966 VSS NMOS L=1u W=3.4u AS=10.88p AD=6.46p PS=13.2u PD=7.2u
* device instance $544 r0 *1 146.4,420.1 NMOS
XM$544 \$I1966 \$I1967 VSS VSS NMOS L=1u W=3.4u AS=6.46p AD=6.46p PS=7.2u
+ PD=7.2u
* device instance $545 r0 *1 151.2,420.1 NMOS
XM$545 VSS \$I1966 \$I1967 VSS NMOS L=1u W=3.4u AS=6.46p AD=6.46p PS=7.2u
+ PD=7.2u
* device instance $546 r0 *1 156,420.1 NMOS
XM$546 \$I1967 WL14 BLB6 VSS NMOS L=1u W=3.4u AS=6.46p AD=10.88p PS=7.2u
+ PD=13.2u
* device instance $547 m0 *1 123.2,269.9 PMOS
XM$547 \$I1968 \$I1969 VDD VDD PMOS L=1u W=3.4u AS=10.88p AD=6.46p PS=13.2u
+ PD=7.2u
* device instance $548 m0 *1 128,269.9 PMOS
XM$548 VDD \$I1968 \$I1969 VDD PMOS L=1u W=3.4u AS=6.46p AD=10.88p PS=7.2u
+ PD=13.2u
* device instance $549 m0 *1 118.4,290.3 NMOS
XM$549 BL5 WL9 \$I1968 VSS NMOS L=1u W=3.4u AS=10.88p AD=6.46p PS=13.2u PD=7.2u
* device instance $550 m0 *1 123.2,290.3 NMOS
XM$550 \$I1968 \$I1969 VSS VSS NMOS L=1u W=3.4u AS=6.46p AD=6.46p PS=7.2u
+ PD=7.2u
* device instance $551 m0 *1 128,290.3 NMOS
XM$551 VSS \$I1968 \$I1969 VSS NMOS L=1u W=3.4u AS=6.46p AD=6.46p PS=7.2u
+ PD=7.2u
* device instance $552 m0 *1 132.8,290.3 NMOS
XM$552 \$I1969 WL9 BLB5 VSS NMOS L=1u W=3.4u AS=6.46p AD=10.88p PS=7.2u PD=13.2u
* device instance $553 m0 *1 123.2,447.5 PMOS
XM$553 \$I1970 \$I1971 VDD VDD PMOS L=1u W=3.4u AS=10.88p AD=6.46p PS=13.2u
+ PD=7.2u
* device instance $554 m0 *1 128,447.5 PMOS
XM$554 VDD \$I1970 \$I1971 VDD PMOS L=1u W=3.4u AS=6.46p AD=10.88p PS=7.2u
+ PD=13.2u
* device instance $555 m0 *1 118.4,467.9 NMOS
XM$555 BL5 WL15 \$I1970 VSS NMOS L=1u W=3.4u AS=10.88p AD=6.46p PS=13.2u PD=7.2u
* device instance $556 m0 *1 123.2,467.9 NMOS
XM$556 \$I1970 \$I1971 VSS VSS NMOS L=1u W=3.4u AS=6.46p AD=6.46p PS=7.2u
+ PD=7.2u
* device instance $557 m0 *1 128,467.9 NMOS
XM$557 VSS \$I1970 \$I1971 VSS NMOS L=1u W=3.4u AS=6.46p AD=6.46p PS=7.2u
+ PD=7.2u
* device instance $558 m0 *1 132.8,467.9 NMOS
XM$558 \$I1971 WL15 BLB5 VSS NMOS L=1u W=3.4u AS=6.46p AD=10.88p PS=7.2u
+ PD=13.2u
* device instance $559 m0 *1 123.2,329.1 PMOS
XM$559 \$I1972 \$I1973 VDD VDD PMOS L=1u W=3.4u AS=10.88p AD=6.46p PS=13.2u
+ PD=7.2u
* device instance $560 m0 *1 128,329.1 PMOS
XM$560 VDD \$I1972 \$I1973 VDD PMOS L=1u W=3.4u AS=6.46p AD=10.88p PS=7.2u
+ PD=13.2u
* device instance $561 m0 *1 118.4,349.5 NMOS
XM$561 BL5 WL11 \$I1972 VSS NMOS L=1u W=3.4u AS=10.88p AD=6.46p PS=13.2u PD=7.2u
* device instance $562 m0 *1 123.2,349.5 NMOS
XM$562 \$I1972 \$I1973 VSS VSS NMOS L=1u W=3.4u AS=6.46p AD=6.46p PS=7.2u
+ PD=7.2u
* device instance $563 m0 *1 128,349.5 NMOS
XM$563 VSS \$I1972 \$I1973 VSS NMOS L=1u W=3.4u AS=6.46p AD=6.46p PS=7.2u
+ PD=7.2u
* device instance $564 m0 *1 132.8,349.5 NMOS
XM$564 \$I1973 WL11 BLB5 VSS NMOS L=1u W=3.4u AS=6.46p AD=10.88p PS=7.2u
+ PD=13.2u
* device instance $565 m0 *1 123.2,151.5 PMOS
XM$565 \$I1974 \$I1975 VDD VDD PMOS L=1u W=3.4u AS=10.88p AD=6.46p PS=13.2u
+ PD=7.2u
* device instance $566 m0 *1 128,151.5 PMOS
XM$566 VDD \$I1974 \$I1975 VDD PMOS L=1u W=3.4u AS=6.46p AD=10.88p PS=7.2u
+ PD=13.2u
* device instance $567 m0 *1 118.4,171.9 NMOS
XM$567 BL5 WL5 \$I1974 VSS NMOS L=1u W=3.4u AS=10.88p AD=6.46p PS=13.2u PD=7.2u
* device instance $568 m0 *1 123.2,171.9 NMOS
XM$568 \$I1974 \$I1975 VSS VSS NMOS L=1u W=3.4u AS=6.46p AD=6.46p PS=7.2u
+ PD=7.2u
* device instance $569 m0 *1 128,171.9 NMOS
XM$569 VSS \$I1974 \$I1975 VSS NMOS L=1u W=3.4u AS=6.46p AD=6.46p PS=7.2u
+ PD=7.2u
* device instance $570 m0 *1 132.8,171.9 NMOS
XM$570 \$I1975 WL5 BLB5 VSS NMOS L=1u W=3.4u AS=6.46p AD=10.88p PS=7.2u PD=13.2u
* device instance $571 m0 *1 123.2,388.3 PMOS
XM$571 \$I1976 \$I1977 VDD VDD PMOS L=1u W=3.4u AS=10.88p AD=6.46p PS=13.2u
+ PD=7.2u
* device instance $572 m0 *1 128,388.3 PMOS
XM$572 VDD \$I1976 \$I1977 VDD PMOS L=1u W=3.4u AS=6.46p AD=10.88p PS=7.2u
+ PD=13.2u
* device instance $573 m0 *1 118.4,408.7 NMOS
XM$573 BL5 WL13 \$I1976 VSS NMOS L=1u W=3.4u AS=10.88p AD=6.46p PS=13.2u PD=7.2u
* device instance $574 m0 *1 123.2,408.7 NMOS
XM$574 \$I1976 \$I1977 VSS VSS NMOS L=1u W=3.4u AS=6.46p AD=6.46p PS=7.2u
+ PD=7.2u
* device instance $575 m0 *1 128,408.7 NMOS
XM$575 VSS \$I1976 \$I1977 VSS NMOS L=1u W=3.4u AS=6.46p AD=6.46p PS=7.2u
+ PD=7.2u
* device instance $576 m0 *1 132.8,408.7 NMOS
XM$576 \$I1977 WL13 BLB5 VSS NMOS L=1u W=3.4u AS=6.46p AD=10.88p PS=7.2u
+ PD=13.2u
* device instance $577 m0 *1 123.2,92.3 PMOS
XM$577 \$I1978 \$I1979 VDD VDD PMOS L=1u W=3.4u AS=10.88p AD=6.46p PS=13.2u
+ PD=7.2u
* device instance $578 m0 *1 128,92.3 PMOS
XM$578 VDD \$I1978 \$I1979 VDD PMOS L=1u W=3.4u AS=6.46p AD=10.88p PS=7.2u
+ PD=13.2u
* device instance $579 m0 *1 118.4,112.7 NMOS
XM$579 BL5 WL3 \$I1978 VSS NMOS L=1u W=3.4u AS=10.88p AD=6.46p PS=13.2u PD=7.2u
* device instance $580 m0 *1 123.2,112.7 NMOS
XM$580 \$I1978 \$I1979 VSS VSS NMOS L=1u W=3.4u AS=6.46p AD=6.46p PS=7.2u
+ PD=7.2u
* device instance $581 m0 *1 128,112.7 NMOS
XM$581 VSS \$I1978 \$I1979 VSS NMOS L=1u W=3.4u AS=6.46p AD=6.46p PS=7.2u
+ PD=7.2u
* device instance $582 m0 *1 132.8,112.7 NMOS
XM$582 \$I1979 WL3 BLB5 VSS NMOS L=1u W=3.4u AS=6.46p AD=10.88p PS=7.2u PD=13.2u
* device instance $583 m0 *1 123.2,33.1 PMOS
XM$583 \$I1980 \$I1981 VDD VDD PMOS L=1u W=3.4u AS=10.88p AD=6.46p PS=13.2u
+ PD=7.2u
* device instance $584 m0 *1 128,33.1 PMOS
XM$584 VDD \$I1980 \$I1981 VDD PMOS L=1u W=3.4u AS=6.46p AD=10.88p PS=7.2u
+ PD=13.2u
* device instance $585 m0 *1 118.4,53.5 NMOS
XM$585 BL5 WL1 \$I1980 VSS NMOS L=1u W=3.4u AS=10.88p AD=6.46p PS=13.2u PD=7.2u
* device instance $586 m0 *1 123.2,53.5 NMOS
XM$586 \$I1980 \$I1981 VSS VSS NMOS L=1u W=3.4u AS=6.46p AD=6.46p PS=7.2u
+ PD=7.2u
* device instance $587 m0 *1 128,53.5 NMOS
XM$587 VSS \$I1980 \$I1981 VSS NMOS L=1u W=3.4u AS=6.46p AD=6.46p PS=7.2u
+ PD=7.2u
* device instance $588 m0 *1 132.8,53.5 NMOS
XM$588 \$I1981 WL1 BLB5 VSS NMOS L=1u W=3.4u AS=6.46p AD=10.88p PS=7.2u PD=13.2u
* device instance $589 m0 *1 123.2,210.7 PMOS
XM$589 \$I1982 \$I1983 VDD VDD PMOS L=1u W=3.4u AS=10.88p AD=6.46p PS=13.2u
+ PD=7.2u
* device instance $590 m0 *1 128,210.7 PMOS
XM$590 VDD \$I1982 \$I1983 VDD PMOS L=1u W=3.4u AS=6.46p AD=10.88p PS=7.2u
+ PD=13.2u
* device instance $591 m0 *1 118.4,231.1 NMOS
XM$591 BL5 WL7 \$I1982 VSS NMOS L=1u W=3.4u AS=10.88p AD=6.46p PS=13.2u PD=7.2u
* device instance $592 m0 *1 123.2,231.1 NMOS
XM$592 \$I1982 \$I1983 VSS VSS NMOS L=1u W=3.4u AS=6.46p AD=6.46p PS=7.2u
+ PD=7.2u
* device instance $593 m0 *1 128,231.1 NMOS
XM$593 VSS \$I1982 \$I1983 VSS NMOS L=1u W=3.4u AS=6.46p AD=6.46p PS=7.2u
+ PD=7.2u
* device instance $594 m0 *1 132.8,231.1 NMOS
XM$594 \$I1983 WL7 BLB5 VSS NMOS L=1u W=3.4u AS=6.46p AD=10.88p PS=7.2u PD=13.2u
* device instance $595 r0 *1 123.2,322.1 PMOS
XM$595 \$I1984 \$I1985 VDD VDD PMOS L=1u W=3.4u AS=10.88p AD=6.46p PS=13.2u
+ PD=7.2u
* device instance $596 r0 *1 128,322.1 PMOS
XM$596 VDD \$I1984 \$I1985 VDD PMOS L=1u W=3.4u AS=6.46p AD=10.88p PS=7.2u
+ PD=13.2u
* device instance $597 r0 *1 118.4,301.7 NMOS
XM$597 BL5 WL10 \$I1984 VSS NMOS L=1u W=3.4u AS=10.88p AD=6.46p PS=13.2u PD=7.2u
* device instance $598 r0 *1 123.2,301.7 NMOS
XM$598 \$I1984 \$I1985 VSS VSS NMOS L=1u W=3.4u AS=6.46p AD=6.46p PS=7.2u
+ PD=7.2u
* device instance $599 r0 *1 128,301.7 NMOS
XM$599 VSS \$I1984 \$I1985 VSS NMOS L=1u W=3.4u AS=6.46p AD=6.46p PS=7.2u
+ PD=7.2u
* device instance $600 r0 *1 132.8,301.7 NMOS
XM$600 \$I1985 WL10 BLB5 VSS NMOS L=1u W=3.4u AS=6.46p AD=10.88p PS=7.2u
+ PD=13.2u
* device instance $601 r0 *1 123.2,381.3 PMOS
XM$601 \$I1986 \$I1987 VDD VDD PMOS L=1u W=3.4u AS=10.88p AD=6.46p PS=13.2u
+ PD=7.2u
* device instance $602 r0 *1 128,381.3 PMOS
XM$602 VDD \$I1986 \$I1987 VDD PMOS L=1u W=3.4u AS=6.46p AD=10.88p PS=7.2u
+ PD=13.2u
* device instance $603 r0 *1 118.4,360.9 NMOS
XM$603 BL5 WL12 \$I1986 VSS NMOS L=1u W=3.4u AS=10.88p AD=6.46p PS=13.2u PD=7.2u
* device instance $604 r0 *1 123.2,360.9 NMOS
XM$604 \$I1986 \$I1987 VSS VSS NMOS L=1u W=3.4u AS=6.46p AD=6.46p PS=7.2u
+ PD=7.2u
* device instance $605 r0 *1 128,360.9 NMOS
XM$605 VSS \$I1986 \$I1987 VSS NMOS L=1u W=3.4u AS=6.46p AD=6.46p PS=7.2u
+ PD=7.2u
* device instance $606 r0 *1 132.8,360.9 NMOS
XM$606 \$I1987 WL12 BLB5 VSS NMOS L=1u W=3.4u AS=6.46p AD=10.88p PS=7.2u
+ PD=13.2u
* device instance $607 r0 *1 123.2,203.7 PMOS
XM$607 \$I1988 \$I1989 VDD VDD PMOS L=1u W=3.4u AS=10.88p AD=6.46p PS=13.2u
+ PD=7.2u
* device instance $608 r0 *1 128,203.7 PMOS
XM$608 VDD \$I1988 \$I1989 VDD PMOS L=1u W=3.4u AS=6.46p AD=10.88p PS=7.2u
+ PD=13.2u
* device instance $609 r0 *1 118.4,183.3 NMOS
XM$609 BL5 WL6 \$I1988 VSS NMOS L=1u W=3.4u AS=10.88p AD=6.46p PS=13.2u PD=7.2u
* device instance $610 r0 *1 123.2,183.3 NMOS
XM$610 \$I1988 \$I1989 VSS VSS NMOS L=1u W=3.4u AS=6.46p AD=6.46p PS=7.2u
+ PD=7.2u
* device instance $611 r0 *1 128,183.3 NMOS
XM$611 VSS \$I1988 \$I1989 VSS NMOS L=1u W=3.4u AS=6.46p AD=6.46p PS=7.2u
+ PD=7.2u
* device instance $612 r0 *1 132.8,183.3 NMOS
XM$612 \$I1989 WL6 BLB5 VSS NMOS L=1u W=3.4u AS=6.46p AD=10.88p PS=7.2u PD=13.2u
* device instance $613 r0 *1 123.2,144.5 PMOS
XM$613 \$I1990 \$I1991 VDD VDD PMOS L=1u W=3.4u AS=10.88p AD=6.46p PS=13.2u
+ PD=7.2u
* device instance $614 r0 *1 128,144.5 PMOS
XM$614 VDD \$I1990 \$I1991 VDD PMOS L=1u W=3.4u AS=6.46p AD=10.88p PS=7.2u
+ PD=13.2u
* device instance $615 r0 *1 118.4,124.1 NMOS
XM$615 BL5 WL4 \$I1990 VSS NMOS L=1u W=3.4u AS=10.88p AD=6.46p PS=13.2u PD=7.2u
* device instance $616 r0 *1 123.2,124.1 NMOS
XM$616 \$I1990 \$I1991 VSS VSS NMOS L=1u W=3.4u AS=6.46p AD=6.46p PS=7.2u
+ PD=7.2u
* device instance $617 r0 *1 128,124.1 NMOS
XM$617 VSS \$I1990 \$I1991 VSS NMOS L=1u W=3.4u AS=6.46p AD=6.46p PS=7.2u
+ PD=7.2u
* device instance $618 r0 *1 132.8,124.1 NMOS
XM$618 \$I1991 WL4 BLB5 VSS NMOS L=1u W=3.4u AS=6.46p AD=10.88p PS=7.2u PD=13.2u
* device instance $619 r0 *1 123.2,85.3 PMOS
XM$619 \$I1992 \$I1993 VDD VDD PMOS L=1u W=3.4u AS=10.88p AD=6.46p PS=13.2u
+ PD=7.2u
* device instance $620 r0 *1 128,85.3 PMOS
XM$620 VDD \$I1992 \$I1993 VDD PMOS L=1u W=3.4u AS=6.46p AD=10.88p PS=7.2u
+ PD=13.2u
* device instance $621 r0 *1 118.4,64.9 NMOS
XM$621 BL5 WL2 \$I1992 VSS NMOS L=1u W=3.4u AS=10.88p AD=6.46p PS=13.2u PD=7.2u
* device instance $622 r0 *1 123.2,64.9 NMOS
XM$622 \$I1992 \$I1993 VSS VSS NMOS L=1u W=3.4u AS=6.46p AD=6.46p PS=7.2u
+ PD=7.2u
* device instance $623 r0 *1 128,64.9 NMOS
XM$623 VSS \$I1992 \$I1993 VSS NMOS L=1u W=3.4u AS=6.46p AD=6.46p PS=7.2u
+ PD=7.2u
* device instance $624 r0 *1 132.8,64.9 NMOS
XM$624 \$I1993 WL2 BLB5 VSS NMOS L=1u W=3.4u AS=6.46p AD=10.88p PS=7.2u PD=13.2u
* device instance $625 r0 *1 123.2,262.9 PMOS
XM$625 \$I1994 \$I1995 VDD VDD PMOS L=1u W=3.4u AS=10.88p AD=6.46p PS=13.2u
+ PD=7.2u
* device instance $626 r0 *1 128,262.9 PMOS
XM$626 VDD \$I1994 \$I1995 VDD PMOS L=1u W=3.4u AS=6.46p AD=10.88p PS=7.2u
+ PD=13.2u
* device instance $627 r0 *1 118.4,242.5 NMOS
XM$627 BL5 WL8 \$I1994 VSS NMOS L=1u W=3.4u AS=10.88p AD=6.46p PS=13.2u PD=7.2u
* device instance $628 r0 *1 123.2,242.5 NMOS
XM$628 \$I1994 \$I1995 VSS VSS NMOS L=1u W=3.4u AS=6.46p AD=6.46p PS=7.2u
+ PD=7.2u
* device instance $629 r0 *1 128,242.5 NMOS
XM$629 VSS \$I1994 \$I1995 VSS NMOS L=1u W=3.4u AS=6.46p AD=6.46p PS=7.2u
+ PD=7.2u
* device instance $630 r0 *1 132.8,242.5 NMOS
XM$630 \$I1995 WL8 BLB5 VSS NMOS L=1u W=3.4u AS=6.46p AD=10.88p PS=7.2u PD=13.2u
* device instance $631 r0 *1 123.2,440.5 PMOS
XM$631 \$I1996 \$I1997 VDD VDD PMOS L=1u W=3.4u AS=10.88p AD=6.46p PS=13.2u
+ PD=7.2u
* device instance $632 r0 *1 128,440.5 PMOS
XM$632 VDD \$I1996 \$I1997 VDD PMOS L=1u W=3.4u AS=6.46p AD=10.88p PS=7.2u
+ PD=13.2u
* device instance $633 r0 *1 118.4,420.1 NMOS
XM$633 BL5 WL14 \$I1996 VSS NMOS L=1u W=3.4u AS=10.88p AD=6.46p PS=13.2u PD=7.2u
* device instance $634 r0 *1 123.2,420.1 NMOS
XM$634 \$I1996 \$I1997 VSS VSS NMOS L=1u W=3.4u AS=6.46p AD=6.46p PS=7.2u
+ PD=7.2u
* device instance $635 r0 *1 128,420.1 NMOS
XM$635 VSS \$I1996 \$I1997 VSS NMOS L=1u W=3.4u AS=6.46p AD=6.46p PS=7.2u
+ PD=7.2u
* device instance $636 r0 *1 132.8,420.1 NMOS
XM$636 \$I1997 WL14 BLB5 VSS NMOS L=1u W=3.4u AS=6.46p AD=10.88p PS=7.2u
+ PD=13.2u
* device instance $637 m0 *1 100,269.9 PMOS
XM$637 \$I1998 \$I1999 VDD VDD PMOS L=1u W=3.4u AS=10.88p AD=6.46p PS=13.2u
+ PD=7.2u
* device instance $638 m0 *1 104.8,269.9 PMOS
XM$638 VDD \$I1998 \$I1999 VDD PMOS L=1u W=3.4u AS=6.46p AD=10.88p PS=7.2u
+ PD=13.2u
* device instance $639 m0 *1 95.2,290.3 NMOS
XM$639 BL4 WL9 \$I1998 VSS NMOS L=1u W=3.4u AS=10.88p AD=6.46p PS=13.2u PD=7.2u
* device instance $640 m0 *1 100,290.3 NMOS
XM$640 \$I1998 \$I1999 VSS VSS NMOS L=1u W=3.4u AS=6.46p AD=6.46p PS=7.2u
+ PD=7.2u
* device instance $641 m0 *1 104.8,290.3 NMOS
XM$641 VSS \$I1998 \$I1999 VSS NMOS L=1u W=3.4u AS=6.46p AD=6.46p PS=7.2u
+ PD=7.2u
* device instance $642 m0 *1 109.6,290.3 NMOS
XM$642 \$I1999 WL9 BLB4 VSS NMOS L=1u W=3.4u AS=6.46p AD=10.88p PS=7.2u PD=13.2u
* device instance $643 m0 *1 100,447.5 PMOS
XM$643 \$I2000 \$I2001 VDD VDD PMOS L=1u W=3.4u AS=10.88p AD=6.46p PS=13.2u
+ PD=7.2u
* device instance $644 m0 *1 104.8,447.5 PMOS
XM$644 VDD \$I2000 \$I2001 VDD PMOS L=1u W=3.4u AS=6.46p AD=10.88p PS=7.2u
+ PD=13.2u
* device instance $645 m0 *1 95.2,467.9 NMOS
XM$645 BL4 WL15 \$I2000 VSS NMOS L=1u W=3.4u AS=10.88p AD=6.46p PS=13.2u PD=7.2u
* device instance $646 m0 *1 100,467.9 NMOS
XM$646 \$I2000 \$I2001 VSS VSS NMOS L=1u W=3.4u AS=6.46p AD=6.46p PS=7.2u
+ PD=7.2u
* device instance $647 m0 *1 104.8,467.9 NMOS
XM$647 VSS \$I2000 \$I2001 VSS NMOS L=1u W=3.4u AS=6.46p AD=6.46p PS=7.2u
+ PD=7.2u
* device instance $648 m0 *1 109.6,467.9 NMOS
XM$648 \$I2001 WL15 BLB4 VSS NMOS L=1u W=3.4u AS=6.46p AD=10.88p PS=7.2u
+ PD=13.2u
* device instance $649 m0 *1 100,329.1 PMOS
XM$649 \$I2002 \$I2003 VDD VDD PMOS L=1u W=3.4u AS=10.88p AD=6.46p PS=13.2u
+ PD=7.2u
* device instance $650 m0 *1 104.8,329.1 PMOS
XM$650 VDD \$I2002 \$I2003 VDD PMOS L=1u W=3.4u AS=6.46p AD=10.88p PS=7.2u
+ PD=13.2u
* device instance $651 m0 *1 95.2,349.5 NMOS
XM$651 BL4 WL11 \$I2002 VSS NMOS L=1u W=3.4u AS=10.88p AD=6.46p PS=13.2u PD=7.2u
* device instance $652 m0 *1 100,349.5 NMOS
XM$652 \$I2002 \$I2003 VSS VSS NMOS L=1u W=3.4u AS=6.46p AD=6.46p PS=7.2u
+ PD=7.2u
* device instance $653 m0 *1 104.8,349.5 NMOS
XM$653 VSS \$I2002 \$I2003 VSS NMOS L=1u W=3.4u AS=6.46p AD=6.46p PS=7.2u
+ PD=7.2u
* device instance $654 m0 *1 109.6,349.5 NMOS
XM$654 \$I2003 WL11 BLB4 VSS NMOS L=1u W=3.4u AS=6.46p AD=10.88p PS=7.2u
+ PD=13.2u
* device instance $655 m0 *1 100,33.1 PMOS
XM$655 \$I2004 \$I2005 VDD VDD PMOS L=1u W=3.4u AS=10.88p AD=6.46p PS=13.2u
+ PD=7.2u
* device instance $656 m0 *1 104.8,33.1 PMOS
XM$656 VDD \$I2004 \$I2005 VDD PMOS L=1u W=3.4u AS=6.46p AD=10.88p PS=7.2u
+ PD=13.2u
* device instance $657 m0 *1 95.2,53.5 NMOS
XM$657 BL4 WL1 \$I2004 VSS NMOS L=1u W=3.4u AS=10.88p AD=6.46p PS=13.2u PD=7.2u
* device instance $658 m0 *1 100,53.5 NMOS
XM$658 \$I2004 \$I2005 VSS VSS NMOS L=1u W=3.4u AS=6.46p AD=6.46p PS=7.2u
+ PD=7.2u
* device instance $659 m0 *1 104.8,53.5 NMOS
XM$659 VSS \$I2004 \$I2005 VSS NMOS L=1u W=3.4u AS=6.46p AD=6.46p PS=7.2u
+ PD=7.2u
* device instance $660 m0 *1 109.6,53.5 NMOS
XM$660 \$I2005 WL1 BLB4 VSS NMOS L=1u W=3.4u AS=6.46p AD=10.88p PS=7.2u PD=13.2u
* device instance $661 m0 *1 100,151.5 PMOS
XM$661 \$I2006 \$I2007 VDD VDD PMOS L=1u W=3.4u AS=10.88p AD=6.46p PS=13.2u
+ PD=7.2u
* device instance $662 m0 *1 104.8,151.5 PMOS
XM$662 VDD \$I2006 \$I2007 VDD PMOS L=1u W=3.4u AS=6.46p AD=10.88p PS=7.2u
+ PD=13.2u
* device instance $663 m0 *1 95.2,171.9 NMOS
XM$663 BL4 WL5 \$I2006 VSS NMOS L=1u W=3.4u AS=10.88p AD=6.46p PS=13.2u PD=7.2u
* device instance $664 m0 *1 100,171.9 NMOS
XM$664 \$I2006 \$I2007 VSS VSS NMOS L=1u W=3.4u AS=6.46p AD=6.46p PS=7.2u
+ PD=7.2u
* device instance $665 m0 *1 104.8,171.9 NMOS
XM$665 VSS \$I2006 \$I2007 VSS NMOS L=1u W=3.4u AS=6.46p AD=6.46p PS=7.2u
+ PD=7.2u
* device instance $666 m0 *1 109.6,171.9 NMOS
XM$666 \$I2007 WL5 BLB4 VSS NMOS L=1u W=3.4u AS=6.46p AD=10.88p PS=7.2u PD=13.2u
* device instance $667 m0 *1 100,388.3 PMOS
XM$667 \$I2008 \$I2009 VDD VDD PMOS L=1u W=3.4u AS=10.88p AD=6.46p PS=13.2u
+ PD=7.2u
* device instance $668 m0 *1 104.8,388.3 PMOS
XM$668 VDD \$I2008 \$I2009 VDD PMOS L=1u W=3.4u AS=6.46p AD=10.88p PS=7.2u
+ PD=13.2u
* device instance $669 m0 *1 95.2,408.7 NMOS
XM$669 BL4 WL13 \$I2008 VSS NMOS L=1u W=3.4u AS=10.88p AD=6.46p PS=13.2u PD=7.2u
* device instance $670 m0 *1 100,408.7 NMOS
XM$670 \$I2008 \$I2009 VSS VSS NMOS L=1u W=3.4u AS=6.46p AD=6.46p PS=7.2u
+ PD=7.2u
* device instance $671 m0 *1 104.8,408.7 NMOS
XM$671 VSS \$I2008 \$I2009 VSS NMOS L=1u W=3.4u AS=6.46p AD=6.46p PS=7.2u
+ PD=7.2u
* device instance $672 m0 *1 109.6,408.7 NMOS
XM$672 \$I2009 WL13 BLB4 VSS NMOS L=1u W=3.4u AS=6.46p AD=10.88p PS=7.2u
+ PD=13.2u
* device instance $673 m0 *1 100,92.3 PMOS
XM$673 \$I2010 \$I2011 VDD VDD PMOS L=1u W=3.4u AS=10.88p AD=6.46p PS=13.2u
+ PD=7.2u
* device instance $674 m0 *1 104.8,92.3 PMOS
XM$674 VDD \$I2010 \$I2011 VDD PMOS L=1u W=3.4u AS=6.46p AD=10.88p PS=7.2u
+ PD=13.2u
* device instance $675 m0 *1 95.2,112.7 NMOS
XM$675 BL4 WL3 \$I2010 VSS NMOS L=1u W=3.4u AS=10.88p AD=6.46p PS=13.2u PD=7.2u
* device instance $676 m0 *1 100,112.7 NMOS
XM$676 \$I2010 \$I2011 VSS VSS NMOS L=1u W=3.4u AS=6.46p AD=6.46p PS=7.2u
+ PD=7.2u
* device instance $677 m0 *1 104.8,112.7 NMOS
XM$677 VSS \$I2010 \$I2011 VSS NMOS L=1u W=3.4u AS=6.46p AD=6.46p PS=7.2u
+ PD=7.2u
* device instance $678 m0 *1 109.6,112.7 NMOS
XM$678 \$I2011 WL3 BLB4 VSS NMOS L=1u W=3.4u AS=6.46p AD=10.88p PS=7.2u PD=13.2u
* device instance $679 m0 *1 100,210.7 PMOS
XM$679 \$I2012 \$I2013 VDD VDD PMOS L=1u W=3.4u AS=10.88p AD=6.46p PS=13.2u
+ PD=7.2u
* device instance $680 m0 *1 104.8,210.7 PMOS
XM$680 VDD \$I2012 \$I2013 VDD PMOS L=1u W=3.4u AS=6.46p AD=10.88p PS=7.2u
+ PD=13.2u
* device instance $681 m0 *1 95.2,231.1 NMOS
XM$681 BL4 WL7 \$I2012 VSS NMOS L=1u W=3.4u AS=10.88p AD=6.46p PS=13.2u PD=7.2u
* device instance $682 m0 *1 100,231.1 NMOS
XM$682 \$I2012 \$I2013 VSS VSS NMOS L=1u W=3.4u AS=6.46p AD=6.46p PS=7.2u
+ PD=7.2u
* device instance $683 m0 *1 104.8,231.1 NMOS
XM$683 VSS \$I2012 \$I2013 VSS NMOS L=1u W=3.4u AS=6.46p AD=6.46p PS=7.2u
+ PD=7.2u
* device instance $684 m0 *1 109.6,231.1 NMOS
XM$684 \$I2013 WL7 BLB4 VSS NMOS L=1u W=3.4u AS=6.46p AD=10.88p PS=7.2u PD=13.2u
* device instance $685 r0 *1 100,144.5 PMOS
XM$685 \$I2014 \$I2015 VDD VDD PMOS L=1u W=3.4u AS=10.88p AD=6.46p PS=13.2u
+ PD=7.2u
* device instance $686 r0 *1 104.8,144.5 PMOS
XM$686 VDD \$I2014 \$I2015 VDD PMOS L=1u W=3.4u AS=6.46p AD=10.88p PS=7.2u
+ PD=13.2u
* device instance $687 r0 *1 95.2,124.1 NMOS
XM$687 BL4 WL4 \$I2014 VSS NMOS L=1u W=3.4u AS=10.88p AD=6.46p PS=13.2u PD=7.2u
* device instance $688 r0 *1 100,124.1 NMOS
XM$688 \$I2014 \$I2015 VSS VSS NMOS L=1u W=3.4u AS=6.46p AD=6.46p PS=7.2u
+ PD=7.2u
* device instance $689 r0 *1 104.8,124.1 NMOS
XM$689 VSS \$I2014 \$I2015 VSS NMOS L=1u W=3.4u AS=6.46p AD=6.46p PS=7.2u
+ PD=7.2u
* device instance $690 r0 *1 109.6,124.1 NMOS
XM$690 \$I2015 WL4 BLB4 VSS NMOS L=1u W=3.4u AS=6.46p AD=10.88p PS=7.2u PD=13.2u
* device instance $691 r0 *1 100,322.1 PMOS
XM$691 \$I2016 \$I2017 VDD VDD PMOS L=1u W=3.4u AS=10.88p AD=6.46p PS=13.2u
+ PD=7.2u
* device instance $692 r0 *1 104.8,322.1 PMOS
XM$692 VDD \$I2016 \$I2017 VDD PMOS L=1u W=3.4u AS=6.46p AD=10.88p PS=7.2u
+ PD=13.2u
* device instance $693 r0 *1 95.2,301.7 NMOS
XM$693 BL4 WL10 \$I2016 VSS NMOS L=1u W=3.4u AS=10.88p AD=6.46p PS=13.2u PD=7.2u
* device instance $694 r0 *1 100,301.7 NMOS
XM$694 \$I2016 \$I2017 VSS VSS NMOS L=1u W=3.4u AS=6.46p AD=6.46p PS=7.2u
+ PD=7.2u
* device instance $695 r0 *1 104.8,301.7 NMOS
XM$695 VSS \$I2016 \$I2017 VSS NMOS L=1u W=3.4u AS=6.46p AD=6.46p PS=7.2u
+ PD=7.2u
* device instance $696 r0 *1 109.6,301.7 NMOS
XM$696 \$I2017 WL10 BLB4 VSS NMOS L=1u W=3.4u AS=6.46p AD=10.88p PS=7.2u
+ PD=13.2u
* device instance $697 r0 *1 100,381.3 PMOS
XM$697 \$I2018 \$I2019 VDD VDD PMOS L=1u W=3.4u AS=10.88p AD=6.46p PS=13.2u
+ PD=7.2u
* device instance $698 r0 *1 104.8,381.3 PMOS
XM$698 VDD \$I2018 \$I2019 VDD PMOS L=1u W=3.4u AS=6.46p AD=10.88p PS=7.2u
+ PD=13.2u
* device instance $699 r0 *1 95.2,360.9 NMOS
XM$699 BL4 WL12 \$I2018 VSS NMOS L=1u W=3.4u AS=10.88p AD=6.46p PS=13.2u PD=7.2u
* device instance $700 r0 *1 100,360.9 NMOS
XM$700 \$I2018 \$I2019 VSS VSS NMOS L=1u W=3.4u AS=6.46p AD=6.46p PS=7.2u
+ PD=7.2u
* device instance $701 r0 *1 104.8,360.9 NMOS
XM$701 VSS \$I2018 \$I2019 VSS NMOS L=1u W=3.4u AS=6.46p AD=6.46p PS=7.2u
+ PD=7.2u
* device instance $702 r0 *1 109.6,360.9 NMOS
XM$702 \$I2019 WL12 BLB4 VSS NMOS L=1u W=3.4u AS=6.46p AD=10.88p PS=7.2u
+ PD=13.2u
* device instance $703 r0 *1 100,203.7 PMOS
XM$703 \$I2020 \$I2021 VDD VDD PMOS L=1u W=3.4u AS=10.88p AD=6.46p PS=13.2u
+ PD=7.2u
* device instance $704 r0 *1 104.8,203.7 PMOS
XM$704 VDD \$I2020 \$I2021 VDD PMOS L=1u W=3.4u AS=6.46p AD=10.88p PS=7.2u
+ PD=13.2u
* device instance $705 r0 *1 95.2,183.3 NMOS
XM$705 BL4 WL6 \$I2020 VSS NMOS L=1u W=3.4u AS=10.88p AD=6.46p PS=13.2u PD=7.2u
* device instance $706 r0 *1 100,183.3 NMOS
XM$706 \$I2020 \$I2021 VSS VSS NMOS L=1u W=3.4u AS=6.46p AD=6.46p PS=7.2u
+ PD=7.2u
* device instance $707 r0 *1 104.8,183.3 NMOS
XM$707 VSS \$I2020 \$I2021 VSS NMOS L=1u W=3.4u AS=6.46p AD=6.46p PS=7.2u
+ PD=7.2u
* device instance $708 r0 *1 109.6,183.3 NMOS
XM$708 \$I2021 WL6 BLB4 VSS NMOS L=1u W=3.4u AS=6.46p AD=10.88p PS=7.2u PD=13.2u
* device instance $709 r0 *1 100,85.3 PMOS
XM$709 \$I2022 \$I2023 VDD VDD PMOS L=1u W=3.4u AS=10.88p AD=6.46p PS=13.2u
+ PD=7.2u
* device instance $710 r0 *1 104.8,85.3 PMOS
XM$710 VDD \$I2022 \$I2023 VDD PMOS L=1u W=3.4u AS=6.46p AD=10.88p PS=7.2u
+ PD=13.2u
* device instance $711 r0 *1 95.2,64.9 NMOS
XM$711 BL4 WL2 \$I2022 VSS NMOS L=1u W=3.4u AS=10.88p AD=6.46p PS=13.2u PD=7.2u
* device instance $712 r0 *1 100,64.9 NMOS
XM$712 \$I2022 \$I2023 VSS VSS NMOS L=1u W=3.4u AS=6.46p AD=6.46p PS=7.2u
+ PD=7.2u
* device instance $713 r0 *1 104.8,64.9 NMOS
XM$713 VSS \$I2022 \$I2023 VSS NMOS L=1u W=3.4u AS=6.46p AD=6.46p PS=7.2u
+ PD=7.2u
* device instance $714 r0 *1 109.6,64.9 NMOS
XM$714 \$I2023 WL2 BLB4 VSS NMOS L=1u W=3.4u AS=6.46p AD=10.88p PS=7.2u PD=13.2u
* device instance $715 r0 *1 100,262.9 PMOS
XM$715 \$I2024 \$I2025 VDD VDD PMOS L=1u W=3.4u AS=10.88p AD=6.46p PS=13.2u
+ PD=7.2u
* device instance $716 r0 *1 104.8,262.9 PMOS
XM$716 VDD \$I2024 \$I2025 VDD PMOS L=1u W=3.4u AS=6.46p AD=10.88p PS=7.2u
+ PD=13.2u
* device instance $717 r0 *1 95.2,242.5 NMOS
XM$717 BL4 WL8 \$I2024 VSS NMOS L=1u W=3.4u AS=10.88p AD=6.46p PS=13.2u PD=7.2u
* device instance $718 r0 *1 100,242.5 NMOS
XM$718 \$I2024 \$I2025 VSS VSS NMOS L=1u W=3.4u AS=6.46p AD=6.46p PS=7.2u
+ PD=7.2u
* device instance $719 r0 *1 104.8,242.5 NMOS
XM$719 VSS \$I2024 \$I2025 VSS NMOS L=1u W=3.4u AS=6.46p AD=6.46p PS=7.2u
+ PD=7.2u
* device instance $720 r0 *1 109.6,242.5 NMOS
XM$720 \$I2025 WL8 BLB4 VSS NMOS L=1u W=3.4u AS=6.46p AD=10.88p PS=7.2u PD=13.2u
* device instance $721 r0 *1 100,440.5 PMOS
XM$721 \$I2026 \$I2027 VDD VDD PMOS L=1u W=3.4u AS=10.88p AD=6.46p PS=13.2u
+ PD=7.2u
* device instance $722 r0 *1 104.8,440.5 PMOS
XM$722 VDD \$I2026 \$I2027 VDD PMOS L=1u W=3.4u AS=6.46p AD=10.88p PS=7.2u
+ PD=13.2u
* device instance $723 r0 *1 95.2,420.1 NMOS
XM$723 BL4 WL14 \$I2026 VSS NMOS L=1u W=3.4u AS=10.88p AD=6.46p PS=13.2u PD=7.2u
* device instance $724 r0 *1 100,420.1 NMOS
XM$724 \$I2026 \$I2027 VSS VSS NMOS L=1u W=3.4u AS=6.46p AD=6.46p PS=7.2u
+ PD=7.2u
* device instance $725 r0 *1 104.8,420.1 NMOS
XM$725 VSS \$I2026 \$I2027 VSS NMOS L=1u W=3.4u AS=6.46p AD=6.46p PS=7.2u
+ PD=7.2u
* device instance $726 r0 *1 109.6,420.1 NMOS
XM$726 \$I2027 WL14 BLB4 VSS NMOS L=1u W=3.4u AS=6.46p AD=10.88p PS=7.2u
+ PD=13.2u
* device instance $727 m0 *1 216,388.3 PMOS
XM$727 \$I2028 \$I2029 VDD VDD PMOS L=1u W=3.4u AS=10.88p AD=6.46p PS=13.2u
+ PD=7.2u
* device instance $728 m0 *1 220.8,388.3 PMOS
XM$728 VDD \$I2028 \$I2029 VDD PMOS L=1u W=3.4u AS=6.46p AD=10.88p PS=7.2u
+ PD=13.2u
* device instance $729 m0 *1 211.2,408.7 NMOS
XM$729 BL9 WL13 \$I2028 VSS NMOS L=1u W=3.4u AS=10.88p AD=6.46p PS=13.2u PD=7.2u
* device instance $730 m0 *1 216,408.7 NMOS
XM$730 \$I2028 \$I2029 VSS VSS NMOS L=1u W=3.4u AS=6.46p AD=6.46p PS=7.2u
+ PD=7.2u
* device instance $731 m0 *1 220.8,408.7 NMOS
XM$731 VSS \$I2028 \$I2029 VSS NMOS L=1u W=3.4u AS=6.46p AD=6.46p PS=7.2u
+ PD=7.2u
* device instance $732 m0 *1 225.6,408.7 NMOS
XM$732 \$I2029 WL13 BLB9 VSS NMOS L=1u W=3.4u AS=6.46p AD=10.88p PS=7.2u
+ PD=13.2u
* device instance $733 m0 *1 216,269.9 PMOS
XM$733 \$I2030 \$I2031 VDD VDD PMOS L=1u W=3.4u AS=10.88p AD=6.46p PS=13.2u
+ PD=7.2u
* device instance $734 m0 *1 220.8,269.9 PMOS
XM$734 VDD \$I2030 \$I2031 VDD PMOS L=1u W=3.4u AS=6.46p AD=10.88p PS=7.2u
+ PD=13.2u
* device instance $735 m0 *1 211.2,290.3 NMOS
XM$735 BL9 WL9 \$I2030 VSS NMOS L=1u W=3.4u AS=10.88p AD=6.46p PS=13.2u PD=7.2u
* device instance $736 m0 *1 216,290.3 NMOS
XM$736 \$I2030 \$I2031 VSS VSS NMOS L=1u W=3.4u AS=6.46p AD=6.46p PS=7.2u
+ PD=7.2u
* device instance $737 m0 *1 220.8,290.3 NMOS
XM$737 VSS \$I2030 \$I2031 VSS NMOS L=1u W=3.4u AS=6.46p AD=6.46p PS=7.2u
+ PD=7.2u
* device instance $738 m0 *1 225.6,290.3 NMOS
XM$738 \$I2031 WL9 BLB9 VSS NMOS L=1u W=3.4u AS=6.46p AD=10.88p PS=7.2u PD=13.2u
* device instance $739 m0 *1 216,329.1 PMOS
XM$739 \$I2032 \$I2033 VDD VDD PMOS L=1u W=3.4u AS=10.88p AD=6.46p PS=13.2u
+ PD=7.2u
* device instance $740 m0 *1 220.8,329.1 PMOS
XM$740 VDD \$I2032 \$I2033 VDD PMOS L=1u W=3.4u AS=6.46p AD=10.88p PS=7.2u
+ PD=13.2u
* device instance $741 m0 *1 211.2,349.5 NMOS
XM$741 BL9 WL11 \$I2032 VSS NMOS L=1u W=3.4u AS=10.88p AD=6.46p PS=13.2u PD=7.2u
* device instance $742 m0 *1 216,349.5 NMOS
XM$742 \$I2032 \$I2033 VSS VSS NMOS L=1u W=3.4u AS=6.46p AD=6.46p PS=7.2u
+ PD=7.2u
* device instance $743 m0 *1 220.8,349.5 NMOS
XM$743 VSS \$I2032 \$I2033 VSS NMOS L=1u W=3.4u AS=6.46p AD=6.46p PS=7.2u
+ PD=7.2u
* device instance $744 m0 *1 225.6,349.5 NMOS
XM$744 \$I2033 WL11 BLB9 VSS NMOS L=1u W=3.4u AS=6.46p AD=10.88p PS=7.2u
+ PD=13.2u
* device instance $745 m0 *1 216,447.5 PMOS
XM$745 \$I2034 \$I2035 VDD VDD PMOS L=1u W=3.4u AS=10.88p AD=6.46p PS=13.2u
+ PD=7.2u
* device instance $746 m0 *1 220.8,447.5 PMOS
XM$746 VDD \$I2034 \$I2035 VDD PMOS L=1u W=3.4u AS=6.46p AD=10.88p PS=7.2u
+ PD=13.2u
* device instance $747 m0 *1 211.2,467.9 NMOS
XM$747 BL9 WL15 \$I2034 VSS NMOS L=1u W=3.4u AS=10.88p AD=6.46p PS=13.2u PD=7.2u
* device instance $748 m0 *1 216,467.9 NMOS
XM$748 \$I2034 \$I2035 VSS VSS NMOS L=1u W=3.4u AS=6.46p AD=6.46p PS=7.2u
+ PD=7.2u
* device instance $749 m0 *1 220.8,467.9 NMOS
XM$749 VSS \$I2034 \$I2035 VSS NMOS L=1u W=3.4u AS=6.46p AD=6.46p PS=7.2u
+ PD=7.2u
* device instance $750 m0 *1 225.6,467.9 NMOS
XM$750 \$I2035 WL15 BLB9 VSS NMOS L=1u W=3.4u AS=6.46p AD=10.88p PS=7.2u
+ PD=13.2u
* device instance $751 m0 *1 216,92.3 PMOS
XM$751 \$I2036 \$I2037 VDD VDD PMOS L=1u W=3.4u AS=10.88p AD=6.46p PS=13.2u
+ PD=7.2u
* device instance $752 m0 *1 220.8,92.3 PMOS
XM$752 VDD \$I2036 \$I2037 VDD PMOS L=1u W=3.4u AS=6.46p AD=10.88p PS=7.2u
+ PD=13.2u
* device instance $753 m0 *1 211.2,112.7 NMOS
XM$753 BL9 WL3 \$I2036 VSS NMOS L=1u W=3.4u AS=10.88p AD=6.46p PS=13.2u PD=7.2u
* device instance $754 m0 *1 216,112.7 NMOS
XM$754 \$I2036 \$I2037 VSS VSS NMOS L=1u W=3.4u AS=6.46p AD=6.46p PS=7.2u
+ PD=7.2u
* device instance $755 m0 *1 220.8,112.7 NMOS
XM$755 VSS \$I2036 \$I2037 VSS NMOS L=1u W=3.4u AS=6.46p AD=6.46p PS=7.2u
+ PD=7.2u
* device instance $756 m0 *1 225.6,112.7 NMOS
XM$756 \$I2037 WL3 BLB9 VSS NMOS L=1u W=3.4u AS=6.46p AD=10.88p PS=7.2u PD=13.2u
* device instance $757 m0 *1 216,33.1 PMOS
XM$757 \$I2038 \$I2039 VDD VDD PMOS L=1u W=3.4u AS=10.88p AD=6.46p PS=13.2u
+ PD=7.2u
* device instance $758 m0 *1 220.8,33.1 PMOS
XM$758 VDD \$I2038 \$I2039 VDD PMOS L=1u W=3.4u AS=6.46p AD=10.88p PS=7.2u
+ PD=13.2u
* device instance $759 m0 *1 211.2,53.5 NMOS
XM$759 BL9 WL1 \$I2038 VSS NMOS L=1u W=3.4u AS=10.88p AD=6.46p PS=13.2u PD=7.2u
* device instance $760 m0 *1 216,53.5 NMOS
XM$760 \$I2038 \$I2039 VSS VSS NMOS L=1u W=3.4u AS=6.46p AD=6.46p PS=7.2u
+ PD=7.2u
* device instance $761 m0 *1 220.8,53.5 NMOS
XM$761 VSS \$I2038 \$I2039 VSS NMOS L=1u W=3.4u AS=6.46p AD=6.46p PS=7.2u
+ PD=7.2u
* device instance $762 m0 *1 225.6,53.5 NMOS
XM$762 \$I2039 WL1 BLB9 VSS NMOS L=1u W=3.4u AS=6.46p AD=10.88p PS=7.2u PD=13.2u
* device instance $763 m0 *1 216,151.5 PMOS
XM$763 \$I2040 \$I2041 VDD VDD PMOS L=1u W=3.4u AS=10.88p AD=6.46p PS=13.2u
+ PD=7.2u
* device instance $764 m0 *1 220.8,151.5 PMOS
XM$764 VDD \$I2040 \$I2041 VDD PMOS L=1u W=3.4u AS=6.46p AD=10.88p PS=7.2u
+ PD=13.2u
* device instance $765 m0 *1 211.2,171.9 NMOS
XM$765 BL9 WL5 \$I2040 VSS NMOS L=1u W=3.4u AS=10.88p AD=6.46p PS=13.2u PD=7.2u
* device instance $766 m0 *1 216,171.9 NMOS
XM$766 \$I2040 \$I2041 VSS VSS NMOS L=1u W=3.4u AS=6.46p AD=6.46p PS=7.2u
+ PD=7.2u
* device instance $767 m0 *1 220.8,171.9 NMOS
XM$767 VSS \$I2040 \$I2041 VSS NMOS L=1u W=3.4u AS=6.46p AD=6.46p PS=7.2u
+ PD=7.2u
* device instance $768 m0 *1 225.6,171.9 NMOS
XM$768 \$I2041 WL5 BLB9 VSS NMOS L=1u W=3.4u AS=6.46p AD=10.88p PS=7.2u PD=13.2u
* device instance $769 m0 *1 216,210.7 PMOS
XM$769 \$I2042 \$I2043 VDD VDD PMOS L=1u W=3.4u AS=10.88p AD=6.46p PS=13.2u
+ PD=7.2u
* device instance $770 m0 *1 220.8,210.7 PMOS
XM$770 VDD \$I2042 \$I2043 VDD PMOS L=1u W=3.4u AS=6.46p AD=10.88p PS=7.2u
+ PD=13.2u
* device instance $771 m0 *1 211.2,231.1 NMOS
XM$771 BL9 WL7 \$I2042 VSS NMOS L=1u W=3.4u AS=10.88p AD=6.46p PS=13.2u PD=7.2u
* device instance $772 m0 *1 216,231.1 NMOS
XM$772 \$I2042 \$I2043 VSS VSS NMOS L=1u W=3.4u AS=6.46p AD=6.46p PS=7.2u
+ PD=7.2u
* device instance $773 m0 *1 220.8,231.1 NMOS
XM$773 VSS \$I2042 \$I2043 VSS NMOS L=1u W=3.4u AS=6.46p AD=6.46p PS=7.2u
+ PD=7.2u
* device instance $774 m0 *1 225.6,231.1 NMOS
XM$774 \$I2043 WL7 BLB9 VSS NMOS L=1u W=3.4u AS=6.46p AD=10.88p PS=7.2u PD=13.2u
* device instance $775 r0 *1 216,322.1 PMOS
XM$775 \$I2044 \$I2045 VDD VDD PMOS L=1u W=3.4u AS=10.88p AD=6.46p PS=13.2u
+ PD=7.2u
* device instance $776 r0 *1 220.8,322.1 PMOS
XM$776 VDD \$I2044 \$I2045 VDD PMOS L=1u W=3.4u AS=6.46p AD=10.88p PS=7.2u
+ PD=13.2u
* device instance $777 r0 *1 211.2,301.7 NMOS
XM$777 BL9 WL10 \$I2044 VSS NMOS L=1u W=3.4u AS=10.88p AD=6.46p PS=13.2u PD=7.2u
* device instance $778 r0 *1 216,301.7 NMOS
XM$778 \$I2044 \$I2045 VSS VSS NMOS L=1u W=3.4u AS=6.46p AD=6.46p PS=7.2u
+ PD=7.2u
* device instance $779 r0 *1 220.8,301.7 NMOS
XM$779 VSS \$I2044 \$I2045 VSS NMOS L=1u W=3.4u AS=6.46p AD=6.46p PS=7.2u
+ PD=7.2u
* device instance $780 r0 *1 225.6,301.7 NMOS
XM$780 \$I2045 WL10 BLB9 VSS NMOS L=1u W=3.4u AS=6.46p AD=10.88p PS=7.2u
+ PD=13.2u
* device instance $781 r0 *1 216,85.3 PMOS
XM$781 \$I2046 \$I2047 VDD VDD PMOS L=1u W=3.4u AS=10.88p AD=6.46p PS=13.2u
+ PD=7.2u
* device instance $782 r0 *1 220.8,85.3 PMOS
XM$782 VDD \$I2046 \$I2047 VDD PMOS L=1u W=3.4u AS=6.46p AD=10.88p PS=7.2u
+ PD=13.2u
* device instance $783 r0 *1 211.2,64.9 NMOS
XM$783 BL9 WL2 \$I2046 VSS NMOS L=1u W=3.4u AS=10.88p AD=6.46p PS=13.2u PD=7.2u
* device instance $784 r0 *1 216,64.9 NMOS
XM$784 \$I2046 \$I2047 VSS VSS NMOS L=1u W=3.4u AS=6.46p AD=6.46p PS=7.2u
+ PD=7.2u
* device instance $785 r0 *1 220.8,64.9 NMOS
XM$785 VSS \$I2046 \$I2047 VSS NMOS L=1u W=3.4u AS=6.46p AD=6.46p PS=7.2u
+ PD=7.2u
* device instance $786 r0 *1 225.6,64.9 NMOS
XM$786 \$I2047 WL2 BLB9 VSS NMOS L=1u W=3.4u AS=6.46p AD=10.88p PS=7.2u PD=13.2u
* device instance $787 r0 *1 216,440.5 PMOS
XM$787 \$I2048 \$I2049 VDD VDD PMOS L=1u W=3.4u AS=10.88p AD=6.46p PS=13.2u
+ PD=7.2u
* device instance $788 r0 *1 220.8,440.5 PMOS
XM$788 VDD \$I2048 \$I2049 VDD PMOS L=1u W=3.4u AS=6.46p AD=10.88p PS=7.2u
+ PD=13.2u
* device instance $789 r0 *1 211.2,420.1 NMOS
XM$789 BL9 WL14 \$I2048 VSS NMOS L=1u W=3.4u AS=10.88p AD=6.46p PS=13.2u PD=7.2u
* device instance $790 r0 *1 216,420.1 NMOS
XM$790 \$I2048 \$I2049 VSS VSS NMOS L=1u W=3.4u AS=6.46p AD=6.46p PS=7.2u
+ PD=7.2u
* device instance $791 r0 *1 220.8,420.1 NMOS
XM$791 VSS \$I2048 \$I2049 VSS NMOS L=1u W=3.4u AS=6.46p AD=6.46p PS=7.2u
+ PD=7.2u
* device instance $792 r0 *1 225.6,420.1 NMOS
XM$792 \$I2049 WL14 BLB9 VSS NMOS L=1u W=3.4u AS=6.46p AD=10.88p PS=7.2u
+ PD=13.2u
* device instance $793 r0 *1 216,144.5 PMOS
XM$793 \$I2050 \$I2051 VDD VDD PMOS L=1u W=3.4u AS=10.88p AD=6.46p PS=13.2u
+ PD=7.2u
* device instance $794 r0 *1 220.8,144.5 PMOS
XM$794 VDD \$I2050 \$I2051 VDD PMOS L=1u W=3.4u AS=6.46p AD=10.88p PS=7.2u
+ PD=13.2u
* device instance $795 r0 *1 211.2,124.1 NMOS
XM$795 BL9 WL4 \$I2050 VSS NMOS L=1u W=3.4u AS=10.88p AD=6.46p PS=13.2u PD=7.2u
* device instance $796 r0 *1 216,124.1 NMOS
XM$796 \$I2050 \$I2051 VSS VSS NMOS L=1u W=3.4u AS=6.46p AD=6.46p PS=7.2u
+ PD=7.2u
* device instance $797 r0 *1 220.8,124.1 NMOS
XM$797 VSS \$I2050 \$I2051 VSS NMOS L=1u W=3.4u AS=6.46p AD=6.46p PS=7.2u
+ PD=7.2u
* device instance $798 r0 *1 225.6,124.1 NMOS
XM$798 \$I2051 WL4 BLB9 VSS NMOS L=1u W=3.4u AS=6.46p AD=10.88p PS=7.2u PD=13.2u
* device instance $799 r0 *1 216,381.3 PMOS
XM$799 \$I2052 \$I2053 VDD VDD PMOS L=1u W=3.4u AS=10.88p AD=6.46p PS=13.2u
+ PD=7.2u
* device instance $800 r0 *1 220.8,381.3 PMOS
XM$800 VDD \$I2052 \$I2053 VDD PMOS L=1u W=3.4u AS=6.46p AD=10.88p PS=7.2u
+ PD=13.2u
* device instance $801 r0 *1 211.2,360.9 NMOS
XM$801 BL9 WL12 \$I2052 VSS NMOS L=1u W=3.4u AS=10.88p AD=6.46p PS=13.2u PD=7.2u
* device instance $802 r0 *1 216,360.9 NMOS
XM$802 \$I2052 \$I2053 VSS VSS NMOS L=1u W=3.4u AS=6.46p AD=6.46p PS=7.2u
+ PD=7.2u
* device instance $803 r0 *1 220.8,360.9 NMOS
XM$803 VSS \$I2052 \$I2053 VSS NMOS L=1u W=3.4u AS=6.46p AD=6.46p PS=7.2u
+ PD=7.2u
* device instance $804 r0 *1 225.6,360.9 NMOS
XM$804 \$I2053 WL12 BLB9 VSS NMOS L=1u W=3.4u AS=6.46p AD=10.88p PS=7.2u
+ PD=13.2u
* device instance $805 r0 *1 216,203.7 PMOS
XM$805 \$I2054 \$I2055 VDD VDD PMOS L=1u W=3.4u AS=10.88p AD=6.46p PS=13.2u
+ PD=7.2u
* device instance $806 r0 *1 220.8,203.7 PMOS
XM$806 VDD \$I2054 \$I2055 VDD PMOS L=1u W=3.4u AS=6.46p AD=10.88p PS=7.2u
+ PD=13.2u
* device instance $807 r0 *1 211.2,183.3 NMOS
XM$807 BL9 WL6 \$I2054 VSS NMOS L=1u W=3.4u AS=10.88p AD=6.46p PS=13.2u PD=7.2u
* device instance $808 r0 *1 216,183.3 NMOS
XM$808 \$I2054 \$I2055 VSS VSS NMOS L=1u W=3.4u AS=6.46p AD=6.46p PS=7.2u
+ PD=7.2u
* device instance $809 r0 *1 220.8,183.3 NMOS
XM$809 VSS \$I2054 \$I2055 VSS NMOS L=1u W=3.4u AS=6.46p AD=6.46p PS=7.2u
+ PD=7.2u
* device instance $810 r0 *1 225.6,183.3 NMOS
XM$810 \$I2055 WL6 BLB9 VSS NMOS L=1u W=3.4u AS=6.46p AD=10.88p PS=7.2u PD=13.2u
* device instance $811 r0 *1 216,262.9 PMOS
XM$811 \$I2056 \$I2057 VDD VDD PMOS L=1u W=3.4u AS=10.88p AD=6.46p PS=13.2u
+ PD=7.2u
* device instance $812 r0 *1 220.8,262.9 PMOS
XM$812 VDD \$I2056 \$I2057 VDD PMOS L=1u W=3.4u AS=6.46p AD=10.88p PS=7.2u
+ PD=13.2u
* device instance $813 r0 *1 211.2,242.5 NMOS
XM$813 BL9 WL8 \$I2056 VSS NMOS L=1u W=3.4u AS=10.88p AD=6.46p PS=13.2u PD=7.2u
* device instance $814 r0 *1 216,242.5 NMOS
XM$814 \$I2056 \$I2057 VSS VSS NMOS L=1u W=3.4u AS=6.46p AD=6.46p PS=7.2u
+ PD=7.2u
* device instance $815 r0 *1 220.8,242.5 NMOS
XM$815 VSS \$I2056 \$I2057 VSS NMOS L=1u W=3.4u AS=6.46p AD=6.46p PS=7.2u
+ PD=7.2u
* device instance $816 r0 *1 225.6,242.5 NMOS
XM$816 \$I2057 WL8 BLB9 VSS NMOS L=1u W=3.4u AS=6.46p AD=10.88p PS=7.2u PD=13.2u
* device instance $817 m0 *1 192.8,210.7 PMOS
XM$817 \$I2058 \$I2059 VDD VDD PMOS L=1u W=3.4u AS=10.88p AD=6.46p PS=13.2u
+ PD=7.2u
* device instance $818 m0 *1 197.6,210.7 PMOS
XM$818 VDD \$I2058 \$I2059 VDD PMOS L=1u W=3.4u AS=6.46p AD=10.88p PS=7.2u
+ PD=13.2u
* device instance $819 m0 *1 188,231.1 NMOS
XM$819 BL8 WL7 \$I2058 VSS NMOS L=1u W=3.4u AS=10.88p AD=6.46p PS=13.2u PD=7.2u
* device instance $820 m0 *1 192.8,231.1 NMOS
XM$820 \$I2058 \$I2059 VSS VSS NMOS L=1u W=3.4u AS=6.46p AD=6.46p PS=7.2u
+ PD=7.2u
* device instance $821 m0 *1 197.6,231.1 NMOS
XM$821 VSS \$I2058 \$I2059 VSS NMOS L=1u W=3.4u AS=6.46p AD=6.46p PS=7.2u
+ PD=7.2u
* device instance $822 m0 *1 202.4,231.1 NMOS
XM$822 \$I2059 WL7 BLB8 VSS NMOS L=1u W=3.4u AS=6.46p AD=10.88p PS=7.2u PD=13.2u
* device instance $823 m0 *1 192.8,92.3 PMOS
XM$823 \$I2060 \$I2061 VDD VDD PMOS L=1u W=3.4u AS=10.88p AD=6.46p PS=13.2u
+ PD=7.2u
* device instance $824 m0 *1 197.6,92.3 PMOS
XM$824 VDD \$I2060 \$I2061 VDD PMOS L=1u W=3.4u AS=6.46p AD=10.88p PS=7.2u
+ PD=13.2u
* device instance $825 m0 *1 188,112.7 NMOS
XM$825 BL8 WL3 \$I2060 VSS NMOS L=1u W=3.4u AS=10.88p AD=6.46p PS=13.2u PD=7.2u
* device instance $826 m0 *1 192.8,112.7 NMOS
XM$826 \$I2060 \$I2061 VSS VSS NMOS L=1u W=3.4u AS=6.46p AD=6.46p PS=7.2u
+ PD=7.2u
* device instance $827 m0 *1 197.6,112.7 NMOS
XM$827 VSS \$I2060 \$I2061 VSS NMOS L=1u W=3.4u AS=6.46p AD=6.46p PS=7.2u
+ PD=7.2u
* device instance $828 m0 *1 202.4,112.7 NMOS
XM$828 \$I2061 WL3 BLB8 VSS NMOS L=1u W=3.4u AS=6.46p AD=10.88p PS=7.2u PD=13.2u
* device instance $829 m0 *1 192.8,33.1 PMOS
XM$829 \$I2062 \$I2063 VDD VDD PMOS L=1u W=3.4u AS=10.88p AD=6.46p PS=13.2u
+ PD=7.2u
* device instance $830 m0 *1 197.6,33.1 PMOS
XM$830 VDD \$I2062 \$I2063 VDD PMOS L=1u W=3.4u AS=6.46p AD=10.88p PS=7.2u
+ PD=13.2u
* device instance $831 m0 *1 188,53.5 NMOS
XM$831 BL8 WL1 \$I2062 VSS NMOS L=1u W=3.4u AS=10.88p AD=6.46p PS=13.2u PD=7.2u
* device instance $832 m0 *1 192.8,53.5 NMOS
XM$832 \$I2062 \$I2063 VSS VSS NMOS L=1u W=3.4u AS=6.46p AD=6.46p PS=7.2u
+ PD=7.2u
* device instance $833 m0 *1 197.6,53.5 NMOS
XM$833 VSS \$I2062 \$I2063 VSS NMOS L=1u W=3.4u AS=6.46p AD=6.46p PS=7.2u
+ PD=7.2u
* device instance $834 m0 *1 202.4,53.5 NMOS
XM$834 \$I2063 WL1 BLB8 VSS NMOS L=1u W=3.4u AS=6.46p AD=10.88p PS=7.2u PD=13.2u
* device instance $835 m0 *1 192.8,151.5 PMOS
XM$835 \$I2064 \$I2065 VDD VDD PMOS L=1u W=3.4u AS=10.88p AD=6.46p PS=13.2u
+ PD=7.2u
* device instance $836 m0 *1 197.6,151.5 PMOS
XM$836 VDD \$I2064 \$I2065 VDD PMOS L=1u W=3.4u AS=6.46p AD=10.88p PS=7.2u
+ PD=13.2u
* device instance $837 m0 *1 188,171.9 NMOS
XM$837 BL8 WL5 \$I2064 VSS NMOS L=1u W=3.4u AS=10.88p AD=6.46p PS=13.2u PD=7.2u
* device instance $838 m0 *1 192.8,171.9 NMOS
XM$838 \$I2064 \$I2065 VSS VSS NMOS L=1u W=3.4u AS=6.46p AD=6.46p PS=7.2u
+ PD=7.2u
* device instance $839 m0 *1 197.6,171.9 NMOS
XM$839 VSS \$I2064 \$I2065 VSS NMOS L=1u W=3.4u AS=6.46p AD=6.46p PS=7.2u
+ PD=7.2u
* device instance $840 m0 *1 202.4,171.9 NMOS
XM$840 \$I2065 WL5 BLB8 VSS NMOS L=1u W=3.4u AS=6.46p AD=10.88p PS=7.2u PD=13.2u
* device instance $841 m0 *1 192.8,447.5 PMOS
XM$841 \$I2066 \$I2067 VDD VDD PMOS L=1u W=3.4u AS=10.88p AD=6.46p PS=13.2u
+ PD=7.2u
* device instance $842 m0 *1 197.6,447.5 PMOS
XM$842 VDD \$I2066 \$I2067 VDD PMOS L=1u W=3.4u AS=6.46p AD=10.88p PS=7.2u
+ PD=13.2u
* device instance $843 m0 *1 188,467.9 NMOS
XM$843 BL8 WL15 \$I2066 VSS NMOS L=1u W=3.4u AS=10.88p AD=6.46p PS=13.2u PD=7.2u
* device instance $844 m0 *1 192.8,467.9 NMOS
XM$844 \$I2066 \$I2067 VSS VSS NMOS L=1u W=3.4u AS=6.46p AD=6.46p PS=7.2u
+ PD=7.2u
* device instance $845 m0 *1 197.6,467.9 NMOS
XM$845 VSS \$I2066 \$I2067 VSS NMOS L=1u W=3.4u AS=6.46p AD=6.46p PS=7.2u
+ PD=7.2u
* device instance $846 m0 *1 202.4,467.9 NMOS
XM$846 \$I2067 WL15 BLB8 VSS NMOS L=1u W=3.4u AS=6.46p AD=10.88p PS=7.2u
+ PD=13.2u
* device instance $847 m0 *1 192.8,388.3 PMOS
XM$847 \$I2068 \$I2069 VDD VDD PMOS L=1u W=3.4u AS=10.88p AD=6.46p PS=13.2u
+ PD=7.2u
* device instance $848 m0 *1 197.6,388.3 PMOS
XM$848 VDD \$I2068 \$I2069 VDD PMOS L=1u W=3.4u AS=6.46p AD=10.88p PS=7.2u
+ PD=13.2u
* device instance $849 m0 *1 188,408.7 NMOS
XM$849 BL8 WL13 \$I2068 VSS NMOS L=1u W=3.4u AS=10.88p AD=6.46p PS=13.2u PD=7.2u
* device instance $850 m0 *1 192.8,408.7 NMOS
XM$850 \$I2068 \$I2069 VSS VSS NMOS L=1u W=3.4u AS=6.46p AD=6.46p PS=7.2u
+ PD=7.2u
* device instance $851 m0 *1 197.6,408.7 NMOS
XM$851 VSS \$I2068 \$I2069 VSS NMOS L=1u W=3.4u AS=6.46p AD=6.46p PS=7.2u
+ PD=7.2u
* device instance $852 m0 *1 202.4,408.7 NMOS
XM$852 \$I2069 WL13 BLB8 VSS NMOS L=1u W=3.4u AS=6.46p AD=10.88p PS=7.2u
+ PD=13.2u
* device instance $853 m0 *1 192.8,329.1 PMOS
XM$853 \$I2070 \$I2071 VDD VDD PMOS L=1u W=3.4u AS=10.88p AD=6.46p PS=13.2u
+ PD=7.2u
* device instance $854 m0 *1 197.6,329.1 PMOS
XM$854 VDD \$I2070 \$I2071 VDD PMOS L=1u W=3.4u AS=6.46p AD=10.88p PS=7.2u
+ PD=13.2u
* device instance $855 m0 *1 188,349.5 NMOS
XM$855 BL8 WL11 \$I2070 VSS NMOS L=1u W=3.4u AS=10.88p AD=6.46p PS=13.2u PD=7.2u
* device instance $856 m0 *1 192.8,349.5 NMOS
XM$856 \$I2070 \$I2071 VSS VSS NMOS L=1u W=3.4u AS=6.46p AD=6.46p PS=7.2u
+ PD=7.2u
* device instance $857 m0 *1 197.6,349.5 NMOS
XM$857 VSS \$I2070 \$I2071 VSS NMOS L=1u W=3.4u AS=6.46p AD=6.46p PS=7.2u
+ PD=7.2u
* device instance $858 m0 *1 202.4,349.5 NMOS
XM$858 \$I2071 WL11 BLB8 VSS NMOS L=1u W=3.4u AS=6.46p AD=10.88p PS=7.2u
+ PD=13.2u
* device instance $859 m0 *1 192.8,269.9 PMOS
XM$859 \$I2072 \$I2073 VDD VDD PMOS L=1u W=3.4u AS=10.88p AD=6.46p PS=13.2u
+ PD=7.2u
* device instance $860 m0 *1 197.6,269.9 PMOS
XM$860 VDD \$I2072 \$I2073 VDD PMOS L=1u W=3.4u AS=6.46p AD=10.88p PS=7.2u
+ PD=13.2u
* device instance $861 m0 *1 188,290.3 NMOS
XM$861 BL8 WL9 \$I2072 VSS NMOS L=1u W=3.4u AS=10.88p AD=6.46p PS=13.2u PD=7.2u
* device instance $862 m0 *1 192.8,290.3 NMOS
XM$862 \$I2072 \$I2073 VSS VSS NMOS L=1u W=3.4u AS=6.46p AD=6.46p PS=7.2u
+ PD=7.2u
* device instance $863 m0 *1 197.6,290.3 NMOS
XM$863 VSS \$I2072 \$I2073 VSS NMOS L=1u W=3.4u AS=6.46p AD=6.46p PS=7.2u
+ PD=7.2u
* device instance $864 m0 *1 202.4,290.3 NMOS
XM$864 \$I2073 WL9 BLB8 VSS NMOS L=1u W=3.4u AS=6.46p AD=10.88p PS=7.2u PD=13.2u
* device instance $865 r0 *1 192.8,440.5 PMOS
XM$865 \$I2074 \$I2075 VDD VDD PMOS L=1u W=3.4u AS=10.88p AD=6.46p PS=13.2u
+ PD=7.2u
* device instance $866 r0 *1 197.6,440.5 PMOS
XM$866 VDD \$I2074 \$I2075 VDD PMOS L=1u W=3.4u AS=6.46p AD=10.88p PS=7.2u
+ PD=13.2u
* device instance $867 r0 *1 188,420.1 NMOS
XM$867 BL8 WL14 \$I2074 VSS NMOS L=1u W=3.4u AS=10.88p AD=6.46p PS=13.2u PD=7.2u
* device instance $868 r0 *1 192.8,420.1 NMOS
XM$868 \$I2074 \$I2075 VSS VSS NMOS L=1u W=3.4u AS=6.46p AD=6.46p PS=7.2u
+ PD=7.2u
* device instance $869 r0 *1 197.6,420.1 NMOS
XM$869 VSS \$I2074 \$I2075 VSS NMOS L=1u W=3.4u AS=6.46p AD=6.46p PS=7.2u
+ PD=7.2u
* device instance $870 r0 *1 202.4,420.1 NMOS
XM$870 \$I2075 WL14 BLB8 VSS NMOS L=1u W=3.4u AS=6.46p AD=10.88p PS=7.2u
+ PD=13.2u
* device instance $871 r0 *1 192.8,381.3 PMOS
XM$871 \$I2076 \$I2077 VDD VDD PMOS L=1u W=3.4u AS=10.88p AD=6.46p PS=13.2u
+ PD=7.2u
* device instance $872 r0 *1 197.6,381.3 PMOS
XM$872 VDD \$I2076 \$I2077 VDD PMOS L=1u W=3.4u AS=6.46p AD=10.88p PS=7.2u
+ PD=13.2u
* device instance $873 r0 *1 188,360.9 NMOS
XM$873 BL8 WL12 \$I2076 VSS NMOS L=1u W=3.4u AS=10.88p AD=6.46p PS=13.2u PD=7.2u
* device instance $874 r0 *1 192.8,360.9 NMOS
XM$874 \$I2076 \$I2077 VSS VSS NMOS L=1u W=3.4u AS=6.46p AD=6.46p PS=7.2u
+ PD=7.2u
* device instance $875 r0 *1 197.6,360.9 NMOS
XM$875 VSS \$I2076 \$I2077 VSS NMOS L=1u W=3.4u AS=6.46p AD=6.46p PS=7.2u
+ PD=7.2u
* device instance $876 r0 *1 202.4,360.9 NMOS
XM$876 \$I2077 WL12 BLB8 VSS NMOS L=1u W=3.4u AS=6.46p AD=10.88p PS=7.2u
+ PD=13.2u
* device instance $877 r0 *1 192.8,322.1 PMOS
XM$877 \$I2078 \$I2079 VDD VDD PMOS L=1u W=3.4u AS=10.88p AD=6.46p PS=13.2u
+ PD=7.2u
* device instance $878 r0 *1 197.6,322.1 PMOS
XM$878 VDD \$I2078 \$I2079 VDD PMOS L=1u W=3.4u AS=6.46p AD=10.88p PS=7.2u
+ PD=13.2u
* device instance $879 r0 *1 188,301.7 NMOS
XM$879 BL8 WL10 \$I2078 VSS NMOS L=1u W=3.4u AS=10.88p AD=6.46p PS=13.2u PD=7.2u
* device instance $880 r0 *1 192.8,301.7 NMOS
XM$880 \$I2078 \$I2079 VSS VSS NMOS L=1u W=3.4u AS=6.46p AD=6.46p PS=7.2u
+ PD=7.2u
* device instance $881 r0 *1 197.6,301.7 NMOS
XM$881 VSS \$I2078 \$I2079 VSS NMOS L=1u W=3.4u AS=6.46p AD=6.46p PS=7.2u
+ PD=7.2u
* device instance $882 r0 *1 202.4,301.7 NMOS
XM$882 \$I2079 WL10 BLB8 VSS NMOS L=1u W=3.4u AS=6.46p AD=10.88p PS=7.2u
+ PD=13.2u
* device instance $883 r0 *1 192.8,203.7 PMOS
XM$883 \$I2080 \$I2081 VDD VDD PMOS L=1u W=3.4u AS=10.88p AD=6.46p PS=13.2u
+ PD=7.2u
* device instance $884 r0 *1 197.6,203.7 PMOS
XM$884 VDD \$I2080 \$I2081 VDD PMOS L=1u W=3.4u AS=6.46p AD=10.88p PS=7.2u
+ PD=13.2u
* device instance $885 r0 *1 188,183.3 NMOS
XM$885 BL8 WL6 \$I2080 VSS NMOS L=1u W=3.4u AS=10.88p AD=6.46p PS=13.2u PD=7.2u
* device instance $886 r0 *1 192.8,183.3 NMOS
XM$886 \$I2080 \$I2081 VSS VSS NMOS L=1u W=3.4u AS=6.46p AD=6.46p PS=7.2u
+ PD=7.2u
* device instance $887 r0 *1 197.6,183.3 NMOS
XM$887 VSS \$I2080 \$I2081 VSS NMOS L=1u W=3.4u AS=6.46p AD=6.46p PS=7.2u
+ PD=7.2u
* device instance $888 r0 *1 202.4,183.3 NMOS
XM$888 \$I2081 WL6 BLB8 VSS NMOS L=1u W=3.4u AS=6.46p AD=10.88p PS=7.2u PD=13.2u
* device instance $889 r0 *1 192.8,85.3 PMOS
XM$889 \$I2082 \$I2083 VDD VDD PMOS L=1u W=3.4u AS=10.88p AD=6.46p PS=13.2u
+ PD=7.2u
* device instance $890 r0 *1 197.6,85.3 PMOS
XM$890 VDD \$I2082 \$I2083 VDD PMOS L=1u W=3.4u AS=6.46p AD=10.88p PS=7.2u
+ PD=13.2u
* device instance $891 r0 *1 188,64.9 NMOS
XM$891 BL8 WL2 \$I2082 VSS NMOS L=1u W=3.4u AS=10.88p AD=6.46p PS=13.2u PD=7.2u
* device instance $892 r0 *1 192.8,64.9 NMOS
XM$892 \$I2082 \$I2083 VSS VSS NMOS L=1u W=3.4u AS=6.46p AD=6.46p PS=7.2u
+ PD=7.2u
* device instance $893 r0 *1 197.6,64.9 NMOS
XM$893 VSS \$I2082 \$I2083 VSS NMOS L=1u W=3.4u AS=6.46p AD=6.46p PS=7.2u
+ PD=7.2u
* device instance $894 r0 *1 202.4,64.9 NMOS
XM$894 \$I2083 WL2 BLB8 VSS NMOS L=1u W=3.4u AS=6.46p AD=10.88p PS=7.2u PD=13.2u
* device instance $895 r0 *1 192.8,144.5 PMOS
XM$895 \$I2084 \$I2085 VDD VDD PMOS L=1u W=3.4u AS=10.88p AD=6.46p PS=13.2u
+ PD=7.2u
* device instance $896 r0 *1 197.6,144.5 PMOS
XM$896 VDD \$I2084 \$I2085 VDD PMOS L=1u W=3.4u AS=6.46p AD=10.88p PS=7.2u
+ PD=13.2u
* device instance $897 r0 *1 188,124.1 NMOS
XM$897 BL8 WL4 \$I2084 VSS NMOS L=1u W=3.4u AS=10.88p AD=6.46p PS=13.2u PD=7.2u
* device instance $898 r0 *1 192.8,124.1 NMOS
XM$898 \$I2084 \$I2085 VSS VSS NMOS L=1u W=3.4u AS=6.46p AD=6.46p PS=7.2u
+ PD=7.2u
* device instance $899 r0 *1 197.6,124.1 NMOS
XM$899 VSS \$I2084 \$I2085 VSS NMOS L=1u W=3.4u AS=6.46p AD=6.46p PS=7.2u
+ PD=7.2u
* device instance $900 r0 *1 202.4,124.1 NMOS
XM$900 \$I2085 WL4 BLB8 VSS NMOS L=1u W=3.4u AS=6.46p AD=10.88p PS=7.2u PD=13.2u
* device instance $901 r0 *1 192.8,262.9 PMOS
XM$901 \$I2086 \$I2087 VDD VDD PMOS L=1u W=3.4u AS=10.88p AD=6.46p PS=13.2u
+ PD=7.2u
* device instance $902 r0 *1 197.6,262.9 PMOS
XM$902 VDD \$I2086 \$I2087 VDD PMOS L=1u W=3.4u AS=6.46p AD=10.88p PS=7.2u
+ PD=13.2u
* device instance $903 r0 *1 188,242.5 NMOS
XM$903 BL8 WL8 \$I2086 VSS NMOS L=1u W=3.4u AS=10.88p AD=6.46p PS=13.2u PD=7.2u
* device instance $904 r0 *1 192.8,242.5 NMOS
XM$904 \$I2086 \$I2087 VSS VSS NMOS L=1u W=3.4u AS=6.46p AD=6.46p PS=7.2u
+ PD=7.2u
* device instance $905 r0 *1 197.6,242.5 NMOS
XM$905 VSS \$I2086 \$I2087 VSS NMOS L=1u W=3.4u AS=6.46p AD=6.46p PS=7.2u
+ PD=7.2u
* device instance $906 r0 *1 202.4,242.5 NMOS
XM$906 \$I2087 WL8 BLB8 VSS NMOS L=1u W=3.4u AS=6.46p AD=10.88p PS=7.2u PD=13.2u
* device instance $907 m0 *1 169.6,210.7 PMOS
XM$907 \$I2088 \$I2089 VDD VDD PMOS L=1u W=3.4u AS=10.88p AD=6.46p PS=13.2u
+ PD=7.2u
* device instance $908 m0 *1 174.4,210.7 PMOS
XM$908 VDD \$I2088 \$I2089 VDD PMOS L=1u W=3.4u AS=6.46p AD=10.88p PS=7.2u
+ PD=13.2u
* device instance $909 m0 *1 164.8,231.1 NMOS
XM$909 BL7 WL7 \$I2088 VSS NMOS L=1u W=3.4u AS=10.88p AD=6.46p PS=13.2u PD=7.2u
* device instance $910 m0 *1 169.6,231.1 NMOS
XM$910 \$I2088 \$I2089 VSS VSS NMOS L=1u W=3.4u AS=6.46p AD=6.46p PS=7.2u
+ PD=7.2u
* device instance $911 m0 *1 174.4,231.1 NMOS
XM$911 VSS \$I2088 \$I2089 VSS NMOS L=1u W=3.4u AS=6.46p AD=6.46p PS=7.2u
+ PD=7.2u
* device instance $912 m0 *1 179.2,231.1 NMOS
XM$912 \$I2089 WL7 BLB7 VSS NMOS L=1u W=3.4u AS=6.46p AD=10.88p PS=7.2u PD=13.2u
* device instance $913 m0 *1 169.6,92.3 PMOS
XM$913 \$I2090 \$I2091 VDD VDD PMOS L=1u W=3.4u AS=10.88p AD=6.46p PS=13.2u
+ PD=7.2u
* device instance $914 m0 *1 174.4,92.3 PMOS
XM$914 VDD \$I2090 \$I2091 VDD PMOS L=1u W=3.4u AS=6.46p AD=10.88p PS=7.2u
+ PD=13.2u
* device instance $915 m0 *1 164.8,112.7 NMOS
XM$915 BL7 WL3 \$I2090 VSS NMOS L=1u W=3.4u AS=10.88p AD=6.46p PS=13.2u PD=7.2u
* device instance $916 m0 *1 169.6,112.7 NMOS
XM$916 \$I2090 \$I2091 VSS VSS NMOS L=1u W=3.4u AS=6.46p AD=6.46p PS=7.2u
+ PD=7.2u
* device instance $917 m0 *1 174.4,112.7 NMOS
XM$917 VSS \$I2090 \$I2091 VSS NMOS L=1u W=3.4u AS=6.46p AD=6.46p PS=7.2u
+ PD=7.2u
* device instance $918 m0 *1 179.2,112.7 NMOS
XM$918 \$I2091 WL3 BLB7 VSS NMOS L=1u W=3.4u AS=6.46p AD=10.88p PS=7.2u PD=13.2u
* device instance $919 m0 *1 169.6,33.1 PMOS
XM$919 \$I2092 \$I2093 VDD VDD PMOS L=1u W=3.4u AS=10.88p AD=6.46p PS=13.2u
+ PD=7.2u
* device instance $920 m0 *1 174.4,33.1 PMOS
XM$920 VDD \$I2092 \$I2093 VDD PMOS L=1u W=3.4u AS=6.46p AD=10.88p PS=7.2u
+ PD=13.2u
* device instance $921 m0 *1 164.8,53.5 NMOS
XM$921 BL7 WL1 \$I2092 VSS NMOS L=1u W=3.4u AS=10.88p AD=6.46p PS=13.2u PD=7.2u
* device instance $922 m0 *1 169.6,53.5 NMOS
XM$922 \$I2092 \$I2093 VSS VSS NMOS L=1u W=3.4u AS=6.46p AD=6.46p PS=7.2u
+ PD=7.2u
* device instance $923 m0 *1 174.4,53.5 NMOS
XM$923 VSS \$I2092 \$I2093 VSS NMOS L=1u W=3.4u AS=6.46p AD=6.46p PS=7.2u
+ PD=7.2u
* device instance $924 m0 *1 179.2,53.5 NMOS
XM$924 \$I2093 WL1 BLB7 VSS NMOS L=1u W=3.4u AS=6.46p AD=10.88p PS=7.2u PD=13.2u
* device instance $925 m0 *1 169.6,447.5 PMOS
XM$925 \$I2094 \$I2095 VDD VDD PMOS L=1u W=3.4u AS=10.88p AD=6.46p PS=13.2u
+ PD=7.2u
* device instance $926 m0 *1 174.4,447.5 PMOS
XM$926 VDD \$I2094 \$I2095 VDD PMOS L=1u W=3.4u AS=6.46p AD=10.88p PS=7.2u
+ PD=13.2u
* device instance $927 m0 *1 164.8,467.9 NMOS
XM$927 BL7 WL15 \$I2094 VSS NMOS L=1u W=3.4u AS=10.88p AD=6.46p PS=13.2u PD=7.2u
* device instance $928 m0 *1 169.6,467.9 NMOS
XM$928 \$I2094 \$I2095 VSS VSS NMOS L=1u W=3.4u AS=6.46p AD=6.46p PS=7.2u
+ PD=7.2u
* device instance $929 m0 *1 174.4,467.9 NMOS
XM$929 VSS \$I2094 \$I2095 VSS NMOS L=1u W=3.4u AS=6.46p AD=6.46p PS=7.2u
+ PD=7.2u
* device instance $930 m0 *1 179.2,467.9 NMOS
XM$930 \$I2095 WL15 BLB7 VSS NMOS L=1u W=3.4u AS=6.46p AD=10.88p PS=7.2u
+ PD=13.2u
* device instance $931 m0 *1 169.6,329.1 PMOS
XM$931 \$I2096 \$I2097 VDD VDD PMOS L=1u W=3.4u AS=10.88p AD=6.46p PS=13.2u
+ PD=7.2u
* device instance $932 m0 *1 174.4,329.1 PMOS
XM$932 VDD \$I2096 \$I2097 VDD PMOS L=1u W=3.4u AS=6.46p AD=10.88p PS=7.2u
+ PD=13.2u
* device instance $933 m0 *1 164.8,349.5 NMOS
XM$933 BL7 WL11 \$I2096 VSS NMOS L=1u W=3.4u AS=10.88p AD=6.46p PS=13.2u PD=7.2u
* device instance $934 m0 *1 169.6,349.5 NMOS
XM$934 \$I2096 \$I2097 VSS VSS NMOS L=1u W=3.4u AS=6.46p AD=6.46p PS=7.2u
+ PD=7.2u
* device instance $935 m0 *1 174.4,349.5 NMOS
XM$935 VSS \$I2096 \$I2097 VSS NMOS L=1u W=3.4u AS=6.46p AD=6.46p PS=7.2u
+ PD=7.2u
* device instance $936 m0 *1 179.2,349.5 NMOS
XM$936 \$I2097 WL11 BLB7 VSS NMOS L=1u W=3.4u AS=6.46p AD=10.88p PS=7.2u
+ PD=13.2u
* device instance $937 m0 *1 169.6,269.9 PMOS
XM$937 \$I2098 \$I2099 VDD VDD PMOS L=1u W=3.4u AS=10.88p AD=6.46p PS=13.2u
+ PD=7.2u
* device instance $938 m0 *1 174.4,269.9 PMOS
XM$938 VDD \$I2098 \$I2099 VDD PMOS L=1u W=3.4u AS=6.46p AD=10.88p PS=7.2u
+ PD=13.2u
* device instance $939 m0 *1 164.8,290.3 NMOS
XM$939 BL7 WL9 \$I2098 VSS NMOS L=1u W=3.4u AS=10.88p AD=6.46p PS=13.2u PD=7.2u
* device instance $940 m0 *1 169.6,290.3 NMOS
XM$940 \$I2098 \$I2099 VSS VSS NMOS L=1u W=3.4u AS=6.46p AD=6.46p PS=7.2u
+ PD=7.2u
* device instance $941 m0 *1 174.4,290.3 NMOS
XM$941 VSS \$I2098 \$I2099 VSS NMOS L=1u W=3.4u AS=6.46p AD=6.46p PS=7.2u
+ PD=7.2u
* device instance $942 m0 *1 179.2,290.3 NMOS
XM$942 \$I2099 WL9 BLB7 VSS NMOS L=1u W=3.4u AS=6.46p AD=10.88p PS=7.2u PD=13.2u
* device instance $943 m0 *1 169.6,388.3 PMOS
XM$943 \$I2100 \$I2101 VDD VDD PMOS L=1u W=3.4u AS=10.88p AD=6.46p PS=13.2u
+ PD=7.2u
* device instance $944 m0 *1 174.4,388.3 PMOS
XM$944 VDD \$I2100 \$I2101 VDD PMOS L=1u W=3.4u AS=6.46p AD=10.88p PS=7.2u
+ PD=13.2u
* device instance $945 m0 *1 164.8,408.7 NMOS
XM$945 BL7 WL13 \$I2100 VSS NMOS L=1u W=3.4u AS=10.88p AD=6.46p PS=13.2u PD=7.2u
* device instance $946 m0 *1 169.6,408.7 NMOS
XM$946 \$I2100 \$I2101 VSS VSS NMOS L=1u W=3.4u AS=6.46p AD=6.46p PS=7.2u
+ PD=7.2u
* device instance $947 m0 *1 174.4,408.7 NMOS
XM$947 VSS \$I2100 \$I2101 VSS NMOS L=1u W=3.4u AS=6.46p AD=6.46p PS=7.2u
+ PD=7.2u
* device instance $948 m0 *1 179.2,408.7 NMOS
XM$948 \$I2101 WL13 BLB7 VSS NMOS L=1u W=3.4u AS=6.46p AD=10.88p PS=7.2u
+ PD=13.2u
* device instance $949 m0 *1 169.6,151.5 PMOS
XM$949 \$I2102 \$I2103 VDD VDD PMOS L=1u W=3.4u AS=10.88p AD=6.46p PS=13.2u
+ PD=7.2u
* device instance $950 m0 *1 174.4,151.5 PMOS
XM$950 VDD \$I2102 \$I2103 VDD PMOS L=1u W=3.4u AS=6.46p AD=10.88p PS=7.2u
+ PD=13.2u
* device instance $951 m0 *1 164.8,171.9 NMOS
XM$951 BL7 WL5 \$I2102 VSS NMOS L=1u W=3.4u AS=10.88p AD=6.46p PS=13.2u PD=7.2u
* device instance $952 m0 *1 169.6,171.9 NMOS
XM$952 \$I2102 \$I2103 VSS VSS NMOS L=1u W=3.4u AS=6.46p AD=6.46p PS=7.2u
+ PD=7.2u
* device instance $953 m0 *1 174.4,171.9 NMOS
XM$953 VSS \$I2102 \$I2103 VSS NMOS L=1u W=3.4u AS=6.46p AD=6.46p PS=7.2u
+ PD=7.2u
* device instance $954 m0 *1 179.2,171.9 NMOS
XM$954 \$I2103 WL5 BLB7 VSS NMOS L=1u W=3.4u AS=6.46p AD=10.88p PS=7.2u PD=13.2u
* device instance $955 r0 *1 169.6,144.5 PMOS
XM$955 \$I2104 \$I2105 VDD VDD PMOS L=1u W=3.4u AS=10.88p AD=6.46p PS=13.2u
+ PD=7.2u
* device instance $956 r0 *1 174.4,144.5 PMOS
XM$956 VDD \$I2104 \$I2105 VDD PMOS L=1u W=3.4u AS=6.46p AD=10.88p PS=7.2u
+ PD=13.2u
* device instance $957 r0 *1 164.8,124.1 NMOS
XM$957 BL7 WL4 \$I2104 VSS NMOS L=1u W=3.4u AS=10.88p AD=6.46p PS=13.2u PD=7.2u
* device instance $958 r0 *1 169.6,124.1 NMOS
XM$958 \$I2104 \$I2105 VSS VSS NMOS L=1u W=3.4u AS=6.46p AD=6.46p PS=7.2u
+ PD=7.2u
* device instance $959 r0 *1 174.4,124.1 NMOS
XM$959 VSS \$I2104 \$I2105 VSS NMOS L=1u W=3.4u AS=6.46p AD=6.46p PS=7.2u
+ PD=7.2u
* device instance $960 r0 *1 179.2,124.1 NMOS
XM$960 \$I2105 WL4 BLB7 VSS NMOS L=1u W=3.4u AS=6.46p AD=10.88p PS=7.2u PD=13.2u
* device instance $961 r0 *1 169.6,85.3 PMOS
XM$961 \$I2106 \$I2107 VDD VDD PMOS L=1u W=3.4u AS=10.88p AD=6.46p PS=13.2u
+ PD=7.2u
* device instance $962 r0 *1 174.4,85.3 PMOS
XM$962 VDD \$I2106 \$I2107 VDD PMOS L=1u W=3.4u AS=6.46p AD=10.88p PS=7.2u
+ PD=13.2u
* device instance $963 r0 *1 164.8,64.9 NMOS
XM$963 BL7 WL2 \$I2106 VSS NMOS L=1u W=3.4u AS=10.88p AD=6.46p PS=13.2u PD=7.2u
* device instance $964 r0 *1 169.6,64.9 NMOS
XM$964 \$I2106 \$I2107 VSS VSS NMOS L=1u W=3.4u AS=6.46p AD=6.46p PS=7.2u
+ PD=7.2u
* device instance $965 r0 *1 174.4,64.9 NMOS
XM$965 VSS \$I2106 \$I2107 VSS NMOS L=1u W=3.4u AS=6.46p AD=6.46p PS=7.2u
+ PD=7.2u
* device instance $966 r0 *1 179.2,64.9 NMOS
XM$966 \$I2107 WL2 BLB7 VSS NMOS L=1u W=3.4u AS=6.46p AD=10.88p PS=7.2u PD=13.2u
* device instance $967 r0 *1 169.6,262.9 PMOS
XM$967 \$I2108 \$I2109 VDD VDD PMOS L=1u W=3.4u AS=10.88p AD=6.46p PS=13.2u
+ PD=7.2u
* device instance $968 r0 *1 174.4,262.9 PMOS
XM$968 VDD \$I2108 \$I2109 VDD PMOS L=1u W=3.4u AS=6.46p AD=10.88p PS=7.2u
+ PD=13.2u
* device instance $969 r0 *1 164.8,242.5 NMOS
XM$969 BL7 WL8 \$I2108 VSS NMOS L=1u W=3.4u AS=10.88p AD=6.46p PS=13.2u PD=7.2u
* device instance $970 r0 *1 169.6,242.5 NMOS
XM$970 \$I2108 \$I2109 VSS VSS NMOS L=1u W=3.4u AS=6.46p AD=6.46p PS=7.2u
+ PD=7.2u
* device instance $971 r0 *1 174.4,242.5 NMOS
XM$971 VSS \$I2108 \$I2109 VSS NMOS L=1u W=3.4u AS=6.46p AD=6.46p PS=7.2u
+ PD=7.2u
* device instance $972 r0 *1 179.2,242.5 NMOS
XM$972 \$I2109 WL8 BLB7 VSS NMOS L=1u W=3.4u AS=6.46p AD=10.88p PS=7.2u PD=13.2u
* device instance $973 r0 *1 169.6,440.5 PMOS
XM$973 \$I2110 \$I2111 VDD VDD PMOS L=1u W=3.4u AS=10.88p AD=6.46p PS=13.2u
+ PD=7.2u
* device instance $974 r0 *1 174.4,440.5 PMOS
XM$974 VDD \$I2110 \$I2111 VDD PMOS L=1u W=3.4u AS=6.46p AD=10.88p PS=7.2u
+ PD=13.2u
* device instance $975 r0 *1 164.8,420.1 NMOS
XM$975 BL7 WL14 \$I2110 VSS NMOS L=1u W=3.4u AS=10.88p AD=6.46p PS=13.2u PD=7.2u
* device instance $976 r0 *1 169.6,420.1 NMOS
XM$976 \$I2110 \$I2111 VSS VSS NMOS L=1u W=3.4u AS=6.46p AD=6.46p PS=7.2u
+ PD=7.2u
* device instance $977 r0 *1 174.4,420.1 NMOS
XM$977 VSS \$I2110 \$I2111 VSS NMOS L=1u W=3.4u AS=6.46p AD=6.46p PS=7.2u
+ PD=7.2u
* device instance $978 r0 *1 179.2,420.1 NMOS
XM$978 \$I2111 WL14 BLB7 VSS NMOS L=1u W=3.4u AS=6.46p AD=10.88p PS=7.2u
+ PD=13.2u
* device instance $979 r0 *1 169.6,322.1 PMOS
XM$979 \$I2112 \$I2113 VDD VDD PMOS L=1u W=3.4u AS=10.88p AD=6.46p PS=13.2u
+ PD=7.2u
* device instance $980 r0 *1 174.4,322.1 PMOS
XM$980 VDD \$I2112 \$I2113 VDD PMOS L=1u W=3.4u AS=6.46p AD=10.88p PS=7.2u
+ PD=13.2u
* device instance $981 r0 *1 164.8,301.7 NMOS
XM$981 BL7 WL10 \$I2112 VSS NMOS L=1u W=3.4u AS=10.88p AD=6.46p PS=13.2u PD=7.2u
* device instance $982 r0 *1 169.6,301.7 NMOS
XM$982 \$I2112 \$I2113 VSS VSS NMOS L=1u W=3.4u AS=6.46p AD=6.46p PS=7.2u
+ PD=7.2u
* device instance $983 r0 *1 174.4,301.7 NMOS
XM$983 VSS \$I2112 \$I2113 VSS NMOS L=1u W=3.4u AS=6.46p AD=6.46p PS=7.2u
+ PD=7.2u
* device instance $984 r0 *1 179.2,301.7 NMOS
XM$984 \$I2113 WL10 BLB7 VSS NMOS L=1u W=3.4u AS=6.46p AD=10.88p PS=7.2u
+ PD=13.2u
* device instance $985 r0 *1 169.6,381.3 PMOS
XM$985 \$I2114 \$I2115 VDD VDD PMOS L=1u W=3.4u AS=10.88p AD=6.46p PS=13.2u
+ PD=7.2u
* device instance $986 r0 *1 174.4,381.3 PMOS
XM$986 VDD \$I2114 \$I2115 VDD PMOS L=1u W=3.4u AS=6.46p AD=10.88p PS=7.2u
+ PD=13.2u
* device instance $987 r0 *1 164.8,360.9 NMOS
XM$987 BL7 WL12 \$I2114 VSS NMOS L=1u W=3.4u AS=10.88p AD=6.46p PS=13.2u PD=7.2u
* device instance $988 r0 *1 169.6,360.9 NMOS
XM$988 \$I2114 \$I2115 VSS VSS NMOS L=1u W=3.4u AS=6.46p AD=6.46p PS=7.2u
+ PD=7.2u
* device instance $989 r0 *1 174.4,360.9 NMOS
XM$989 VSS \$I2114 \$I2115 VSS NMOS L=1u W=3.4u AS=6.46p AD=6.46p PS=7.2u
+ PD=7.2u
* device instance $990 r0 *1 179.2,360.9 NMOS
XM$990 \$I2115 WL12 BLB7 VSS NMOS L=1u W=3.4u AS=6.46p AD=10.88p PS=7.2u
+ PD=13.2u
* device instance $991 r0 *1 169.6,203.7 PMOS
XM$991 \$I2116 \$I2117 VDD VDD PMOS L=1u W=3.4u AS=10.88p AD=6.46p PS=13.2u
+ PD=7.2u
* device instance $992 r0 *1 174.4,203.7 PMOS
XM$992 VDD \$I2116 \$I2117 VDD PMOS L=1u W=3.4u AS=6.46p AD=10.88p PS=7.2u
+ PD=13.2u
* device instance $993 r0 *1 164.8,183.3 NMOS
XM$993 BL7 WL6 \$I2116 VSS NMOS L=1u W=3.4u AS=10.88p AD=6.46p PS=13.2u PD=7.2u
* device instance $994 r0 *1 169.6,183.3 NMOS
XM$994 \$I2116 \$I2117 VSS VSS NMOS L=1u W=3.4u AS=6.46p AD=6.46p PS=7.2u
+ PD=7.2u
* device instance $995 r0 *1 174.4,183.3 NMOS
XM$995 VSS \$I2116 \$I2117 VSS NMOS L=1u W=3.4u AS=6.46p AD=6.46p PS=7.2u
+ PD=7.2u
* device instance $996 r0 *1 179.2,183.3 NMOS
XM$996 \$I2117 WL6 BLB7 VSS NMOS L=1u W=3.4u AS=6.46p AD=10.88p PS=7.2u PD=13.2u
* device instance $997 m0 *1 285.6,388.3 PMOS
XM$997 \$I2118 \$I2119 VDD VDD PMOS L=1u W=3.4u AS=10.88p AD=6.46p PS=13.2u
+ PD=7.2u
* device instance $998 m0 *1 290.4,388.3 PMOS
XM$998 VDD \$I2118 \$I2119 VDD PMOS L=1u W=3.4u AS=6.46p AD=10.88p PS=7.2u
+ PD=13.2u
* device instance $999 m0 *1 280.8,408.7 NMOS
XM$999 BL12 WL13 \$I2118 VSS NMOS L=1u W=3.4u AS=10.88p AD=6.46p PS=13.2u
+ PD=7.2u
* device instance $1000 m0 *1 285.6,408.7 NMOS
XM$1000 \$I2118 \$I2119 VSS VSS NMOS L=1u W=3.4u AS=6.46p AD=6.46p PS=7.2u
+ PD=7.2u
* device instance $1001 m0 *1 290.4,408.7 NMOS
XM$1001 VSS \$I2118 \$I2119 VSS NMOS L=1u W=3.4u AS=6.46p AD=6.46p PS=7.2u
+ PD=7.2u
* device instance $1002 m0 *1 295.2,408.7 NMOS
XM$1002 \$I2119 WL13 BLB12 VSS NMOS L=1u W=3.4u AS=6.46p AD=10.88p PS=7.2u
+ PD=13.2u
* device instance $1003 m0 *1 285.6,329.1 PMOS
XM$1003 \$I2120 \$I2121 VDD VDD PMOS L=1u W=3.4u AS=10.88p AD=6.46p PS=13.2u
+ PD=7.2u
* device instance $1004 m0 *1 290.4,329.1 PMOS
XM$1004 VDD \$I2120 \$I2121 VDD PMOS L=1u W=3.4u AS=6.46p AD=10.88p PS=7.2u
+ PD=13.2u
* device instance $1005 m0 *1 280.8,349.5 NMOS
XM$1005 BL12 WL11 \$I2120 VSS NMOS L=1u W=3.4u AS=10.88p AD=6.46p PS=13.2u
+ PD=7.2u
* device instance $1006 m0 *1 285.6,349.5 NMOS
XM$1006 \$I2120 \$I2121 VSS VSS NMOS L=1u W=3.4u AS=6.46p AD=6.46p PS=7.2u
+ PD=7.2u
* device instance $1007 m0 *1 290.4,349.5 NMOS
XM$1007 VSS \$I2120 \$I2121 VSS NMOS L=1u W=3.4u AS=6.46p AD=6.46p PS=7.2u
+ PD=7.2u
* device instance $1008 m0 *1 295.2,349.5 NMOS
XM$1008 \$I2121 WL11 BLB12 VSS NMOS L=1u W=3.4u AS=6.46p AD=10.88p PS=7.2u
+ PD=13.2u
* device instance $1009 m0 *1 285.6,447.5 PMOS
XM$1009 \$I2122 \$I2123 VDD VDD PMOS L=1u W=3.4u AS=10.88p AD=6.46p PS=13.2u
+ PD=7.2u
* device instance $1010 m0 *1 290.4,447.5 PMOS
XM$1010 VDD \$I2122 \$I2123 VDD PMOS L=1u W=3.4u AS=6.46p AD=10.88p PS=7.2u
+ PD=13.2u
* device instance $1011 m0 *1 280.8,467.9 NMOS
XM$1011 BL12 WL15 \$I2122 VSS NMOS L=1u W=3.4u AS=10.88p AD=6.46p PS=13.2u
+ PD=7.2u
* device instance $1012 m0 *1 285.6,467.9 NMOS
XM$1012 \$I2122 \$I2123 VSS VSS NMOS L=1u W=3.4u AS=6.46p AD=6.46p PS=7.2u
+ PD=7.2u
* device instance $1013 m0 *1 290.4,467.9 NMOS
XM$1013 VSS \$I2122 \$I2123 VSS NMOS L=1u W=3.4u AS=6.46p AD=6.46p PS=7.2u
+ PD=7.2u
* device instance $1014 m0 *1 295.2,467.9 NMOS
XM$1014 \$I2123 WL15 BLB12 VSS NMOS L=1u W=3.4u AS=6.46p AD=10.88p PS=7.2u
+ PD=13.2u
* device instance $1015 m0 *1 285.6,269.9 PMOS
XM$1015 \$I2124 \$I2125 VDD VDD PMOS L=1u W=3.4u AS=10.88p AD=6.46p PS=13.2u
+ PD=7.2u
* device instance $1016 m0 *1 290.4,269.9 PMOS
XM$1016 VDD \$I2124 \$I2125 VDD PMOS L=1u W=3.4u AS=6.46p AD=10.88p PS=7.2u
+ PD=13.2u
* device instance $1017 m0 *1 280.8,290.3 NMOS
XM$1017 BL12 WL9 \$I2124 VSS NMOS L=1u W=3.4u AS=10.88p AD=6.46p PS=13.2u
+ PD=7.2u
* device instance $1018 m0 *1 285.6,290.3 NMOS
XM$1018 \$I2124 \$I2125 VSS VSS NMOS L=1u W=3.4u AS=6.46p AD=6.46p PS=7.2u
+ PD=7.2u
* device instance $1019 m0 *1 290.4,290.3 NMOS
XM$1019 VSS \$I2124 \$I2125 VSS NMOS L=1u W=3.4u AS=6.46p AD=6.46p PS=7.2u
+ PD=7.2u
* device instance $1020 m0 *1 295.2,290.3 NMOS
XM$1020 \$I2125 WL9 BLB12 VSS NMOS L=1u W=3.4u AS=6.46p AD=10.88p PS=7.2u
+ PD=13.2u
* device instance $1021 m0 *1 285.6,210.7 PMOS
XM$1021 \$I2126 \$I2127 VDD VDD PMOS L=1u W=3.4u AS=10.88p AD=6.46p PS=13.2u
+ PD=7.2u
* device instance $1022 m0 *1 290.4,210.7 PMOS
XM$1022 VDD \$I2126 \$I2127 VDD PMOS L=1u W=3.4u AS=6.46p AD=10.88p PS=7.2u
+ PD=13.2u
* device instance $1023 m0 *1 280.8,231.1 NMOS
XM$1023 BL12 WL7 \$I2126 VSS NMOS L=1u W=3.4u AS=10.88p AD=6.46p PS=13.2u
+ PD=7.2u
* device instance $1024 m0 *1 285.6,231.1 NMOS
XM$1024 \$I2126 \$I2127 VSS VSS NMOS L=1u W=3.4u AS=6.46p AD=6.46p PS=7.2u
+ PD=7.2u
* device instance $1025 m0 *1 290.4,231.1 NMOS
XM$1025 VSS \$I2126 \$I2127 VSS NMOS L=1u W=3.4u AS=6.46p AD=6.46p PS=7.2u
+ PD=7.2u
* device instance $1026 m0 *1 295.2,231.1 NMOS
XM$1026 \$I2127 WL7 BLB12 VSS NMOS L=1u W=3.4u AS=6.46p AD=10.88p PS=7.2u
+ PD=13.2u
* device instance $1027 m0 *1 285.6,151.5 PMOS
XM$1027 \$I2128 \$I2129 VDD VDD PMOS L=1u W=3.4u AS=10.88p AD=6.46p PS=13.2u
+ PD=7.2u
* device instance $1028 m0 *1 290.4,151.5 PMOS
XM$1028 VDD \$I2128 \$I2129 VDD PMOS L=1u W=3.4u AS=6.46p AD=10.88p PS=7.2u
+ PD=13.2u
* device instance $1029 m0 *1 280.8,171.9 NMOS
XM$1029 BL12 WL5 \$I2128 VSS NMOS L=1u W=3.4u AS=10.88p AD=6.46p PS=13.2u
+ PD=7.2u
* device instance $1030 m0 *1 285.6,171.9 NMOS
XM$1030 \$I2128 \$I2129 VSS VSS NMOS L=1u W=3.4u AS=6.46p AD=6.46p PS=7.2u
+ PD=7.2u
* device instance $1031 m0 *1 290.4,171.9 NMOS
XM$1031 VSS \$I2128 \$I2129 VSS NMOS L=1u W=3.4u AS=6.46p AD=6.46p PS=7.2u
+ PD=7.2u
* device instance $1032 m0 *1 295.2,171.9 NMOS
XM$1032 \$I2129 WL5 BLB12 VSS NMOS L=1u W=3.4u AS=6.46p AD=10.88p PS=7.2u
+ PD=13.2u
* device instance $1033 m0 *1 285.6,33.1 PMOS
XM$1033 \$I2130 \$I2131 VDD VDD PMOS L=1u W=3.4u AS=10.88p AD=6.46p PS=13.2u
+ PD=7.2u
* device instance $1034 m0 *1 290.4,33.1 PMOS
XM$1034 VDD \$I2130 \$I2131 VDD PMOS L=1u W=3.4u AS=6.46p AD=10.88p PS=7.2u
+ PD=13.2u
* device instance $1035 m0 *1 280.8,53.5 NMOS
XM$1035 BL12 WL1 \$I2130 VSS NMOS L=1u W=3.4u AS=10.88p AD=6.46p PS=13.2u
+ PD=7.2u
* device instance $1036 m0 *1 285.6,53.5 NMOS
XM$1036 \$I2130 \$I2131 VSS VSS NMOS L=1u W=3.4u AS=6.46p AD=6.46p PS=7.2u
+ PD=7.2u
* device instance $1037 m0 *1 290.4,53.5 NMOS
XM$1037 VSS \$I2130 \$I2131 VSS NMOS L=1u W=3.4u AS=6.46p AD=6.46p PS=7.2u
+ PD=7.2u
* device instance $1038 m0 *1 295.2,53.5 NMOS
XM$1038 \$I2131 WL1 BLB12 VSS NMOS L=1u W=3.4u AS=6.46p AD=10.88p PS=7.2u
+ PD=13.2u
* device instance $1039 m0 *1 285.6,92.3 PMOS
XM$1039 \$I2132 \$I2133 VDD VDD PMOS L=1u W=3.4u AS=10.88p AD=6.46p PS=13.2u
+ PD=7.2u
* device instance $1040 m0 *1 290.4,92.3 PMOS
XM$1040 VDD \$I2132 \$I2133 VDD PMOS L=1u W=3.4u AS=6.46p AD=10.88p PS=7.2u
+ PD=13.2u
* device instance $1041 m0 *1 280.8,112.7 NMOS
XM$1041 BL12 WL3 \$I2132 VSS NMOS L=1u W=3.4u AS=10.88p AD=6.46p PS=13.2u
+ PD=7.2u
* device instance $1042 m0 *1 285.6,112.7 NMOS
XM$1042 \$I2132 \$I2133 VSS VSS NMOS L=1u W=3.4u AS=6.46p AD=6.46p PS=7.2u
+ PD=7.2u
* device instance $1043 m0 *1 290.4,112.7 NMOS
XM$1043 VSS \$I2132 \$I2133 VSS NMOS L=1u W=3.4u AS=6.46p AD=6.46p PS=7.2u
+ PD=7.2u
* device instance $1044 m0 *1 295.2,112.7 NMOS
XM$1044 \$I2133 WL3 BLB12 VSS NMOS L=1u W=3.4u AS=6.46p AD=10.88p PS=7.2u
+ PD=13.2u
* device instance $1045 r0 *1 285.6,322.1 PMOS
XM$1045 \$I2134 \$I2135 VDD VDD PMOS L=1u W=3.4u AS=10.88p AD=6.46p PS=13.2u
+ PD=7.2u
* device instance $1046 r0 *1 290.4,322.1 PMOS
XM$1046 VDD \$I2134 \$I2135 VDD PMOS L=1u W=3.4u AS=6.46p AD=10.88p PS=7.2u
+ PD=13.2u
* device instance $1047 r0 *1 280.8,301.7 NMOS
XM$1047 BL12 WL10 \$I2134 VSS NMOS L=1u W=3.4u AS=10.88p AD=6.46p PS=13.2u
+ PD=7.2u
* device instance $1048 r0 *1 285.6,301.7 NMOS
XM$1048 \$I2134 \$I2135 VSS VSS NMOS L=1u W=3.4u AS=6.46p AD=6.46p PS=7.2u
+ PD=7.2u
* device instance $1049 r0 *1 290.4,301.7 NMOS
XM$1049 VSS \$I2134 \$I2135 VSS NMOS L=1u W=3.4u AS=6.46p AD=6.46p PS=7.2u
+ PD=7.2u
* device instance $1050 r0 *1 295.2,301.7 NMOS
XM$1050 \$I2135 WL10 BLB12 VSS NMOS L=1u W=3.4u AS=6.46p AD=10.88p PS=7.2u
+ PD=13.2u
* device instance $1051 r0 *1 285.6,440.5 PMOS
XM$1051 \$I2136 \$I2137 VDD VDD PMOS L=1u W=3.4u AS=10.88p AD=6.46p PS=13.2u
+ PD=7.2u
* device instance $1052 r0 *1 290.4,440.5 PMOS
XM$1052 VDD \$I2136 \$I2137 VDD PMOS L=1u W=3.4u AS=6.46p AD=10.88p PS=7.2u
+ PD=13.2u
* device instance $1053 r0 *1 280.8,420.1 NMOS
XM$1053 BL12 WL14 \$I2136 VSS NMOS L=1u W=3.4u AS=10.88p AD=6.46p PS=13.2u
+ PD=7.2u
* device instance $1054 r0 *1 285.6,420.1 NMOS
XM$1054 \$I2136 \$I2137 VSS VSS NMOS L=1u W=3.4u AS=6.46p AD=6.46p PS=7.2u
+ PD=7.2u
* device instance $1055 r0 *1 290.4,420.1 NMOS
XM$1055 VSS \$I2136 \$I2137 VSS NMOS L=1u W=3.4u AS=6.46p AD=6.46p PS=7.2u
+ PD=7.2u
* device instance $1056 r0 *1 295.2,420.1 NMOS
XM$1056 \$I2137 WL14 BLB12 VSS NMOS L=1u W=3.4u AS=6.46p AD=10.88p PS=7.2u
+ PD=13.2u
* device instance $1057 r0 *1 285.6,262.9 PMOS
XM$1057 \$I2138 \$I2139 VDD VDD PMOS L=1u W=3.4u AS=10.88p AD=6.46p PS=13.2u
+ PD=7.2u
* device instance $1058 r0 *1 290.4,262.9 PMOS
XM$1058 VDD \$I2138 \$I2139 VDD PMOS L=1u W=3.4u AS=6.46p AD=10.88p PS=7.2u
+ PD=13.2u
* device instance $1059 r0 *1 280.8,242.5 NMOS
XM$1059 BL12 WL8 \$I2138 VSS NMOS L=1u W=3.4u AS=10.88p AD=6.46p PS=13.2u
+ PD=7.2u
* device instance $1060 r0 *1 285.6,242.5 NMOS
XM$1060 \$I2138 \$I2139 VSS VSS NMOS L=1u W=3.4u AS=6.46p AD=6.46p PS=7.2u
+ PD=7.2u
* device instance $1061 r0 *1 290.4,242.5 NMOS
XM$1061 VSS \$I2138 \$I2139 VSS NMOS L=1u W=3.4u AS=6.46p AD=6.46p PS=7.2u
+ PD=7.2u
* device instance $1062 r0 *1 295.2,242.5 NMOS
XM$1062 \$I2139 WL8 BLB12 VSS NMOS L=1u W=3.4u AS=6.46p AD=10.88p PS=7.2u
+ PD=13.2u
* device instance $1063 r0 *1 285.6,203.7 PMOS
XM$1063 \$I2140 \$I2141 VDD VDD PMOS L=1u W=3.4u AS=10.88p AD=6.46p PS=13.2u
+ PD=7.2u
* device instance $1064 r0 *1 290.4,203.7 PMOS
XM$1064 VDD \$I2140 \$I2141 VDD PMOS L=1u W=3.4u AS=6.46p AD=10.88p PS=7.2u
+ PD=13.2u
* device instance $1065 r0 *1 280.8,183.3 NMOS
XM$1065 BL12 WL6 \$I2140 VSS NMOS L=1u W=3.4u AS=10.88p AD=6.46p PS=13.2u
+ PD=7.2u
* device instance $1066 r0 *1 285.6,183.3 NMOS
XM$1066 \$I2140 \$I2141 VSS VSS NMOS L=1u W=3.4u AS=6.46p AD=6.46p PS=7.2u
+ PD=7.2u
* device instance $1067 r0 *1 290.4,183.3 NMOS
XM$1067 VSS \$I2140 \$I2141 VSS NMOS L=1u W=3.4u AS=6.46p AD=6.46p PS=7.2u
+ PD=7.2u
* device instance $1068 r0 *1 295.2,183.3 NMOS
XM$1068 \$I2141 WL6 BLB12 VSS NMOS L=1u W=3.4u AS=6.46p AD=10.88p PS=7.2u
+ PD=13.2u
* device instance $1069 r0 *1 285.6,381.3 PMOS
XM$1069 \$I2142 \$I2143 VDD VDD PMOS L=1u W=3.4u AS=10.88p AD=6.46p PS=13.2u
+ PD=7.2u
* device instance $1070 r0 *1 290.4,381.3 PMOS
XM$1070 VDD \$I2142 \$I2143 VDD PMOS L=1u W=3.4u AS=6.46p AD=10.88p PS=7.2u
+ PD=13.2u
* device instance $1071 r0 *1 280.8,360.9 NMOS
XM$1071 BL12 WL12 \$I2142 VSS NMOS L=1u W=3.4u AS=10.88p AD=6.46p PS=13.2u
+ PD=7.2u
* device instance $1072 r0 *1 285.6,360.9 NMOS
XM$1072 \$I2142 \$I2143 VSS VSS NMOS L=1u W=3.4u AS=6.46p AD=6.46p PS=7.2u
+ PD=7.2u
* device instance $1073 r0 *1 290.4,360.9 NMOS
XM$1073 VSS \$I2142 \$I2143 VSS NMOS L=1u W=3.4u AS=6.46p AD=6.46p PS=7.2u
+ PD=7.2u
* device instance $1074 r0 *1 295.2,360.9 NMOS
XM$1074 \$I2143 WL12 BLB12 VSS NMOS L=1u W=3.4u AS=6.46p AD=10.88p PS=7.2u
+ PD=13.2u
* device instance $1075 r0 *1 285.6,144.5 PMOS
XM$1075 \$I2144 \$I2145 VDD VDD PMOS L=1u W=3.4u AS=10.88p AD=6.46p PS=13.2u
+ PD=7.2u
* device instance $1076 r0 *1 290.4,144.5 PMOS
XM$1076 VDD \$I2144 \$I2145 VDD PMOS L=1u W=3.4u AS=6.46p AD=10.88p PS=7.2u
+ PD=13.2u
* device instance $1077 r0 *1 280.8,124.1 NMOS
XM$1077 BL12 WL4 \$I2144 VSS NMOS L=1u W=3.4u AS=10.88p AD=6.46p PS=13.2u
+ PD=7.2u
* device instance $1078 r0 *1 285.6,124.1 NMOS
XM$1078 \$I2144 \$I2145 VSS VSS NMOS L=1u W=3.4u AS=6.46p AD=6.46p PS=7.2u
+ PD=7.2u
* device instance $1079 r0 *1 290.4,124.1 NMOS
XM$1079 VSS \$I2144 \$I2145 VSS NMOS L=1u W=3.4u AS=6.46p AD=6.46p PS=7.2u
+ PD=7.2u
* device instance $1080 r0 *1 295.2,124.1 NMOS
XM$1080 \$I2145 WL4 BLB12 VSS NMOS L=1u W=3.4u AS=6.46p AD=10.88p PS=7.2u
+ PD=13.2u
* device instance $1081 r0 *1 285.6,85.3 PMOS
XM$1081 \$I2146 \$I2147 VDD VDD PMOS L=1u W=3.4u AS=10.88p AD=6.46p PS=13.2u
+ PD=7.2u
* device instance $1082 r0 *1 290.4,85.3 PMOS
XM$1082 VDD \$I2146 \$I2147 VDD PMOS L=1u W=3.4u AS=6.46p AD=10.88p PS=7.2u
+ PD=13.2u
* device instance $1083 r0 *1 280.8,64.9 NMOS
XM$1083 BL12 WL2 \$I2146 VSS NMOS L=1u W=3.4u AS=10.88p AD=6.46p PS=13.2u
+ PD=7.2u
* device instance $1084 r0 *1 285.6,64.9 NMOS
XM$1084 \$I2146 \$I2147 VSS VSS NMOS L=1u W=3.4u AS=6.46p AD=6.46p PS=7.2u
+ PD=7.2u
* device instance $1085 r0 *1 290.4,64.9 NMOS
XM$1085 VSS \$I2146 \$I2147 VSS NMOS L=1u W=3.4u AS=6.46p AD=6.46p PS=7.2u
+ PD=7.2u
* device instance $1086 r0 *1 295.2,64.9 NMOS
XM$1086 \$I2147 WL2 BLB12 VSS NMOS L=1u W=3.4u AS=6.46p AD=10.88p PS=7.2u
+ PD=13.2u
* device instance $1087 m0 *1 262.4,388.3 PMOS
XM$1087 \$I2148 \$I2149 VDD VDD PMOS L=1u W=3.4u AS=10.88p AD=6.46p PS=13.2u
+ PD=7.2u
* device instance $1088 m0 *1 267.2,388.3 PMOS
XM$1088 VDD \$I2148 \$I2149 VDD PMOS L=1u W=3.4u AS=6.46p AD=10.88p PS=7.2u
+ PD=13.2u
* device instance $1089 m0 *1 257.6,408.7 NMOS
XM$1089 BL11 WL13 \$I2148 VSS NMOS L=1u W=3.4u AS=10.88p AD=6.46p PS=13.2u
+ PD=7.2u
* device instance $1090 m0 *1 262.4,408.7 NMOS
XM$1090 \$I2148 \$I2149 VSS VSS NMOS L=1u W=3.4u AS=6.46p AD=6.46p PS=7.2u
+ PD=7.2u
* device instance $1091 m0 *1 267.2,408.7 NMOS
XM$1091 VSS \$I2148 \$I2149 VSS NMOS L=1u W=3.4u AS=6.46p AD=6.46p PS=7.2u
+ PD=7.2u
* device instance $1092 m0 *1 272,408.7 NMOS
XM$1092 \$I2149 WL13 BLB11 VSS NMOS L=1u W=3.4u AS=6.46p AD=10.88p PS=7.2u
+ PD=13.2u
* device instance $1093 m0 *1 262.4,329.1 PMOS
XM$1093 \$I2150 \$I2151 VDD VDD PMOS L=1u W=3.4u AS=10.88p AD=6.46p PS=13.2u
+ PD=7.2u
* device instance $1094 m0 *1 267.2,329.1 PMOS
XM$1094 VDD \$I2150 \$I2151 VDD PMOS L=1u W=3.4u AS=6.46p AD=10.88p PS=7.2u
+ PD=13.2u
* device instance $1095 m0 *1 257.6,349.5 NMOS
XM$1095 BL11 WL11 \$I2150 VSS NMOS L=1u W=3.4u AS=10.88p AD=6.46p PS=13.2u
+ PD=7.2u
* device instance $1096 m0 *1 262.4,349.5 NMOS
XM$1096 \$I2150 \$I2151 VSS VSS NMOS L=1u W=3.4u AS=6.46p AD=6.46p PS=7.2u
+ PD=7.2u
* device instance $1097 m0 *1 267.2,349.5 NMOS
XM$1097 VSS \$I2150 \$I2151 VSS NMOS L=1u W=3.4u AS=6.46p AD=6.46p PS=7.2u
+ PD=7.2u
* device instance $1098 m0 *1 272,349.5 NMOS
XM$1098 \$I2151 WL11 BLB11 VSS NMOS L=1u W=3.4u AS=6.46p AD=10.88p PS=7.2u
+ PD=13.2u
* device instance $1099 m0 *1 262.4,447.5 PMOS
XM$1099 \$I2152 \$I2153 VDD VDD PMOS L=1u W=3.4u AS=10.88p AD=6.46p PS=13.2u
+ PD=7.2u
* device instance $1100 m0 *1 267.2,447.5 PMOS
XM$1100 VDD \$I2152 \$I2153 VDD PMOS L=1u W=3.4u AS=6.46p AD=10.88p PS=7.2u
+ PD=13.2u
* device instance $1101 m0 *1 257.6,467.9 NMOS
XM$1101 BL11 WL15 \$I2152 VSS NMOS L=1u W=3.4u AS=10.88p AD=6.46p PS=13.2u
+ PD=7.2u
* device instance $1102 m0 *1 262.4,467.9 NMOS
XM$1102 \$I2152 \$I2153 VSS VSS NMOS L=1u W=3.4u AS=6.46p AD=6.46p PS=7.2u
+ PD=7.2u
* device instance $1103 m0 *1 267.2,467.9 NMOS
XM$1103 VSS \$I2152 \$I2153 VSS NMOS L=1u W=3.4u AS=6.46p AD=6.46p PS=7.2u
+ PD=7.2u
* device instance $1104 m0 *1 272,467.9 NMOS
XM$1104 \$I2153 WL15 BLB11 VSS NMOS L=1u W=3.4u AS=6.46p AD=10.88p PS=7.2u
+ PD=13.2u
* device instance $1105 m0 *1 262.4,269.9 PMOS
XM$1105 \$I2154 \$I2155 VDD VDD PMOS L=1u W=3.4u AS=10.88p AD=6.46p PS=13.2u
+ PD=7.2u
* device instance $1106 m0 *1 267.2,269.9 PMOS
XM$1106 VDD \$I2154 \$I2155 VDD PMOS L=1u W=3.4u AS=6.46p AD=10.88p PS=7.2u
+ PD=13.2u
* device instance $1107 m0 *1 257.6,290.3 NMOS
XM$1107 BL11 WL9 \$I2154 VSS NMOS L=1u W=3.4u AS=10.88p AD=6.46p PS=13.2u
+ PD=7.2u
* device instance $1108 m0 *1 262.4,290.3 NMOS
XM$1108 \$I2154 \$I2155 VSS VSS NMOS L=1u W=3.4u AS=6.46p AD=6.46p PS=7.2u
+ PD=7.2u
* device instance $1109 m0 *1 267.2,290.3 NMOS
XM$1109 VSS \$I2154 \$I2155 VSS NMOS L=1u W=3.4u AS=6.46p AD=6.46p PS=7.2u
+ PD=7.2u
* device instance $1110 m0 *1 272,290.3 NMOS
XM$1110 \$I2155 WL9 BLB11 VSS NMOS L=1u W=3.4u AS=6.46p AD=10.88p PS=7.2u
+ PD=13.2u
* device instance $1111 m0 *1 262.4,210.7 PMOS
XM$1111 \$I2156 \$I2157 VDD VDD PMOS L=1u W=3.4u AS=10.88p AD=6.46p PS=13.2u
+ PD=7.2u
* device instance $1112 m0 *1 267.2,210.7 PMOS
XM$1112 VDD \$I2156 \$I2157 VDD PMOS L=1u W=3.4u AS=6.46p AD=10.88p PS=7.2u
+ PD=13.2u
* device instance $1113 m0 *1 257.6,231.1 NMOS
XM$1113 BL11 WL7 \$I2156 VSS NMOS L=1u W=3.4u AS=10.88p AD=6.46p PS=13.2u
+ PD=7.2u
* device instance $1114 m0 *1 262.4,231.1 NMOS
XM$1114 \$I2156 \$I2157 VSS VSS NMOS L=1u W=3.4u AS=6.46p AD=6.46p PS=7.2u
+ PD=7.2u
* device instance $1115 m0 *1 267.2,231.1 NMOS
XM$1115 VSS \$I2156 \$I2157 VSS NMOS L=1u W=3.4u AS=6.46p AD=6.46p PS=7.2u
+ PD=7.2u
* device instance $1116 m0 *1 272,231.1 NMOS
XM$1116 \$I2157 WL7 BLB11 VSS NMOS L=1u W=3.4u AS=6.46p AD=10.88p PS=7.2u
+ PD=13.2u
* device instance $1117 m0 *1 262.4,151.5 PMOS
XM$1117 \$I2158 \$I2159 VDD VDD PMOS L=1u W=3.4u AS=10.88p AD=6.46p PS=13.2u
+ PD=7.2u
* device instance $1118 m0 *1 267.2,151.5 PMOS
XM$1118 VDD \$I2158 \$I2159 VDD PMOS L=1u W=3.4u AS=6.46p AD=10.88p PS=7.2u
+ PD=13.2u
* device instance $1119 m0 *1 257.6,171.9 NMOS
XM$1119 BL11 WL5 \$I2158 VSS NMOS L=1u W=3.4u AS=10.88p AD=6.46p PS=13.2u
+ PD=7.2u
* device instance $1120 m0 *1 262.4,171.9 NMOS
XM$1120 \$I2158 \$I2159 VSS VSS NMOS L=1u W=3.4u AS=6.46p AD=6.46p PS=7.2u
+ PD=7.2u
* device instance $1121 m0 *1 267.2,171.9 NMOS
XM$1121 VSS \$I2158 \$I2159 VSS NMOS L=1u W=3.4u AS=6.46p AD=6.46p PS=7.2u
+ PD=7.2u
* device instance $1122 m0 *1 272,171.9 NMOS
XM$1122 \$I2159 WL5 BLB11 VSS NMOS L=1u W=3.4u AS=6.46p AD=10.88p PS=7.2u
+ PD=13.2u
* device instance $1123 m0 *1 262.4,33.1 PMOS
XM$1123 \$I2160 \$I2161 VDD VDD PMOS L=1u W=3.4u AS=10.88p AD=6.46p PS=13.2u
+ PD=7.2u
* device instance $1124 m0 *1 267.2,33.1 PMOS
XM$1124 VDD \$I2160 \$I2161 VDD PMOS L=1u W=3.4u AS=6.46p AD=10.88p PS=7.2u
+ PD=13.2u
* device instance $1125 m0 *1 257.6,53.5 NMOS
XM$1125 BL11 WL1 \$I2160 VSS NMOS L=1u W=3.4u AS=10.88p AD=6.46p PS=13.2u
+ PD=7.2u
* device instance $1126 m0 *1 262.4,53.5 NMOS
XM$1126 \$I2160 \$I2161 VSS VSS NMOS L=1u W=3.4u AS=6.46p AD=6.46p PS=7.2u
+ PD=7.2u
* device instance $1127 m0 *1 267.2,53.5 NMOS
XM$1127 VSS \$I2160 \$I2161 VSS NMOS L=1u W=3.4u AS=6.46p AD=6.46p PS=7.2u
+ PD=7.2u
* device instance $1128 m0 *1 272,53.5 NMOS
XM$1128 \$I2161 WL1 BLB11 VSS NMOS L=1u W=3.4u AS=6.46p AD=10.88p PS=7.2u
+ PD=13.2u
* device instance $1129 m0 *1 262.4,92.3 PMOS
XM$1129 \$I2162 \$I2163 VDD VDD PMOS L=1u W=3.4u AS=10.88p AD=6.46p PS=13.2u
+ PD=7.2u
* device instance $1130 m0 *1 267.2,92.3 PMOS
XM$1130 VDD \$I2162 \$I2163 VDD PMOS L=1u W=3.4u AS=6.46p AD=10.88p PS=7.2u
+ PD=13.2u
* device instance $1131 m0 *1 257.6,112.7 NMOS
XM$1131 BL11 WL3 \$I2162 VSS NMOS L=1u W=3.4u AS=10.88p AD=6.46p PS=13.2u
+ PD=7.2u
* device instance $1132 m0 *1 262.4,112.7 NMOS
XM$1132 \$I2162 \$I2163 VSS VSS NMOS L=1u W=3.4u AS=6.46p AD=6.46p PS=7.2u
+ PD=7.2u
* device instance $1133 m0 *1 267.2,112.7 NMOS
XM$1133 VSS \$I2162 \$I2163 VSS NMOS L=1u W=3.4u AS=6.46p AD=6.46p PS=7.2u
+ PD=7.2u
* device instance $1134 m0 *1 272,112.7 NMOS
XM$1134 \$I2163 WL3 BLB11 VSS NMOS L=1u W=3.4u AS=6.46p AD=10.88p PS=7.2u
+ PD=13.2u
* device instance $1135 r0 *1 262.4,440.5 PMOS
XM$1135 \$I2164 \$I2165 VDD VDD PMOS L=1u W=3.4u AS=10.88p AD=6.46p PS=13.2u
+ PD=7.2u
* device instance $1136 r0 *1 267.2,440.5 PMOS
XM$1136 VDD \$I2164 \$I2165 VDD PMOS L=1u W=3.4u AS=6.46p AD=10.88p PS=7.2u
+ PD=13.2u
* device instance $1137 r0 *1 257.6,420.1 NMOS
XM$1137 BL11 WL14 \$I2164 VSS NMOS L=1u W=3.4u AS=10.88p AD=6.46p PS=13.2u
+ PD=7.2u
* device instance $1138 r0 *1 262.4,420.1 NMOS
XM$1138 \$I2164 \$I2165 VSS VSS NMOS L=1u W=3.4u AS=6.46p AD=6.46p PS=7.2u
+ PD=7.2u
* device instance $1139 r0 *1 267.2,420.1 NMOS
XM$1139 VSS \$I2164 \$I2165 VSS NMOS L=1u W=3.4u AS=6.46p AD=6.46p PS=7.2u
+ PD=7.2u
* device instance $1140 r0 *1 272,420.1 NMOS
XM$1140 \$I2165 WL14 BLB11 VSS NMOS L=1u W=3.4u AS=6.46p AD=10.88p PS=7.2u
+ PD=13.2u
* device instance $1141 r0 *1 262.4,262.9 PMOS
XM$1141 \$I2166 \$I2167 VDD VDD PMOS L=1u W=3.4u AS=10.88p AD=6.46p PS=13.2u
+ PD=7.2u
* device instance $1142 r0 *1 267.2,262.9 PMOS
XM$1142 VDD \$I2166 \$I2167 VDD PMOS L=1u W=3.4u AS=6.46p AD=10.88p PS=7.2u
+ PD=13.2u
* device instance $1143 r0 *1 257.6,242.5 NMOS
XM$1143 BL11 WL8 \$I2166 VSS NMOS L=1u W=3.4u AS=10.88p AD=6.46p PS=13.2u
+ PD=7.2u
* device instance $1144 r0 *1 262.4,242.5 NMOS
XM$1144 \$I2166 \$I2167 VSS VSS NMOS L=1u W=3.4u AS=6.46p AD=6.46p PS=7.2u
+ PD=7.2u
* device instance $1145 r0 *1 267.2,242.5 NMOS
XM$1145 VSS \$I2166 \$I2167 VSS NMOS L=1u W=3.4u AS=6.46p AD=6.46p PS=7.2u
+ PD=7.2u
* device instance $1146 r0 *1 272,242.5 NMOS
XM$1146 \$I2167 WL8 BLB11 VSS NMOS L=1u W=3.4u AS=6.46p AD=10.88p PS=7.2u
+ PD=13.2u
* device instance $1147 r0 *1 262.4,203.7 PMOS
XM$1147 \$I2168 \$I2169 VDD VDD PMOS L=1u W=3.4u AS=10.88p AD=6.46p PS=13.2u
+ PD=7.2u
* device instance $1148 r0 *1 267.2,203.7 PMOS
XM$1148 VDD \$I2168 \$I2169 VDD PMOS L=1u W=3.4u AS=6.46p AD=10.88p PS=7.2u
+ PD=13.2u
* device instance $1149 r0 *1 257.6,183.3 NMOS
XM$1149 BL11 WL6 \$I2168 VSS NMOS L=1u W=3.4u AS=10.88p AD=6.46p PS=13.2u
+ PD=7.2u
* device instance $1150 r0 *1 262.4,183.3 NMOS
XM$1150 \$I2168 \$I2169 VSS VSS NMOS L=1u W=3.4u AS=6.46p AD=6.46p PS=7.2u
+ PD=7.2u
* device instance $1151 r0 *1 267.2,183.3 NMOS
XM$1151 VSS \$I2168 \$I2169 VSS NMOS L=1u W=3.4u AS=6.46p AD=6.46p PS=7.2u
+ PD=7.2u
* device instance $1152 r0 *1 272,183.3 NMOS
XM$1152 \$I2169 WL6 BLB11 VSS NMOS L=1u W=3.4u AS=6.46p AD=10.88p PS=7.2u
+ PD=13.2u
* device instance $1153 r0 *1 262.4,322.1 PMOS
XM$1153 \$I2170 \$I2171 VDD VDD PMOS L=1u W=3.4u AS=10.88p AD=6.46p PS=13.2u
+ PD=7.2u
* device instance $1154 r0 *1 267.2,322.1 PMOS
XM$1154 VDD \$I2170 \$I2171 VDD PMOS L=1u W=3.4u AS=6.46p AD=10.88p PS=7.2u
+ PD=13.2u
* device instance $1155 r0 *1 257.6,301.7 NMOS
XM$1155 BL11 WL10 \$I2170 VSS NMOS L=1u W=3.4u AS=10.88p AD=6.46p PS=13.2u
+ PD=7.2u
* device instance $1156 r0 *1 262.4,301.7 NMOS
XM$1156 \$I2170 \$I2171 VSS VSS NMOS L=1u W=3.4u AS=6.46p AD=6.46p PS=7.2u
+ PD=7.2u
* device instance $1157 r0 *1 267.2,301.7 NMOS
XM$1157 VSS \$I2170 \$I2171 VSS NMOS L=1u W=3.4u AS=6.46p AD=6.46p PS=7.2u
+ PD=7.2u
* device instance $1158 r0 *1 272,301.7 NMOS
XM$1158 \$I2171 WL10 BLB11 VSS NMOS L=1u W=3.4u AS=6.46p AD=10.88p PS=7.2u
+ PD=13.2u
* device instance $1159 r0 *1 262.4,85.3 PMOS
XM$1159 \$I2172 \$I2173 VDD VDD PMOS L=1u W=3.4u AS=10.88p AD=6.46p PS=13.2u
+ PD=7.2u
* device instance $1160 r0 *1 267.2,85.3 PMOS
XM$1160 VDD \$I2172 \$I2173 VDD PMOS L=1u W=3.4u AS=6.46p AD=10.88p PS=7.2u
+ PD=13.2u
* device instance $1161 r0 *1 257.6,64.9 NMOS
XM$1161 BL11 WL2 \$I2172 VSS NMOS L=1u W=3.4u AS=10.88p AD=6.46p PS=13.2u
+ PD=7.2u
* device instance $1162 r0 *1 262.4,64.9 NMOS
XM$1162 \$I2172 \$I2173 VSS VSS NMOS L=1u W=3.4u AS=6.46p AD=6.46p PS=7.2u
+ PD=7.2u
* device instance $1163 r0 *1 267.2,64.9 NMOS
XM$1163 VSS \$I2172 \$I2173 VSS NMOS L=1u W=3.4u AS=6.46p AD=6.46p PS=7.2u
+ PD=7.2u
* device instance $1164 r0 *1 272,64.9 NMOS
XM$1164 \$I2173 WL2 BLB11 VSS NMOS L=1u W=3.4u AS=6.46p AD=10.88p PS=7.2u
+ PD=13.2u
* device instance $1165 r0 *1 262.4,381.3 PMOS
XM$1165 \$I2174 \$I2175 VDD VDD PMOS L=1u W=3.4u AS=10.88p AD=6.46p PS=13.2u
+ PD=7.2u
* device instance $1166 r0 *1 267.2,381.3 PMOS
XM$1166 VDD \$I2174 \$I2175 VDD PMOS L=1u W=3.4u AS=6.46p AD=10.88p PS=7.2u
+ PD=13.2u
* device instance $1167 r0 *1 257.6,360.9 NMOS
XM$1167 BL11 WL12 \$I2174 VSS NMOS L=1u W=3.4u AS=10.88p AD=6.46p PS=13.2u
+ PD=7.2u
* device instance $1168 r0 *1 262.4,360.9 NMOS
XM$1168 \$I2174 \$I2175 VSS VSS NMOS L=1u W=3.4u AS=6.46p AD=6.46p PS=7.2u
+ PD=7.2u
* device instance $1169 r0 *1 267.2,360.9 NMOS
XM$1169 VSS \$I2174 \$I2175 VSS NMOS L=1u W=3.4u AS=6.46p AD=6.46p PS=7.2u
+ PD=7.2u
* device instance $1170 r0 *1 272,360.9 NMOS
XM$1170 \$I2175 WL12 BLB11 VSS NMOS L=1u W=3.4u AS=6.46p AD=10.88p PS=7.2u
+ PD=13.2u
* device instance $1171 r0 *1 262.4,144.5 PMOS
XM$1171 \$I2176 \$I2177 VDD VDD PMOS L=1u W=3.4u AS=10.88p AD=6.46p PS=13.2u
+ PD=7.2u
* device instance $1172 r0 *1 267.2,144.5 PMOS
XM$1172 VDD \$I2176 \$I2177 VDD PMOS L=1u W=3.4u AS=6.46p AD=10.88p PS=7.2u
+ PD=13.2u
* device instance $1173 r0 *1 257.6,124.1 NMOS
XM$1173 BL11 WL4 \$I2176 VSS NMOS L=1u W=3.4u AS=10.88p AD=6.46p PS=13.2u
+ PD=7.2u
* device instance $1174 r0 *1 262.4,124.1 NMOS
XM$1174 \$I2176 \$I2177 VSS VSS NMOS L=1u W=3.4u AS=6.46p AD=6.46p PS=7.2u
+ PD=7.2u
* device instance $1175 r0 *1 267.2,124.1 NMOS
XM$1175 VSS \$I2176 \$I2177 VSS NMOS L=1u W=3.4u AS=6.46p AD=6.46p PS=7.2u
+ PD=7.2u
* device instance $1176 r0 *1 272,124.1 NMOS
XM$1176 \$I2177 WL4 BLB11 VSS NMOS L=1u W=3.4u AS=6.46p AD=10.88p PS=7.2u
+ PD=13.2u
* device instance $1177 m0 *1 239.2,388.3 PMOS
XM$1177 \$I2178 \$I2179 VDD VDD PMOS L=1u W=3.4u AS=10.88p AD=6.46p PS=13.2u
+ PD=7.2u
* device instance $1178 m0 *1 244,388.3 PMOS
XM$1178 VDD \$I2178 \$I2179 VDD PMOS L=1u W=3.4u AS=6.46p AD=10.88p PS=7.2u
+ PD=13.2u
* device instance $1179 m0 *1 234.4,408.7 NMOS
XM$1179 BL10 WL13 \$I2178 VSS NMOS L=1u W=3.4u AS=10.88p AD=6.46p PS=13.2u
+ PD=7.2u
* device instance $1180 m0 *1 239.2,408.7 NMOS
XM$1180 \$I2178 \$I2179 VSS VSS NMOS L=1u W=3.4u AS=6.46p AD=6.46p PS=7.2u
+ PD=7.2u
* device instance $1181 m0 *1 244,408.7 NMOS
XM$1181 VSS \$I2178 \$I2179 VSS NMOS L=1u W=3.4u AS=6.46p AD=6.46p PS=7.2u
+ PD=7.2u
* device instance $1182 m0 *1 248.8,408.7 NMOS
XM$1182 \$I2179 WL13 BLB10 VSS NMOS L=1u W=3.4u AS=6.46p AD=10.88p PS=7.2u
+ PD=13.2u
* device instance $1183 m0 *1 239.2,329.1 PMOS
XM$1183 \$I2180 \$I2181 VDD VDD PMOS L=1u W=3.4u AS=10.88p AD=6.46p PS=13.2u
+ PD=7.2u
* device instance $1184 m0 *1 244,329.1 PMOS
XM$1184 VDD \$I2180 \$I2181 VDD PMOS L=1u W=3.4u AS=6.46p AD=10.88p PS=7.2u
+ PD=13.2u
* device instance $1185 m0 *1 234.4,349.5 NMOS
XM$1185 BL10 WL11 \$I2180 VSS NMOS L=1u W=3.4u AS=10.88p AD=6.46p PS=13.2u
+ PD=7.2u
* device instance $1186 m0 *1 239.2,349.5 NMOS
XM$1186 \$I2180 \$I2181 VSS VSS NMOS L=1u W=3.4u AS=6.46p AD=6.46p PS=7.2u
+ PD=7.2u
* device instance $1187 m0 *1 244,349.5 NMOS
XM$1187 VSS \$I2180 \$I2181 VSS NMOS L=1u W=3.4u AS=6.46p AD=6.46p PS=7.2u
+ PD=7.2u
* device instance $1188 m0 *1 248.8,349.5 NMOS
XM$1188 \$I2181 WL11 BLB10 VSS NMOS L=1u W=3.4u AS=6.46p AD=10.88p PS=7.2u
+ PD=13.2u
* device instance $1189 m0 *1 239.2,447.5 PMOS
XM$1189 \$I2182 \$I2183 VDD VDD PMOS L=1u W=3.4u AS=10.88p AD=6.46p PS=13.2u
+ PD=7.2u
* device instance $1190 m0 *1 244,447.5 PMOS
XM$1190 VDD \$I2182 \$I2183 VDD PMOS L=1u W=3.4u AS=6.46p AD=10.88p PS=7.2u
+ PD=13.2u
* device instance $1191 m0 *1 234.4,467.9 NMOS
XM$1191 BL10 WL15 \$I2182 VSS NMOS L=1u W=3.4u AS=10.88p AD=6.46p PS=13.2u
+ PD=7.2u
* device instance $1192 m0 *1 239.2,467.9 NMOS
XM$1192 \$I2182 \$I2183 VSS VSS NMOS L=1u W=3.4u AS=6.46p AD=6.46p PS=7.2u
+ PD=7.2u
* device instance $1193 m0 *1 244,467.9 NMOS
XM$1193 VSS \$I2182 \$I2183 VSS NMOS L=1u W=3.4u AS=6.46p AD=6.46p PS=7.2u
+ PD=7.2u
* device instance $1194 m0 *1 248.8,467.9 NMOS
XM$1194 \$I2183 WL15 BLB10 VSS NMOS L=1u W=3.4u AS=6.46p AD=10.88p PS=7.2u
+ PD=13.2u
* device instance $1195 m0 *1 239.2,269.9 PMOS
XM$1195 \$I2184 \$I2185 VDD VDD PMOS L=1u W=3.4u AS=10.88p AD=6.46p PS=13.2u
+ PD=7.2u
* device instance $1196 m0 *1 244,269.9 PMOS
XM$1196 VDD \$I2184 \$I2185 VDD PMOS L=1u W=3.4u AS=6.46p AD=10.88p PS=7.2u
+ PD=13.2u
* device instance $1197 m0 *1 234.4,290.3 NMOS
XM$1197 BL10 WL9 \$I2184 VSS NMOS L=1u W=3.4u AS=10.88p AD=6.46p PS=13.2u
+ PD=7.2u
* device instance $1198 m0 *1 239.2,290.3 NMOS
XM$1198 \$I2184 \$I2185 VSS VSS NMOS L=1u W=3.4u AS=6.46p AD=6.46p PS=7.2u
+ PD=7.2u
* device instance $1199 m0 *1 244,290.3 NMOS
XM$1199 VSS \$I2184 \$I2185 VSS NMOS L=1u W=3.4u AS=6.46p AD=6.46p PS=7.2u
+ PD=7.2u
* device instance $1200 m0 *1 248.8,290.3 NMOS
XM$1200 \$I2185 WL9 BLB10 VSS NMOS L=1u W=3.4u AS=6.46p AD=10.88p PS=7.2u
+ PD=13.2u
* device instance $1201 m0 *1 239.2,33.1 PMOS
XM$1201 \$I2186 \$I2187 VDD VDD PMOS L=1u W=3.4u AS=10.88p AD=6.46p PS=13.2u
+ PD=7.2u
* device instance $1202 m0 *1 244,33.1 PMOS
XM$1202 VDD \$I2186 \$I2187 VDD PMOS L=1u W=3.4u AS=6.46p AD=10.88p PS=7.2u
+ PD=13.2u
* device instance $1203 m0 *1 234.4,53.5 NMOS
XM$1203 BL10 WL1 \$I2186 VSS NMOS L=1u W=3.4u AS=10.88p AD=6.46p PS=13.2u
+ PD=7.2u
* device instance $1204 m0 *1 239.2,53.5 NMOS
XM$1204 \$I2186 \$I2187 VSS VSS NMOS L=1u W=3.4u AS=6.46p AD=6.46p PS=7.2u
+ PD=7.2u
* device instance $1205 m0 *1 244,53.5 NMOS
XM$1205 VSS \$I2186 \$I2187 VSS NMOS L=1u W=3.4u AS=6.46p AD=6.46p PS=7.2u
+ PD=7.2u
* device instance $1206 m0 *1 248.8,53.5 NMOS
XM$1206 \$I2187 WL1 BLB10 VSS NMOS L=1u W=3.4u AS=6.46p AD=10.88p PS=7.2u
+ PD=13.2u
* device instance $1207 m0 *1 239.2,151.5 PMOS
XM$1207 \$I2188 \$I2189 VDD VDD PMOS L=1u W=3.4u AS=10.88p AD=6.46p PS=13.2u
+ PD=7.2u
* device instance $1208 m0 *1 244,151.5 PMOS
XM$1208 VDD \$I2188 \$I2189 VDD PMOS L=1u W=3.4u AS=6.46p AD=10.88p PS=7.2u
+ PD=13.2u
* device instance $1209 m0 *1 234.4,171.9 NMOS
XM$1209 BL10 WL5 \$I2188 VSS NMOS L=1u W=3.4u AS=10.88p AD=6.46p PS=13.2u
+ PD=7.2u
* device instance $1210 m0 *1 239.2,171.9 NMOS
XM$1210 \$I2188 \$I2189 VSS VSS NMOS L=1u W=3.4u AS=6.46p AD=6.46p PS=7.2u
+ PD=7.2u
* device instance $1211 m0 *1 244,171.9 NMOS
XM$1211 VSS \$I2188 \$I2189 VSS NMOS L=1u W=3.4u AS=6.46p AD=6.46p PS=7.2u
+ PD=7.2u
* device instance $1212 m0 *1 248.8,171.9 NMOS
XM$1212 \$I2189 WL5 BLB10 VSS NMOS L=1u W=3.4u AS=6.46p AD=10.88p PS=7.2u
+ PD=13.2u
* device instance $1213 m0 *1 239.2,210.7 PMOS
XM$1213 \$I2190 \$I2191 VDD VDD PMOS L=1u W=3.4u AS=10.88p AD=6.46p PS=13.2u
+ PD=7.2u
* device instance $1214 m0 *1 244,210.7 PMOS
XM$1214 VDD \$I2190 \$I2191 VDD PMOS L=1u W=3.4u AS=6.46p AD=10.88p PS=7.2u
+ PD=13.2u
* device instance $1215 m0 *1 234.4,231.1 NMOS
XM$1215 BL10 WL7 \$I2190 VSS NMOS L=1u W=3.4u AS=10.88p AD=6.46p PS=13.2u
+ PD=7.2u
* device instance $1216 m0 *1 239.2,231.1 NMOS
XM$1216 \$I2190 \$I2191 VSS VSS NMOS L=1u W=3.4u AS=6.46p AD=6.46p PS=7.2u
+ PD=7.2u
* device instance $1217 m0 *1 244,231.1 NMOS
XM$1217 VSS \$I2190 \$I2191 VSS NMOS L=1u W=3.4u AS=6.46p AD=6.46p PS=7.2u
+ PD=7.2u
* device instance $1218 m0 *1 248.8,231.1 NMOS
XM$1218 \$I2191 WL7 BLB10 VSS NMOS L=1u W=3.4u AS=6.46p AD=10.88p PS=7.2u
+ PD=13.2u
* device instance $1219 m0 *1 239.2,92.3 PMOS
XM$1219 \$I2192 \$I2193 VDD VDD PMOS L=1u W=3.4u AS=10.88p AD=6.46p PS=13.2u
+ PD=7.2u
* device instance $1220 m0 *1 244,92.3 PMOS
XM$1220 VDD \$I2192 \$I2193 VDD PMOS L=1u W=3.4u AS=6.46p AD=10.88p PS=7.2u
+ PD=13.2u
* device instance $1221 m0 *1 234.4,112.7 NMOS
XM$1221 BL10 WL3 \$I2192 VSS NMOS L=1u W=3.4u AS=10.88p AD=6.46p PS=13.2u
+ PD=7.2u
* device instance $1222 m0 *1 239.2,112.7 NMOS
XM$1222 \$I2192 \$I2193 VSS VSS NMOS L=1u W=3.4u AS=6.46p AD=6.46p PS=7.2u
+ PD=7.2u
* device instance $1223 m0 *1 244,112.7 NMOS
XM$1223 VSS \$I2192 \$I2193 VSS NMOS L=1u W=3.4u AS=6.46p AD=6.46p PS=7.2u
+ PD=7.2u
* device instance $1224 m0 *1 248.8,112.7 NMOS
XM$1224 \$I2193 WL3 BLB10 VSS NMOS L=1u W=3.4u AS=6.46p AD=10.88p PS=7.2u
+ PD=13.2u
* device instance $1225 r0 *1 239.2,440.5 PMOS
XM$1225 \$I2194 \$I2195 VDD VDD PMOS L=1u W=3.4u AS=10.88p AD=6.46p PS=13.2u
+ PD=7.2u
* device instance $1226 r0 *1 244,440.5 PMOS
XM$1226 VDD \$I2194 \$I2195 VDD PMOS L=1u W=3.4u AS=6.46p AD=10.88p PS=7.2u
+ PD=13.2u
* device instance $1227 r0 *1 234.4,420.1 NMOS
XM$1227 BL10 WL14 \$I2194 VSS NMOS L=1u W=3.4u AS=10.88p AD=6.46p PS=13.2u
+ PD=7.2u
* device instance $1228 r0 *1 239.2,420.1 NMOS
XM$1228 \$I2194 \$I2195 VSS VSS NMOS L=1u W=3.4u AS=6.46p AD=6.46p PS=7.2u
+ PD=7.2u
* device instance $1229 r0 *1 244,420.1 NMOS
XM$1229 VSS \$I2194 \$I2195 VSS NMOS L=1u W=3.4u AS=6.46p AD=6.46p PS=7.2u
+ PD=7.2u
* device instance $1230 r0 *1 248.8,420.1 NMOS
XM$1230 \$I2195 WL14 BLB10 VSS NMOS L=1u W=3.4u AS=6.46p AD=10.88p PS=7.2u
+ PD=13.2u
* device instance $1231 r0 *1 239.2,322.1 PMOS
XM$1231 \$I2196 \$I2197 VDD VDD PMOS L=1u W=3.4u AS=10.88p AD=6.46p PS=13.2u
+ PD=7.2u
* device instance $1232 r0 *1 244,322.1 PMOS
XM$1232 VDD \$I2196 \$I2197 VDD PMOS L=1u W=3.4u AS=6.46p AD=10.88p PS=7.2u
+ PD=13.2u
* device instance $1233 r0 *1 234.4,301.7 NMOS
XM$1233 BL10 WL10 \$I2196 VSS NMOS L=1u W=3.4u AS=10.88p AD=6.46p PS=13.2u
+ PD=7.2u
* device instance $1234 r0 *1 239.2,301.7 NMOS
XM$1234 \$I2196 \$I2197 VSS VSS NMOS L=1u W=3.4u AS=6.46p AD=6.46p PS=7.2u
+ PD=7.2u
* device instance $1235 r0 *1 244,301.7 NMOS
XM$1235 VSS \$I2196 \$I2197 VSS NMOS L=1u W=3.4u AS=6.46p AD=6.46p PS=7.2u
+ PD=7.2u
* device instance $1236 r0 *1 248.8,301.7 NMOS
XM$1236 \$I2197 WL10 BLB10 VSS NMOS L=1u W=3.4u AS=6.46p AD=10.88p PS=7.2u
+ PD=13.2u
* device instance $1237 r0 *1 239.2,85.3 PMOS
XM$1237 \$I2198 \$I2199 VDD VDD PMOS L=1u W=3.4u AS=10.88p AD=6.46p PS=13.2u
+ PD=7.2u
* device instance $1238 r0 *1 244,85.3 PMOS
XM$1238 VDD \$I2198 \$I2199 VDD PMOS L=1u W=3.4u AS=6.46p AD=10.88p PS=7.2u
+ PD=13.2u
* device instance $1239 r0 *1 234.4,64.9 NMOS
XM$1239 BL10 WL2 \$I2198 VSS NMOS L=1u W=3.4u AS=10.88p AD=6.46p PS=13.2u
+ PD=7.2u
* device instance $1240 r0 *1 239.2,64.9 NMOS
XM$1240 \$I2198 \$I2199 VSS VSS NMOS L=1u W=3.4u AS=6.46p AD=6.46p PS=7.2u
+ PD=7.2u
* device instance $1241 r0 *1 244,64.9 NMOS
XM$1241 VSS \$I2198 \$I2199 VSS NMOS L=1u W=3.4u AS=6.46p AD=6.46p PS=7.2u
+ PD=7.2u
* device instance $1242 r0 *1 248.8,64.9 NMOS
XM$1242 \$I2199 WL2 BLB10 VSS NMOS L=1u W=3.4u AS=6.46p AD=10.88p PS=7.2u
+ PD=13.2u
* device instance $1243 r0 *1 239.2,262.9 PMOS
XM$1243 \$I2200 \$I2201 VDD VDD PMOS L=1u W=3.4u AS=10.88p AD=6.46p PS=13.2u
+ PD=7.2u
* device instance $1244 r0 *1 244,262.9 PMOS
XM$1244 VDD \$I2200 \$I2201 VDD PMOS L=1u W=3.4u AS=6.46p AD=10.88p PS=7.2u
+ PD=13.2u
* device instance $1245 r0 *1 234.4,242.5 NMOS
XM$1245 BL10 WL8 \$I2200 VSS NMOS L=1u W=3.4u AS=10.88p AD=6.46p PS=13.2u
+ PD=7.2u
* device instance $1246 r0 *1 239.2,242.5 NMOS
XM$1246 \$I2200 \$I2201 VSS VSS NMOS L=1u W=3.4u AS=6.46p AD=6.46p PS=7.2u
+ PD=7.2u
* device instance $1247 r0 *1 244,242.5 NMOS
XM$1247 VSS \$I2200 \$I2201 VSS NMOS L=1u W=3.4u AS=6.46p AD=6.46p PS=7.2u
+ PD=7.2u
* device instance $1248 r0 *1 248.8,242.5 NMOS
XM$1248 \$I2201 WL8 BLB10 VSS NMOS L=1u W=3.4u AS=6.46p AD=10.88p PS=7.2u
+ PD=13.2u
* device instance $1249 r0 *1 239.2,144.5 PMOS
XM$1249 \$I2202 \$I2203 VDD VDD PMOS L=1u W=3.4u AS=10.88p AD=6.46p PS=13.2u
+ PD=7.2u
* device instance $1250 r0 *1 244,144.5 PMOS
XM$1250 VDD \$I2202 \$I2203 VDD PMOS L=1u W=3.4u AS=6.46p AD=10.88p PS=7.2u
+ PD=13.2u
* device instance $1251 r0 *1 234.4,124.1 NMOS
XM$1251 BL10 WL4 \$I2202 VSS NMOS L=1u W=3.4u AS=10.88p AD=6.46p PS=13.2u
+ PD=7.2u
* device instance $1252 r0 *1 239.2,124.1 NMOS
XM$1252 \$I2202 \$I2203 VSS VSS NMOS L=1u W=3.4u AS=6.46p AD=6.46p PS=7.2u
+ PD=7.2u
* device instance $1253 r0 *1 244,124.1 NMOS
XM$1253 VSS \$I2202 \$I2203 VSS NMOS L=1u W=3.4u AS=6.46p AD=6.46p PS=7.2u
+ PD=7.2u
* device instance $1254 r0 *1 248.8,124.1 NMOS
XM$1254 \$I2203 WL4 BLB10 VSS NMOS L=1u W=3.4u AS=6.46p AD=10.88p PS=7.2u
+ PD=13.2u
* device instance $1255 r0 *1 239.2,381.3 PMOS
XM$1255 \$I2204 \$I2205 VDD VDD PMOS L=1u W=3.4u AS=10.88p AD=6.46p PS=13.2u
+ PD=7.2u
* device instance $1256 r0 *1 244,381.3 PMOS
XM$1256 VDD \$I2204 \$I2205 VDD PMOS L=1u W=3.4u AS=6.46p AD=10.88p PS=7.2u
+ PD=13.2u
* device instance $1257 r0 *1 234.4,360.9 NMOS
XM$1257 BL10 WL12 \$I2204 VSS NMOS L=1u W=3.4u AS=10.88p AD=6.46p PS=13.2u
+ PD=7.2u
* device instance $1258 r0 *1 239.2,360.9 NMOS
XM$1258 \$I2204 \$I2205 VSS VSS NMOS L=1u W=3.4u AS=6.46p AD=6.46p PS=7.2u
+ PD=7.2u
* device instance $1259 r0 *1 244,360.9 NMOS
XM$1259 VSS \$I2204 \$I2205 VSS NMOS L=1u W=3.4u AS=6.46p AD=6.46p PS=7.2u
+ PD=7.2u
* device instance $1260 r0 *1 248.8,360.9 NMOS
XM$1260 \$I2205 WL12 BLB10 VSS NMOS L=1u W=3.4u AS=6.46p AD=10.88p PS=7.2u
+ PD=13.2u
* device instance $1261 r0 *1 239.2,203.7 PMOS
XM$1261 \$I2206 \$I2207 VDD VDD PMOS L=1u W=3.4u AS=10.88p AD=6.46p PS=13.2u
+ PD=7.2u
* device instance $1262 r0 *1 244,203.7 PMOS
XM$1262 VDD \$I2206 \$I2207 VDD PMOS L=1u W=3.4u AS=6.46p AD=10.88p PS=7.2u
+ PD=13.2u
* device instance $1263 r0 *1 234.4,183.3 NMOS
XM$1263 BL10 WL6 \$I2206 VSS NMOS L=1u W=3.4u AS=10.88p AD=6.46p PS=13.2u
+ PD=7.2u
* device instance $1264 r0 *1 239.2,183.3 NMOS
XM$1264 \$I2206 \$I2207 VSS VSS NMOS L=1u W=3.4u AS=6.46p AD=6.46p PS=7.2u
+ PD=7.2u
* device instance $1265 r0 *1 244,183.3 NMOS
XM$1265 VSS \$I2206 \$I2207 VSS NMOS L=1u W=3.4u AS=6.46p AD=6.46p PS=7.2u
+ PD=7.2u
* device instance $1266 r0 *1 248.8,183.3 NMOS
XM$1266 \$I2207 WL6 BLB10 VSS NMOS L=1u W=3.4u AS=6.46p AD=10.88p PS=7.2u
+ PD=13.2u
* device instance $1267 m0 *1 355.2,329.1 PMOS
XM$1267 \$I2208 \$I2209 VDD VDD PMOS L=1u W=3.4u AS=10.88p AD=6.46p PS=13.2u
+ PD=7.2u
* device instance $1268 m0 *1 360,329.1 PMOS
XM$1268 VDD \$I2208 \$I2209 VDD PMOS L=1u W=3.4u AS=6.46p AD=10.88p PS=7.2u
+ PD=13.2u
* device instance $1269 m0 *1 350.4,349.5 NMOS
XM$1269 BL15 WL11 \$I2208 VSS NMOS L=1u W=3.4u AS=10.88p AD=6.46p PS=13.2u
+ PD=7.2u
* device instance $1270 m0 *1 355.2,349.5 NMOS
XM$1270 \$I2208 \$I2209 VSS VSS NMOS L=1u W=3.4u AS=6.46p AD=6.46p PS=7.2u
+ PD=7.2u
* device instance $1271 m0 *1 360,349.5 NMOS
XM$1271 VSS \$I2208 \$I2209 VSS NMOS L=1u W=3.4u AS=6.46p AD=6.46p PS=7.2u
+ PD=7.2u
* device instance $1272 m0 *1 364.8,349.5 NMOS
XM$1272 \$I2209 WL11 BLB15 VSS NMOS L=1u W=3.4u AS=6.46p AD=10.88p PS=7.2u
+ PD=13.2u
* device instance $1273 m0 *1 355.2,269.9 PMOS
XM$1273 \$I2210 \$I2211 VDD VDD PMOS L=1u W=3.4u AS=10.88p AD=6.46p PS=13.2u
+ PD=7.2u
* device instance $1274 m0 *1 360,269.9 PMOS
XM$1274 VDD \$I2210 \$I2211 VDD PMOS L=1u W=3.4u AS=6.46p AD=10.88p PS=7.2u
+ PD=13.2u
* device instance $1275 m0 *1 350.4,290.3 NMOS
XM$1275 BL15 WL9 \$I2210 VSS NMOS L=1u W=3.4u AS=10.88p AD=6.46p PS=13.2u
+ PD=7.2u
* device instance $1276 m0 *1 355.2,290.3 NMOS
XM$1276 \$I2210 \$I2211 VSS VSS NMOS L=1u W=3.4u AS=6.46p AD=6.46p PS=7.2u
+ PD=7.2u
* device instance $1277 m0 *1 360,290.3 NMOS
XM$1277 VSS \$I2210 \$I2211 VSS NMOS L=1u W=3.4u AS=6.46p AD=6.46p PS=7.2u
+ PD=7.2u
* device instance $1278 m0 *1 364.8,290.3 NMOS
XM$1278 \$I2211 WL9 BLB15 VSS NMOS L=1u W=3.4u AS=6.46p AD=10.88p PS=7.2u
+ PD=13.2u
* device instance $1279 m0 *1 355.2,447.5 PMOS
XM$1279 \$I2212 \$I2213 VDD VDD PMOS L=1u W=3.4u AS=10.88p AD=6.46p PS=13.2u
+ PD=7.2u
* device instance $1280 m0 *1 360,447.5 PMOS
XM$1280 VDD \$I2212 \$I2213 VDD PMOS L=1u W=3.4u AS=6.46p AD=10.88p PS=7.2u
+ PD=13.2u
* device instance $1281 m0 *1 350.4,467.9 NMOS
XM$1281 BL15 WL15 \$I2212 VSS NMOS L=1u W=3.4u AS=10.88p AD=6.46p PS=13.2u
+ PD=7.2u
* device instance $1282 m0 *1 355.2,467.9 NMOS
XM$1282 \$I2212 \$I2213 VSS VSS NMOS L=1u W=3.4u AS=6.46p AD=6.46p PS=7.2u
+ PD=7.2u
* device instance $1283 m0 *1 360,467.9 NMOS
XM$1283 VSS \$I2212 \$I2213 VSS NMOS L=1u W=3.4u AS=6.46p AD=6.46p PS=7.2u
+ PD=7.2u
* device instance $1284 m0 *1 364.8,467.9 NMOS
XM$1284 \$I2213 WL15 BLB15 VSS NMOS L=1u W=3.4u AS=6.46p AD=10.88p PS=7.2u
+ PD=13.2u
* device instance $1285 m0 *1 355.2,388.3 PMOS
XM$1285 \$I2214 \$I2215 VDD VDD PMOS L=1u W=3.4u AS=10.88p AD=6.46p PS=13.2u
+ PD=7.2u
* device instance $1286 m0 *1 360,388.3 PMOS
XM$1286 VDD \$I2214 \$I2215 VDD PMOS L=1u W=3.4u AS=6.46p AD=10.88p PS=7.2u
+ PD=13.2u
* device instance $1287 m0 *1 350.4,408.7 NMOS
XM$1287 BL15 WL13 \$I2214 VSS NMOS L=1u W=3.4u AS=10.88p AD=6.46p PS=13.2u
+ PD=7.2u
* device instance $1288 m0 *1 355.2,408.7 NMOS
XM$1288 \$I2214 \$I2215 VSS VSS NMOS L=1u W=3.4u AS=6.46p AD=6.46p PS=7.2u
+ PD=7.2u
* device instance $1289 m0 *1 360,408.7 NMOS
XM$1289 VSS \$I2214 \$I2215 VSS NMOS L=1u W=3.4u AS=6.46p AD=6.46p PS=7.2u
+ PD=7.2u
* device instance $1290 m0 *1 364.8,408.7 NMOS
XM$1290 \$I2215 WL13 BLB15 VSS NMOS L=1u W=3.4u AS=6.46p AD=10.88p PS=7.2u
+ PD=13.2u
* device instance $1291 m0 *1 355.2,151.5 PMOS
XM$1291 \$I2216 \$I2217 VDD VDD PMOS L=1u W=3.4u AS=10.88p AD=6.46p PS=13.2u
+ PD=7.2u
* device instance $1292 m0 *1 360,151.5 PMOS
XM$1292 VDD \$I2216 \$I2217 VDD PMOS L=1u W=3.4u AS=6.46p AD=10.88p PS=7.2u
+ PD=13.2u
* device instance $1293 m0 *1 350.4,171.9 NMOS
XM$1293 BL15 WL5 \$I2216 VSS NMOS L=1u W=3.4u AS=10.88p AD=6.46p PS=13.2u
+ PD=7.2u
* device instance $1294 m0 *1 355.2,171.9 NMOS
XM$1294 \$I2216 \$I2217 VSS VSS NMOS L=1u W=3.4u AS=6.46p AD=6.46p PS=7.2u
+ PD=7.2u
* device instance $1295 m0 *1 360,171.9 NMOS
XM$1295 VSS \$I2216 \$I2217 VSS NMOS L=1u W=3.4u AS=6.46p AD=6.46p PS=7.2u
+ PD=7.2u
* device instance $1296 m0 *1 364.8,171.9 NMOS
XM$1296 \$I2217 WL5 BLB15 VSS NMOS L=1u W=3.4u AS=6.46p AD=10.88p PS=7.2u
+ PD=13.2u
* device instance $1297 m0 *1 355.2,92.3 PMOS
XM$1297 \$I2218 \$I2219 VDD VDD PMOS L=1u W=3.4u AS=10.88p AD=6.46p PS=13.2u
+ PD=7.2u
* device instance $1298 m0 *1 360,92.3 PMOS
XM$1298 VDD \$I2218 \$I2219 VDD PMOS L=1u W=3.4u AS=6.46p AD=10.88p PS=7.2u
+ PD=13.2u
* device instance $1299 m0 *1 350.4,112.7 NMOS
XM$1299 BL15 WL3 \$I2218 VSS NMOS L=1u W=3.4u AS=10.88p AD=6.46p PS=13.2u
+ PD=7.2u
* device instance $1300 m0 *1 355.2,112.7 NMOS
XM$1300 \$I2218 \$I2219 VSS VSS NMOS L=1u W=3.4u AS=6.46p AD=6.46p PS=7.2u
+ PD=7.2u
* device instance $1301 m0 *1 360,112.7 NMOS
XM$1301 VSS \$I2218 \$I2219 VSS NMOS L=1u W=3.4u AS=6.46p AD=6.46p PS=7.2u
+ PD=7.2u
* device instance $1302 m0 *1 364.8,112.7 NMOS
XM$1302 \$I2219 WL3 BLB15 VSS NMOS L=1u W=3.4u AS=6.46p AD=10.88p PS=7.2u
+ PD=13.2u
* device instance $1303 m0 *1 355.2,210.7 PMOS
XM$1303 \$I2220 \$I2221 VDD VDD PMOS L=1u W=3.4u AS=10.88p AD=6.46p PS=13.2u
+ PD=7.2u
* device instance $1304 m0 *1 360,210.7 PMOS
XM$1304 VDD \$I2220 \$I2221 VDD PMOS L=1u W=3.4u AS=6.46p AD=10.88p PS=7.2u
+ PD=13.2u
* device instance $1305 m0 *1 350.4,231.1 NMOS
XM$1305 BL15 WL7 \$I2220 VSS NMOS L=1u W=3.4u AS=10.88p AD=6.46p PS=13.2u
+ PD=7.2u
* device instance $1306 m0 *1 355.2,231.1 NMOS
XM$1306 \$I2220 \$I2221 VSS VSS NMOS L=1u W=3.4u AS=6.46p AD=6.46p PS=7.2u
+ PD=7.2u
* device instance $1307 m0 *1 360,231.1 NMOS
XM$1307 VSS \$I2220 \$I2221 VSS NMOS L=1u W=3.4u AS=6.46p AD=6.46p PS=7.2u
+ PD=7.2u
* device instance $1308 m0 *1 364.8,231.1 NMOS
XM$1308 \$I2221 WL7 BLB15 VSS NMOS L=1u W=3.4u AS=6.46p AD=10.88p PS=7.2u
+ PD=13.2u
* device instance $1309 m0 *1 355.2,33.1 PMOS
XM$1309 \$I2222 \$I2223 VDD VDD PMOS L=1u W=3.4u AS=10.88p AD=6.46p PS=13.2u
+ PD=7.2u
* device instance $1310 m0 *1 360,33.1 PMOS
XM$1310 VDD \$I2222 \$I2223 VDD PMOS L=1u W=3.4u AS=6.46p AD=10.88p PS=7.2u
+ PD=13.2u
* device instance $1311 m0 *1 350.4,53.5 NMOS
XM$1311 BL15 WL1 \$I2222 VSS NMOS L=1u W=3.4u AS=10.88p AD=6.46p PS=13.2u
+ PD=7.2u
* device instance $1312 m0 *1 355.2,53.5 NMOS
XM$1312 \$I2222 \$I2223 VSS VSS NMOS L=1u W=3.4u AS=6.46p AD=6.46p PS=7.2u
+ PD=7.2u
* device instance $1313 m0 *1 360,53.5 NMOS
XM$1313 VSS \$I2222 \$I2223 VSS NMOS L=1u W=3.4u AS=6.46p AD=6.46p PS=7.2u
+ PD=7.2u
* device instance $1314 m0 *1 364.8,53.5 NMOS
XM$1314 \$I2223 WL1 BLB15 VSS NMOS L=1u W=3.4u AS=6.46p AD=10.88p PS=7.2u
+ PD=13.2u
* device instance $1315 r0 *1 355.2,440.5 PMOS
XM$1315 \$I2224 \$I2225 VDD VDD PMOS L=1u W=3.4u AS=10.88p AD=6.46p PS=13.2u
+ PD=7.2u
* device instance $1316 r0 *1 360,440.5 PMOS
XM$1316 VDD \$I2224 \$I2225 VDD PMOS L=1u W=3.4u AS=6.46p AD=10.88p PS=7.2u
+ PD=13.2u
* device instance $1317 r0 *1 350.4,420.1 NMOS
XM$1317 BL15 WL14 \$I2224 VSS NMOS L=1u W=3.4u AS=10.88p AD=6.46p PS=13.2u
+ PD=7.2u
* device instance $1318 r0 *1 355.2,420.1 NMOS
XM$1318 \$I2224 \$I2225 VSS VSS NMOS L=1u W=3.4u AS=6.46p AD=6.46p PS=7.2u
+ PD=7.2u
* device instance $1319 r0 *1 360,420.1 NMOS
XM$1319 VSS \$I2224 \$I2225 VSS NMOS L=1u W=3.4u AS=6.46p AD=6.46p PS=7.2u
+ PD=7.2u
* device instance $1320 r0 *1 364.8,420.1 NMOS
XM$1320 \$I2225 WL14 BLB15 VSS NMOS L=1u W=3.4u AS=6.46p AD=10.88p PS=7.2u
+ PD=13.2u
* device instance $1321 r0 *1 355.2,203.7 PMOS
XM$1321 \$I2226 \$I2227 VDD VDD PMOS L=1u W=3.4u AS=10.88p AD=6.46p PS=13.2u
+ PD=7.2u
* device instance $1322 r0 *1 360,203.7 PMOS
XM$1322 VDD \$I2226 \$I2227 VDD PMOS L=1u W=3.4u AS=6.46p AD=10.88p PS=7.2u
+ PD=13.2u
* device instance $1323 r0 *1 350.4,183.3 NMOS
XM$1323 BL15 WL6 \$I2226 VSS NMOS L=1u W=3.4u AS=10.88p AD=6.46p PS=13.2u
+ PD=7.2u
* device instance $1324 r0 *1 355.2,183.3 NMOS
XM$1324 \$I2226 \$I2227 VSS VSS NMOS L=1u W=3.4u AS=6.46p AD=6.46p PS=7.2u
+ PD=7.2u
* device instance $1325 r0 *1 360,183.3 NMOS
XM$1325 VSS \$I2226 \$I2227 VSS NMOS L=1u W=3.4u AS=6.46p AD=6.46p PS=7.2u
+ PD=7.2u
* device instance $1326 r0 *1 364.8,183.3 NMOS
XM$1326 \$I2227 WL6 BLB15 VSS NMOS L=1u W=3.4u AS=6.46p AD=10.88p PS=7.2u
+ PD=13.2u
* device instance $1327 r0 *1 355.2,144.5 PMOS
XM$1327 \$I2228 \$I2229 VDD VDD PMOS L=1u W=3.4u AS=10.88p AD=6.46p PS=13.2u
+ PD=7.2u
* device instance $1328 r0 *1 360,144.5 PMOS
XM$1328 VDD \$I2228 \$I2229 VDD PMOS L=1u W=3.4u AS=6.46p AD=10.88p PS=7.2u
+ PD=13.2u
* device instance $1329 r0 *1 350.4,124.1 NMOS
XM$1329 BL15 WL4 \$I2228 VSS NMOS L=1u W=3.4u AS=10.88p AD=6.46p PS=13.2u
+ PD=7.2u
* device instance $1330 r0 *1 355.2,124.1 NMOS
XM$1330 \$I2228 \$I2229 VSS VSS NMOS L=1u W=3.4u AS=6.46p AD=6.46p PS=7.2u
+ PD=7.2u
* device instance $1331 r0 *1 360,124.1 NMOS
XM$1331 VSS \$I2228 \$I2229 VSS NMOS L=1u W=3.4u AS=6.46p AD=6.46p PS=7.2u
+ PD=7.2u
* device instance $1332 r0 *1 364.8,124.1 NMOS
XM$1332 \$I2229 WL4 BLB15 VSS NMOS L=1u W=3.4u AS=6.46p AD=10.88p PS=7.2u
+ PD=13.2u
* device instance $1333 r0 *1 355.2,85.3 PMOS
XM$1333 \$I2230 \$I2231 VDD VDD PMOS L=1u W=3.4u AS=10.88p AD=6.46p PS=13.2u
+ PD=7.2u
* device instance $1334 r0 *1 360,85.3 PMOS
XM$1334 VDD \$I2230 \$I2231 VDD PMOS L=1u W=3.4u AS=6.46p AD=10.88p PS=7.2u
+ PD=13.2u
* device instance $1335 r0 *1 350.4,64.9 NMOS
XM$1335 BL15 WL2 \$I2230 VSS NMOS L=1u W=3.4u AS=10.88p AD=6.46p PS=13.2u
+ PD=7.2u
* device instance $1336 r0 *1 355.2,64.9 NMOS
XM$1336 \$I2230 \$I2231 VSS VSS NMOS L=1u W=3.4u AS=6.46p AD=6.46p PS=7.2u
+ PD=7.2u
* device instance $1337 r0 *1 360,64.9 NMOS
XM$1337 VSS \$I2230 \$I2231 VSS NMOS L=1u W=3.4u AS=6.46p AD=6.46p PS=7.2u
+ PD=7.2u
* device instance $1338 r0 *1 364.8,64.9 NMOS
XM$1338 \$I2231 WL2 BLB15 VSS NMOS L=1u W=3.4u AS=6.46p AD=10.88p PS=7.2u
+ PD=13.2u
* device instance $1339 r0 *1 355.2,381.3 PMOS
XM$1339 \$I2232 \$I2233 VDD VDD PMOS L=1u W=3.4u AS=10.88p AD=6.46p PS=13.2u
+ PD=7.2u
* device instance $1340 r0 *1 360,381.3 PMOS
XM$1340 VDD \$I2232 \$I2233 VDD PMOS L=1u W=3.4u AS=6.46p AD=10.88p PS=7.2u
+ PD=13.2u
* device instance $1341 r0 *1 350.4,360.9 NMOS
XM$1341 BL15 WL12 \$I2232 VSS NMOS L=1u W=3.4u AS=10.88p AD=6.46p PS=13.2u
+ PD=7.2u
* device instance $1342 r0 *1 355.2,360.9 NMOS
XM$1342 \$I2232 \$I2233 VSS VSS NMOS L=1u W=3.4u AS=6.46p AD=6.46p PS=7.2u
+ PD=7.2u
* device instance $1343 r0 *1 360,360.9 NMOS
XM$1343 VSS \$I2232 \$I2233 VSS NMOS L=1u W=3.4u AS=6.46p AD=6.46p PS=7.2u
+ PD=7.2u
* device instance $1344 r0 *1 364.8,360.9 NMOS
XM$1344 \$I2233 WL12 BLB15 VSS NMOS L=1u W=3.4u AS=6.46p AD=10.88p PS=7.2u
+ PD=13.2u
* device instance $1345 r0 *1 355.2,262.9 PMOS
XM$1345 \$I2234 \$I2235 VDD VDD PMOS L=1u W=3.4u AS=10.88p AD=6.46p PS=13.2u
+ PD=7.2u
* device instance $1346 r0 *1 360,262.9 PMOS
XM$1346 VDD \$I2234 \$I2235 VDD PMOS L=1u W=3.4u AS=6.46p AD=10.88p PS=7.2u
+ PD=13.2u
* device instance $1347 r0 *1 350.4,242.5 NMOS
XM$1347 BL15 WL8 \$I2234 VSS NMOS L=1u W=3.4u AS=10.88p AD=6.46p PS=13.2u
+ PD=7.2u
* device instance $1348 r0 *1 355.2,242.5 NMOS
XM$1348 \$I2234 \$I2235 VSS VSS NMOS L=1u W=3.4u AS=6.46p AD=6.46p PS=7.2u
+ PD=7.2u
* device instance $1349 r0 *1 360,242.5 NMOS
XM$1349 VSS \$I2234 \$I2235 VSS NMOS L=1u W=3.4u AS=6.46p AD=6.46p PS=7.2u
+ PD=7.2u
* device instance $1350 r0 *1 364.8,242.5 NMOS
XM$1350 \$I2235 WL8 BLB15 VSS NMOS L=1u W=3.4u AS=6.46p AD=10.88p PS=7.2u
+ PD=13.2u
* device instance $1351 r0 *1 355.2,322.1 PMOS
XM$1351 \$I2236 \$I2237 VDD VDD PMOS L=1u W=3.4u AS=10.88p AD=6.46p PS=13.2u
+ PD=7.2u
* device instance $1352 r0 *1 360,322.1 PMOS
XM$1352 VDD \$I2236 \$I2237 VDD PMOS L=1u W=3.4u AS=6.46p AD=10.88p PS=7.2u
+ PD=13.2u
* device instance $1353 r0 *1 350.4,301.7 NMOS
XM$1353 BL15 WL10 \$I2236 VSS NMOS L=1u W=3.4u AS=10.88p AD=6.46p PS=13.2u
+ PD=7.2u
* device instance $1354 r0 *1 355.2,301.7 NMOS
XM$1354 \$I2236 \$I2237 VSS VSS NMOS L=1u W=3.4u AS=6.46p AD=6.46p PS=7.2u
+ PD=7.2u
* device instance $1355 r0 *1 360,301.7 NMOS
XM$1355 VSS \$I2236 \$I2237 VSS NMOS L=1u W=3.4u AS=6.46p AD=6.46p PS=7.2u
+ PD=7.2u
* device instance $1356 r0 *1 364.8,301.7 NMOS
XM$1356 \$I2237 WL10 BLB15 VSS NMOS L=1u W=3.4u AS=6.46p AD=10.88p PS=7.2u
+ PD=13.2u
* device instance $1357 m0 *1 332,329.1 PMOS
XM$1357 \$I2238 \$I2239 VDD VDD PMOS L=1u W=3.4u AS=10.88p AD=6.46p PS=13.2u
+ PD=7.2u
* device instance $1358 m0 *1 336.8,329.1 PMOS
XM$1358 VDD \$I2238 \$I2239 VDD PMOS L=1u W=3.4u AS=6.46p AD=10.88p PS=7.2u
+ PD=13.2u
* device instance $1359 m0 *1 327.2,349.5 NMOS
XM$1359 BL14 WL11 \$I2238 VSS NMOS L=1u W=3.4u AS=10.88p AD=6.46p PS=13.2u
+ PD=7.2u
* device instance $1360 m0 *1 332,349.5 NMOS
XM$1360 \$I2238 \$I2239 VSS VSS NMOS L=1u W=3.4u AS=6.46p AD=6.46p PS=7.2u
+ PD=7.2u
* device instance $1361 m0 *1 336.8,349.5 NMOS
XM$1361 VSS \$I2238 \$I2239 VSS NMOS L=1u W=3.4u AS=6.46p AD=6.46p PS=7.2u
+ PD=7.2u
* device instance $1362 m0 *1 341.6,349.5 NMOS
XM$1362 \$I2239 WL11 BLB14 VSS NMOS L=1u W=3.4u AS=6.46p AD=10.88p PS=7.2u
+ PD=13.2u
* device instance $1363 m0 *1 332,269.9 PMOS
XM$1363 \$I2240 \$I2241 VDD VDD PMOS L=1u W=3.4u AS=10.88p AD=6.46p PS=13.2u
+ PD=7.2u
* device instance $1364 m0 *1 336.8,269.9 PMOS
XM$1364 VDD \$I2240 \$I2241 VDD PMOS L=1u W=3.4u AS=6.46p AD=10.88p PS=7.2u
+ PD=13.2u
* device instance $1365 m0 *1 327.2,290.3 NMOS
XM$1365 BL14 WL9 \$I2240 VSS NMOS L=1u W=3.4u AS=10.88p AD=6.46p PS=13.2u
+ PD=7.2u
* device instance $1366 m0 *1 332,290.3 NMOS
XM$1366 \$I2240 \$I2241 VSS VSS NMOS L=1u W=3.4u AS=6.46p AD=6.46p PS=7.2u
+ PD=7.2u
* device instance $1367 m0 *1 336.8,290.3 NMOS
XM$1367 VSS \$I2240 \$I2241 VSS NMOS L=1u W=3.4u AS=6.46p AD=6.46p PS=7.2u
+ PD=7.2u
* device instance $1368 m0 *1 341.6,290.3 NMOS
XM$1368 \$I2241 WL9 BLB14 VSS NMOS L=1u W=3.4u AS=6.46p AD=10.88p PS=7.2u
+ PD=13.2u
* device instance $1369 m0 *1 332,447.5 PMOS
XM$1369 \$I2242 \$I2243 VDD VDD PMOS L=1u W=3.4u AS=10.88p AD=6.46p PS=13.2u
+ PD=7.2u
* device instance $1370 m0 *1 336.8,447.5 PMOS
XM$1370 VDD \$I2242 \$I2243 VDD PMOS L=1u W=3.4u AS=6.46p AD=10.88p PS=7.2u
+ PD=13.2u
* device instance $1371 m0 *1 327.2,467.9 NMOS
XM$1371 BL14 WL15 \$I2242 VSS NMOS L=1u W=3.4u AS=10.88p AD=6.46p PS=13.2u
+ PD=7.2u
* device instance $1372 m0 *1 332,467.9 NMOS
XM$1372 \$I2242 \$I2243 VSS VSS NMOS L=1u W=3.4u AS=6.46p AD=6.46p PS=7.2u
+ PD=7.2u
* device instance $1373 m0 *1 336.8,467.9 NMOS
XM$1373 VSS \$I2242 \$I2243 VSS NMOS L=1u W=3.4u AS=6.46p AD=6.46p PS=7.2u
+ PD=7.2u
* device instance $1374 m0 *1 341.6,467.9 NMOS
XM$1374 \$I2243 WL15 BLB14 VSS NMOS L=1u W=3.4u AS=6.46p AD=10.88p PS=7.2u
+ PD=13.2u
* device instance $1375 m0 *1 332,388.3 PMOS
XM$1375 \$I2244 \$I2245 VDD VDD PMOS L=1u W=3.4u AS=10.88p AD=6.46p PS=13.2u
+ PD=7.2u
* device instance $1376 m0 *1 336.8,388.3 PMOS
XM$1376 VDD \$I2244 \$I2245 VDD PMOS L=1u W=3.4u AS=6.46p AD=10.88p PS=7.2u
+ PD=13.2u
* device instance $1377 m0 *1 327.2,408.7 NMOS
XM$1377 BL14 WL13 \$I2244 VSS NMOS L=1u W=3.4u AS=10.88p AD=6.46p PS=13.2u
+ PD=7.2u
* device instance $1378 m0 *1 332,408.7 NMOS
XM$1378 \$I2244 \$I2245 VSS VSS NMOS L=1u W=3.4u AS=6.46p AD=6.46p PS=7.2u
+ PD=7.2u
* device instance $1379 m0 *1 336.8,408.7 NMOS
XM$1379 VSS \$I2244 \$I2245 VSS NMOS L=1u W=3.4u AS=6.46p AD=6.46p PS=7.2u
+ PD=7.2u
* device instance $1380 m0 *1 341.6,408.7 NMOS
XM$1380 \$I2245 WL13 BLB14 VSS NMOS L=1u W=3.4u AS=6.46p AD=10.88p PS=7.2u
+ PD=13.2u
* device instance $1381 m0 *1 332,151.5 PMOS
XM$1381 \$I2246 \$I2247 VDD VDD PMOS L=1u W=3.4u AS=10.88p AD=6.46p PS=13.2u
+ PD=7.2u
* device instance $1382 m0 *1 336.8,151.5 PMOS
XM$1382 VDD \$I2246 \$I2247 VDD PMOS L=1u W=3.4u AS=6.46p AD=10.88p PS=7.2u
+ PD=13.2u
* device instance $1383 m0 *1 327.2,171.9 NMOS
XM$1383 BL14 WL5 \$I2246 VSS NMOS L=1u W=3.4u AS=10.88p AD=6.46p PS=13.2u
+ PD=7.2u
* device instance $1384 m0 *1 332,171.9 NMOS
XM$1384 \$I2246 \$I2247 VSS VSS NMOS L=1u W=3.4u AS=6.46p AD=6.46p PS=7.2u
+ PD=7.2u
* device instance $1385 m0 *1 336.8,171.9 NMOS
XM$1385 VSS \$I2246 \$I2247 VSS NMOS L=1u W=3.4u AS=6.46p AD=6.46p PS=7.2u
+ PD=7.2u
* device instance $1386 m0 *1 341.6,171.9 NMOS
XM$1386 \$I2247 WL5 BLB14 VSS NMOS L=1u W=3.4u AS=6.46p AD=10.88p PS=7.2u
+ PD=13.2u
* device instance $1387 m0 *1 332,210.7 PMOS
XM$1387 \$I2248 \$I2249 VDD VDD PMOS L=1u W=3.4u AS=10.88p AD=6.46p PS=13.2u
+ PD=7.2u
* device instance $1388 m0 *1 336.8,210.7 PMOS
XM$1388 VDD \$I2248 \$I2249 VDD PMOS L=1u W=3.4u AS=6.46p AD=10.88p PS=7.2u
+ PD=13.2u
* device instance $1389 m0 *1 327.2,231.1 NMOS
XM$1389 BL14 WL7 \$I2248 VSS NMOS L=1u W=3.4u AS=10.88p AD=6.46p PS=13.2u
+ PD=7.2u
* device instance $1390 m0 *1 332,231.1 NMOS
XM$1390 \$I2248 \$I2249 VSS VSS NMOS L=1u W=3.4u AS=6.46p AD=6.46p PS=7.2u
+ PD=7.2u
* device instance $1391 m0 *1 336.8,231.1 NMOS
XM$1391 VSS \$I2248 \$I2249 VSS NMOS L=1u W=3.4u AS=6.46p AD=6.46p PS=7.2u
+ PD=7.2u
* device instance $1392 m0 *1 341.6,231.1 NMOS
XM$1392 \$I2249 WL7 BLB14 VSS NMOS L=1u W=3.4u AS=6.46p AD=10.88p PS=7.2u
+ PD=13.2u
* device instance $1393 m0 *1 332,33.1 PMOS
XM$1393 \$I2250 \$I2251 VDD VDD PMOS L=1u W=3.4u AS=10.88p AD=6.46p PS=13.2u
+ PD=7.2u
* device instance $1394 m0 *1 336.8,33.1 PMOS
XM$1394 VDD \$I2250 \$I2251 VDD PMOS L=1u W=3.4u AS=6.46p AD=10.88p PS=7.2u
+ PD=13.2u
* device instance $1395 m0 *1 327.2,53.5 NMOS
XM$1395 BL14 WL1 \$I2250 VSS NMOS L=1u W=3.4u AS=10.88p AD=6.46p PS=13.2u
+ PD=7.2u
* device instance $1396 m0 *1 332,53.5 NMOS
XM$1396 \$I2250 \$I2251 VSS VSS NMOS L=1u W=3.4u AS=6.46p AD=6.46p PS=7.2u
+ PD=7.2u
* device instance $1397 m0 *1 336.8,53.5 NMOS
XM$1397 VSS \$I2250 \$I2251 VSS NMOS L=1u W=3.4u AS=6.46p AD=6.46p PS=7.2u
+ PD=7.2u
* device instance $1398 m0 *1 341.6,53.5 NMOS
XM$1398 \$I2251 WL1 BLB14 VSS NMOS L=1u W=3.4u AS=6.46p AD=10.88p PS=7.2u
+ PD=13.2u
* device instance $1399 m0 *1 332,92.3 PMOS
XM$1399 \$I2252 \$I2253 VDD VDD PMOS L=1u W=3.4u AS=10.88p AD=6.46p PS=13.2u
+ PD=7.2u
* device instance $1400 m0 *1 336.8,92.3 PMOS
XM$1400 VDD \$I2252 \$I2253 VDD PMOS L=1u W=3.4u AS=6.46p AD=10.88p PS=7.2u
+ PD=13.2u
* device instance $1401 m0 *1 327.2,112.7 NMOS
XM$1401 BL14 WL3 \$I2252 VSS NMOS L=1u W=3.4u AS=10.88p AD=6.46p PS=13.2u
+ PD=7.2u
* device instance $1402 m0 *1 332,112.7 NMOS
XM$1402 \$I2252 \$I2253 VSS VSS NMOS L=1u W=3.4u AS=6.46p AD=6.46p PS=7.2u
+ PD=7.2u
* device instance $1403 m0 *1 336.8,112.7 NMOS
XM$1403 VSS \$I2252 \$I2253 VSS NMOS L=1u W=3.4u AS=6.46p AD=6.46p PS=7.2u
+ PD=7.2u
* device instance $1404 m0 *1 341.6,112.7 NMOS
XM$1404 \$I2253 WL3 BLB14 VSS NMOS L=1u W=3.4u AS=6.46p AD=10.88p PS=7.2u
+ PD=13.2u
* device instance $1405 r0 *1 332,203.7 PMOS
XM$1405 \$I2254 \$I2255 VDD VDD PMOS L=1u W=3.4u AS=10.88p AD=6.46p PS=13.2u
+ PD=7.2u
* device instance $1406 r0 *1 336.8,203.7 PMOS
XM$1406 VDD \$I2254 \$I2255 VDD PMOS L=1u W=3.4u AS=6.46p AD=10.88p PS=7.2u
+ PD=13.2u
* device instance $1407 r0 *1 327.2,183.3 NMOS
XM$1407 BL14 WL6 \$I2254 VSS NMOS L=1u W=3.4u AS=10.88p AD=6.46p PS=13.2u
+ PD=7.2u
* device instance $1408 r0 *1 332,183.3 NMOS
XM$1408 \$I2254 \$I2255 VSS VSS NMOS L=1u W=3.4u AS=6.46p AD=6.46p PS=7.2u
+ PD=7.2u
* device instance $1409 r0 *1 336.8,183.3 NMOS
XM$1409 VSS \$I2254 \$I2255 VSS NMOS L=1u W=3.4u AS=6.46p AD=6.46p PS=7.2u
+ PD=7.2u
* device instance $1410 r0 *1 341.6,183.3 NMOS
XM$1410 \$I2255 WL6 BLB14 VSS NMOS L=1u W=3.4u AS=6.46p AD=10.88p PS=7.2u
+ PD=13.2u
* device instance $1411 r0 *1 332,440.5 PMOS
XM$1411 \$I2256 \$I2257 VDD VDD PMOS L=1u W=3.4u AS=10.88p AD=6.46p PS=13.2u
+ PD=7.2u
* device instance $1412 r0 *1 336.8,440.5 PMOS
XM$1412 VDD \$I2256 \$I2257 VDD PMOS L=1u W=3.4u AS=6.46p AD=10.88p PS=7.2u
+ PD=13.2u
* device instance $1413 r0 *1 327.2,420.1 NMOS
XM$1413 BL14 WL14 \$I2256 VSS NMOS L=1u W=3.4u AS=10.88p AD=6.46p PS=13.2u
+ PD=7.2u
* device instance $1414 r0 *1 332,420.1 NMOS
XM$1414 \$I2256 \$I2257 VSS VSS NMOS L=1u W=3.4u AS=6.46p AD=6.46p PS=7.2u
+ PD=7.2u
* device instance $1415 r0 *1 336.8,420.1 NMOS
XM$1415 VSS \$I2256 \$I2257 VSS NMOS L=1u W=3.4u AS=6.46p AD=6.46p PS=7.2u
+ PD=7.2u
* device instance $1416 r0 *1 341.6,420.1 NMOS
XM$1416 \$I2257 WL14 BLB14 VSS NMOS L=1u W=3.4u AS=6.46p AD=10.88p PS=7.2u
+ PD=13.2u
* device instance $1417 r0 *1 332,144.5 PMOS
XM$1417 \$I2258 \$I2259 VDD VDD PMOS L=1u W=3.4u AS=10.88p AD=6.46p PS=13.2u
+ PD=7.2u
* device instance $1418 r0 *1 336.8,144.5 PMOS
XM$1418 VDD \$I2258 \$I2259 VDD PMOS L=1u W=3.4u AS=6.46p AD=10.88p PS=7.2u
+ PD=13.2u
* device instance $1419 r0 *1 327.2,124.1 NMOS
XM$1419 BL14 WL4 \$I2258 VSS NMOS L=1u W=3.4u AS=10.88p AD=6.46p PS=13.2u
+ PD=7.2u
* device instance $1420 r0 *1 332,124.1 NMOS
XM$1420 \$I2258 \$I2259 VSS VSS NMOS L=1u W=3.4u AS=6.46p AD=6.46p PS=7.2u
+ PD=7.2u
* device instance $1421 r0 *1 336.8,124.1 NMOS
XM$1421 VSS \$I2258 \$I2259 VSS NMOS L=1u W=3.4u AS=6.46p AD=6.46p PS=7.2u
+ PD=7.2u
* device instance $1422 r0 *1 341.6,124.1 NMOS
XM$1422 \$I2259 WL4 BLB14 VSS NMOS L=1u W=3.4u AS=6.46p AD=10.88p PS=7.2u
+ PD=13.2u
* device instance $1423 r0 *1 332,85.3 PMOS
XM$1423 \$I2260 \$I2261 VDD VDD PMOS L=1u W=3.4u AS=10.88p AD=6.46p PS=13.2u
+ PD=7.2u
* device instance $1424 r0 *1 336.8,85.3 PMOS
XM$1424 VDD \$I2260 \$I2261 VDD PMOS L=1u W=3.4u AS=6.46p AD=10.88p PS=7.2u
+ PD=13.2u
* device instance $1425 r0 *1 327.2,64.9 NMOS
XM$1425 BL14 WL2 \$I2260 VSS NMOS L=1u W=3.4u AS=10.88p AD=6.46p PS=13.2u
+ PD=7.2u
* device instance $1426 r0 *1 332,64.9 NMOS
XM$1426 \$I2260 \$I2261 VSS VSS NMOS L=1u W=3.4u AS=6.46p AD=6.46p PS=7.2u
+ PD=7.2u
* device instance $1427 r0 *1 336.8,64.9 NMOS
XM$1427 VSS \$I2260 \$I2261 VSS NMOS L=1u W=3.4u AS=6.46p AD=6.46p PS=7.2u
+ PD=7.2u
* device instance $1428 r0 *1 341.6,64.9 NMOS
XM$1428 \$I2261 WL2 BLB14 VSS NMOS L=1u W=3.4u AS=6.46p AD=10.88p PS=7.2u
+ PD=13.2u
* device instance $1429 r0 *1 332,381.3 PMOS
XM$1429 \$I2262 \$I2263 VDD VDD PMOS L=1u W=3.4u AS=10.88p AD=6.46p PS=13.2u
+ PD=7.2u
* device instance $1430 r0 *1 336.8,381.3 PMOS
XM$1430 VDD \$I2262 \$I2263 VDD PMOS L=1u W=3.4u AS=6.46p AD=10.88p PS=7.2u
+ PD=13.2u
* device instance $1431 r0 *1 327.2,360.9 NMOS
XM$1431 BL14 WL12 \$I2262 VSS NMOS L=1u W=3.4u AS=10.88p AD=6.46p PS=13.2u
+ PD=7.2u
* device instance $1432 r0 *1 332,360.9 NMOS
XM$1432 \$I2262 \$I2263 VSS VSS NMOS L=1u W=3.4u AS=6.46p AD=6.46p PS=7.2u
+ PD=7.2u
* device instance $1433 r0 *1 336.8,360.9 NMOS
XM$1433 VSS \$I2262 \$I2263 VSS NMOS L=1u W=3.4u AS=6.46p AD=6.46p PS=7.2u
+ PD=7.2u
* device instance $1434 r0 *1 341.6,360.9 NMOS
XM$1434 \$I2263 WL12 BLB14 VSS NMOS L=1u W=3.4u AS=6.46p AD=10.88p PS=7.2u
+ PD=13.2u
* device instance $1435 r0 *1 332,262.9 PMOS
XM$1435 \$I2264 \$I2265 VDD VDD PMOS L=1u W=3.4u AS=10.88p AD=6.46p PS=13.2u
+ PD=7.2u
* device instance $1436 r0 *1 336.8,262.9 PMOS
XM$1436 VDD \$I2264 \$I2265 VDD PMOS L=1u W=3.4u AS=6.46p AD=10.88p PS=7.2u
+ PD=13.2u
* device instance $1437 r0 *1 327.2,242.5 NMOS
XM$1437 BL14 WL8 \$I2264 VSS NMOS L=1u W=3.4u AS=10.88p AD=6.46p PS=13.2u
+ PD=7.2u
* device instance $1438 r0 *1 332,242.5 NMOS
XM$1438 \$I2264 \$I2265 VSS VSS NMOS L=1u W=3.4u AS=6.46p AD=6.46p PS=7.2u
+ PD=7.2u
* device instance $1439 r0 *1 336.8,242.5 NMOS
XM$1439 VSS \$I2264 \$I2265 VSS NMOS L=1u W=3.4u AS=6.46p AD=6.46p PS=7.2u
+ PD=7.2u
* device instance $1440 r0 *1 341.6,242.5 NMOS
XM$1440 \$I2265 WL8 BLB14 VSS NMOS L=1u W=3.4u AS=6.46p AD=10.88p PS=7.2u
+ PD=13.2u
* device instance $1441 r0 *1 332,322.1 PMOS
XM$1441 \$I2266 \$I2267 VDD VDD PMOS L=1u W=3.4u AS=10.88p AD=6.46p PS=13.2u
+ PD=7.2u
* device instance $1442 r0 *1 336.8,322.1 PMOS
XM$1442 VDD \$I2266 \$I2267 VDD PMOS L=1u W=3.4u AS=6.46p AD=10.88p PS=7.2u
+ PD=13.2u
* device instance $1443 r0 *1 327.2,301.7 NMOS
XM$1443 BL14 WL10 \$I2266 VSS NMOS L=1u W=3.4u AS=10.88p AD=6.46p PS=13.2u
+ PD=7.2u
* device instance $1444 r0 *1 332,301.7 NMOS
XM$1444 \$I2266 \$I2267 VSS VSS NMOS L=1u W=3.4u AS=6.46p AD=6.46p PS=7.2u
+ PD=7.2u
* device instance $1445 r0 *1 336.8,301.7 NMOS
XM$1445 VSS \$I2266 \$I2267 VSS NMOS L=1u W=3.4u AS=6.46p AD=6.46p PS=7.2u
+ PD=7.2u
* device instance $1446 r0 *1 341.6,301.7 NMOS
XM$1446 \$I2267 WL10 BLB14 VSS NMOS L=1u W=3.4u AS=6.46p AD=10.88p PS=7.2u
+ PD=13.2u
* device instance $1447 m0 *1 308.8,329.1 PMOS
XM$1447 \$I2268 \$I2269 VDD VDD PMOS L=1u W=3.4u AS=10.88p AD=6.46p PS=13.2u
+ PD=7.2u
* device instance $1448 m0 *1 313.6,329.1 PMOS
XM$1448 VDD \$I2268 \$I2269 VDD PMOS L=1u W=3.4u AS=6.46p AD=10.88p PS=7.2u
+ PD=13.2u
* device instance $1449 m0 *1 304,349.5 NMOS
XM$1449 BL13 WL11 \$I2268 VSS NMOS L=1u W=3.4u AS=10.88p AD=6.46p PS=13.2u
+ PD=7.2u
* device instance $1450 m0 *1 308.8,349.5 NMOS
XM$1450 \$I2268 \$I2269 VSS VSS NMOS L=1u W=3.4u AS=6.46p AD=6.46p PS=7.2u
+ PD=7.2u
* device instance $1451 m0 *1 313.6,349.5 NMOS
XM$1451 VSS \$I2268 \$I2269 VSS NMOS L=1u W=3.4u AS=6.46p AD=6.46p PS=7.2u
+ PD=7.2u
* device instance $1452 m0 *1 318.4,349.5 NMOS
XM$1452 \$I2269 WL11 BLB13 VSS NMOS L=1u W=3.4u AS=6.46p AD=10.88p PS=7.2u
+ PD=13.2u
* device instance $1453 m0 *1 308.8,388.3 PMOS
XM$1453 \$I2270 \$I2271 VDD VDD PMOS L=1u W=3.4u AS=10.88p AD=6.46p PS=13.2u
+ PD=7.2u
* device instance $1454 m0 *1 313.6,388.3 PMOS
XM$1454 VDD \$I2270 \$I2271 VDD PMOS L=1u W=3.4u AS=6.46p AD=10.88p PS=7.2u
+ PD=13.2u
* device instance $1455 m0 *1 304,408.7 NMOS
XM$1455 BL13 WL13 \$I2270 VSS NMOS L=1u W=3.4u AS=10.88p AD=6.46p PS=13.2u
+ PD=7.2u
* device instance $1456 m0 *1 308.8,408.7 NMOS
XM$1456 \$I2270 \$I2271 VSS VSS NMOS L=1u W=3.4u AS=6.46p AD=6.46p PS=7.2u
+ PD=7.2u
* device instance $1457 m0 *1 313.6,408.7 NMOS
XM$1457 VSS \$I2270 \$I2271 VSS NMOS L=1u W=3.4u AS=6.46p AD=6.46p PS=7.2u
+ PD=7.2u
* device instance $1458 m0 *1 318.4,408.7 NMOS
XM$1458 \$I2271 WL13 BLB13 VSS NMOS L=1u W=3.4u AS=6.46p AD=10.88p PS=7.2u
+ PD=13.2u
* device instance $1459 m0 *1 308.8,269.9 PMOS
XM$1459 \$I2272 \$I2273 VDD VDD PMOS L=1u W=3.4u AS=10.88p AD=6.46p PS=13.2u
+ PD=7.2u
* device instance $1460 m0 *1 313.6,269.9 PMOS
XM$1460 VDD \$I2272 \$I2273 VDD PMOS L=1u W=3.4u AS=6.46p AD=10.88p PS=7.2u
+ PD=13.2u
* device instance $1461 m0 *1 304,290.3 NMOS
XM$1461 BL13 WL9 \$I2272 VSS NMOS L=1u W=3.4u AS=10.88p AD=6.46p PS=13.2u
+ PD=7.2u
* device instance $1462 m0 *1 308.8,290.3 NMOS
XM$1462 \$I2272 \$I2273 VSS VSS NMOS L=1u W=3.4u AS=6.46p AD=6.46p PS=7.2u
+ PD=7.2u
* device instance $1463 m0 *1 313.6,290.3 NMOS
XM$1463 VSS \$I2272 \$I2273 VSS NMOS L=1u W=3.4u AS=6.46p AD=6.46p PS=7.2u
+ PD=7.2u
* device instance $1464 m0 *1 318.4,290.3 NMOS
XM$1464 \$I2273 WL9 BLB13 VSS NMOS L=1u W=3.4u AS=6.46p AD=10.88p PS=7.2u
+ PD=13.2u
* device instance $1465 m0 *1 308.8,447.5 PMOS
XM$1465 \$I2274 \$I2275 VDD VDD PMOS L=1u W=3.4u AS=10.88p AD=6.46p PS=13.2u
+ PD=7.2u
* device instance $1466 m0 *1 313.6,447.5 PMOS
XM$1466 VDD \$I2274 \$I2275 VDD PMOS L=1u W=3.4u AS=6.46p AD=10.88p PS=7.2u
+ PD=13.2u
* device instance $1467 m0 *1 304,467.9 NMOS
XM$1467 BL13 WL15 \$I2274 VSS NMOS L=1u W=3.4u AS=10.88p AD=6.46p PS=13.2u
+ PD=7.2u
* device instance $1468 m0 *1 308.8,467.9 NMOS
XM$1468 \$I2274 \$I2275 VSS VSS NMOS L=1u W=3.4u AS=6.46p AD=6.46p PS=7.2u
+ PD=7.2u
* device instance $1469 m0 *1 313.6,467.9 NMOS
XM$1469 VSS \$I2274 \$I2275 VSS NMOS L=1u W=3.4u AS=6.46p AD=6.46p PS=7.2u
+ PD=7.2u
* device instance $1470 m0 *1 318.4,467.9 NMOS
XM$1470 \$I2275 WL15 BLB13 VSS NMOS L=1u W=3.4u AS=6.46p AD=10.88p PS=7.2u
+ PD=13.2u
* device instance $1471 m0 *1 308.8,210.7 PMOS
XM$1471 \$I2276 \$I2277 VDD VDD PMOS L=1u W=3.4u AS=10.88p AD=6.46p PS=13.2u
+ PD=7.2u
* device instance $1472 m0 *1 313.6,210.7 PMOS
XM$1472 VDD \$I2276 \$I2277 VDD PMOS L=1u W=3.4u AS=6.46p AD=10.88p PS=7.2u
+ PD=13.2u
* device instance $1473 m0 *1 304,231.1 NMOS
XM$1473 BL13 WL7 \$I2276 VSS NMOS L=1u W=3.4u AS=10.88p AD=6.46p PS=13.2u
+ PD=7.2u
* device instance $1474 m0 *1 308.8,231.1 NMOS
XM$1474 \$I2276 \$I2277 VSS VSS NMOS L=1u W=3.4u AS=6.46p AD=6.46p PS=7.2u
+ PD=7.2u
* device instance $1475 m0 *1 313.6,231.1 NMOS
XM$1475 VSS \$I2276 \$I2277 VSS NMOS L=1u W=3.4u AS=6.46p AD=6.46p PS=7.2u
+ PD=7.2u
* device instance $1476 m0 *1 318.4,231.1 NMOS
XM$1476 \$I2277 WL7 BLB13 VSS NMOS L=1u W=3.4u AS=6.46p AD=10.88p PS=7.2u
+ PD=13.2u
* device instance $1477 m0 *1 308.8,151.5 PMOS
XM$1477 \$I2278 \$I2279 VDD VDD PMOS L=1u W=3.4u AS=10.88p AD=6.46p PS=13.2u
+ PD=7.2u
* device instance $1478 m0 *1 313.6,151.5 PMOS
XM$1478 VDD \$I2278 \$I2279 VDD PMOS L=1u W=3.4u AS=6.46p AD=10.88p PS=7.2u
+ PD=13.2u
* device instance $1479 m0 *1 304,171.9 NMOS
XM$1479 BL13 WL5 \$I2278 VSS NMOS L=1u W=3.4u AS=10.88p AD=6.46p PS=13.2u
+ PD=7.2u
* device instance $1480 m0 *1 308.8,171.9 NMOS
XM$1480 \$I2278 \$I2279 VSS VSS NMOS L=1u W=3.4u AS=6.46p AD=6.46p PS=7.2u
+ PD=7.2u
* device instance $1481 m0 *1 313.6,171.9 NMOS
XM$1481 VSS \$I2278 \$I2279 VSS NMOS L=1u W=3.4u AS=6.46p AD=6.46p PS=7.2u
+ PD=7.2u
* device instance $1482 m0 *1 318.4,171.9 NMOS
XM$1482 \$I2279 WL5 BLB13 VSS NMOS L=1u W=3.4u AS=6.46p AD=10.88p PS=7.2u
+ PD=13.2u
* device instance $1483 m0 *1 308.8,33.1 PMOS
XM$1483 \$I2280 \$I2281 VDD VDD PMOS L=1u W=3.4u AS=10.88p AD=6.46p PS=13.2u
+ PD=7.2u
* device instance $1484 m0 *1 313.6,33.1 PMOS
XM$1484 VDD \$I2280 \$I2281 VDD PMOS L=1u W=3.4u AS=6.46p AD=10.88p PS=7.2u
+ PD=13.2u
* device instance $1485 m0 *1 304,53.5 NMOS
XM$1485 BL13 WL1 \$I2280 VSS NMOS L=1u W=3.4u AS=10.88p AD=6.46p PS=13.2u
+ PD=7.2u
* device instance $1486 m0 *1 308.8,53.5 NMOS
XM$1486 \$I2280 \$I2281 VSS VSS NMOS L=1u W=3.4u AS=6.46p AD=6.46p PS=7.2u
+ PD=7.2u
* device instance $1487 m0 *1 313.6,53.5 NMOS
XM$1487 VSS \$I2280 \$I2281 VSS NMOS L=1u W=3.4u AS=6.46p AD=6.46p PS=7.2u
+ PD=7.2u
* device instance $1488 m0 *1 318.4,53.5 NMOS
XM$1488 \$I2281 WL1 BLB13 VSS NMOS L=1u W=3.4u AS=6.46p AD=10.88p PS=7.2u
+ PD=13.2u
* device instance $1489 m0 *1 308.8,92.3 PMOS
XM$1489 \$I2282 \$I2283 VDD VDD PMOS L=1u W=3.4u AS=10.88p AD=6.46p PS=13.2u
+ PD=7.2u
* device instance $1490 m0 *1 313.6,92.3 PMOS
XM$1490 VDD \$I2282 \$I2283 VDD PMOS L=1u W=3.4u AS=6.46p AD=10.88p PS=7.2u
+ PD=13.2u
* device instance $1491 m0 *1 304,112.7 NMOS
XM$1491 BL13 WL3 \$I2282 VSS NMOS L=1u W=3.4u AS=10.88p AD=6.46p PS=13.2u
+ PD=7.2u
* device instance $1492 m0 *1 308.8,112.7 NMOS
XM$1492 \$I2282 \$I2283 VSS VSS NMOS L=1u W=3.4u AS=6.46p AD=6.46p PS=7.2u
+ PD=7.2u
* device instance $1493 m0 *1 313.6,112.7 NMOS
XM$1493 VSS \$I2282 \$I2283 VSS NMOS L=1u W=3.4u AS=6.46p AD=6.46p PS=7.2u
+ PD=7.2u
* device instance $1494 m0 *1 318.4,112.7 NMOS
XM$1494 \$I2283 WL3 BLB13 VSS NMOS L=1u W=3.4u AS=6.46p AD=10.88p PS=7.2u
+ PD=13.2u
* device instance $1495 r0 *1 308.8,440.5 PMOS
XM$1495 \$I2284 \$I2285 VDD VDD PMOS L=1u W=3.4u AS=10.88p AD=6.46p PS=13.2u
+ PD=7.2u
* device instance $1496 r0 *1 313.6,440.5 PMOS
XM$1496 VDD \$I2284 \$I2285 VDD PMOS L=1u W=3.4u AS=6.46p AD=10.88p PS=7.2u
+ PD=13.2u
* device instance $1497 r0 *1 304,420.1 NMOS
XM$1497 BL13 WL14 \$I2284 VSS NMOS L=1u W=3.4u AS=10.88p AD=6.46p PS=13.2u
+ PD=7.2u
* device instance $1498 r0 *1 308.8,420.1 NMOS
XM$1498 \$I2284 \$I2285 VSS VSS NMOS L=1u W=3.4u AS=6.46p AD=6.46p PS=7.2u
+ PD=7.2u
* device instance $1499 r0 *1 313.6,420.1 NMOS
XM$1499 VSS \$I2284 \$I2285 VSS NMOS L=1u W=3.4u AS=6.46p AD=6.46p PS=7.2u
+ PD=7.2u
* device instance $1500 r0 *1 318.4,420.1 NMOS
XM$1500 \$I2285 WL14 BLB13 VSS NMOS L=1u W=3.4u AS=6.46p AD=10.88p PS=7.2u
+ PD=13.2u
* device instance $1501 r0 *1 308.8,203.7 PMOS
XM$1501 \$I2286 \$I2287 VDD VDD PMOS L=1u W=3.4u AS=10.88p AD=6.46p PS=13.2u
+ PD=7.2u
* device instance $1502 r0 *1 313.6,203.7 PMOS
XM$1502 VDD \$I2286 \$I2287 VDD PMOS L=1u W=3.4u AS=6.46p AD=10.88p PS=7.2u
+ PD=13.2u
* device instance $1503 r0 *1 304,183.3 NMOS
XM$1503 BL13 WL6 \$I2286 VSS NMOS L=1u W=3.4u AS=10.88p AD=6.46p PS=13.2u
+ PD=7.2u
* device instance $1504 r0 *1 308.8,183.3 NMOS
XM$1504 \$I2286 \$I2287 VSS VSS NMOS L=1u W=3.4u AS=6.46p AD=6.46p PS=7.2u
+ PD=7.2u
* device instance $1505 r0 *1 313.6,183.3 NMOS
XM$1505 VSS \$I2286 \$I2287 VSS NMOS L=1u W=3.4u AS=6.46p AD=6.46p PS=7.2u
+ PD=7.2u
* device instance $1506 r0 *1 318.4,183.3 NMOS
XM$1506 \$I2287 WL6 BLB13 VSS NMOS L=1u W=3.4u AS=6.46p AD=10.88p PS=7.2u
+ PD=13.2u
* device instance $1507 r0 *1 308.8,144.5 PMOS
XM$1507 \$I2288 \$I2289 VDD VDD PMOS L=1u W=3.4u AS=10.88p AD=6.46p PS=13.2u
+ PD=7.2u
* device instance $1508 r0 *1 313.6,144.5 PMOS
XM$1508 VDD \$I2288 \$I2289 VDD PMOS L=1u W=3.4u AS=6.46p AD=10.88p PS=7.2u
+ PD=13.2u
* device instance $1509 r0 *1 304,124.1 NMOS
XM$1509 BL13 WL4 \$I2288 VSS NMOS L=1u W=3.4u AS=10.88p AD=6.46p PS=13.2u
+ PD=7.2u
* device instance $1510 r0 *1 308.8,124.1 NMOS
XM$1510 \$I2288 \$I2289 VSS VSS NMOS L=1u W=3.4u AS=6.46p AD=6.46p PS=7.2u
+ PD=7.2u
* device instance $1511 r0 *1 313.6,124.1 NMOS
XM$1511 VSS \$I2288 \$I2289 VSS NMOS L=1u W=3.4u AS=6.46p AD=6.46p PS=7.2u
+ PD=7.2u
* device instance $1512 r0 *1 318.4,124.1 NMOS
XM$1512 \$I2289 WL4 BLB13 VSS NMOS L=1u W=3.4u AS=6.46p AD=10.88p PS=7.2u
+ PD=13.2u
* device instance $1513 r0 *1 308.8,85.3 PMOS
XM$1513 \$I2290 \$I2291 VDD VDD PMOS L=1u W=3.4u AS=10.88p AD=6.46p PS=13.2u
+ PD=7.2u
* device instance $1514 r0 *1 313.6,85.3 PMOS
XM$1514 VDD \$I2290 \$I2291 VDD PMOS L=1u W=3.4u AS=6.46p AD=10.88p PS=7.2u
+ PD=13.2u
* device instance $1515 r0 *1 304,64.9 NMOS
XM$1515 BL13 WL2 \$I2290 VSS NMOS L=1u W=3.4u AS=10.88p AD=6.46p PS=13.2u
+ PD=7.2u
* device instance $1516 r0 *1 308.8,64.9 NMOS
XM$1516 \$I2290 \$I2291 VSS VSS NMOS L=1u W=3.4u AS=6.46p AD=6.46p PS=7.2u
+ PD=7.2u
* device instance $1517 r0 *1 313.6,64.9 NMOS
XM$1517 VSS \$I2290 \$I2291 VSS NMOS L=1u W=3.4u AS=6.46p AD=6.46p PS=7.2u
+ PD=7.2u
* device instance $1518 r0 *1 318.4,64.9 NMOS
XM$1518 \$I2291 WL2 BLB13 VSS NMOS L=1u W=3.4u AS=6.46p AD=10.88p PS=7.2u
+ PD=13.2u
* device instance $1519 r0 *1 308.8,381.3 PMOS
XM$1519 \$I2292 \$I2293 VDD VDD PMOS L=1u W=3.4u AS=10.88p AD=6.46p PS=13.2u
+ PD=7.2u
* device instance $1520 r0 *1 313.6,381.3 PMOS
XM$1520 VDD \$I2292 \$I2293 VDD PMOS L=1u W=3.4u AS=6.46p AD=10.88p PS=7.2u
+ PD=13.2u
* device instance $1521 r0 *1 304,360.9 NMOS
XM$1521 BL13 WL12 \$I2292 VSS NMOS L=1u W=3.4u AS=10.88p AD=6.46p PS=13.2u
+ PD=7.2u
* device instance $1522 r0 *1 308.8,360.9 NMOS
XM$1522 \$I2292 \$I2293 VSS VSS NMOS L=1u W=3.4u AS=6.46p AD=6.46p PS=7.2u
+ PD=7.2u
* device instance $1523 r0 *1 313.6,360.9 NMOS
XM$1523 VSS \$I2292 \$I2293 VSS NMOS L=1u W=3.4u AS=6.46p AD=6.46p PS=7.2u
+ PD=7.2u
* device instance $1524 r0 *1 318.4,360.9 NMOS
XM$1524 \$I2293 WL12 BLB13 VSS NMOS L=1u W=3.4u AS=6.46p AD=10.88p PS=7.2u
+ PD=13.2u
* device instance $1525 r0 *1 308.8,262.9 PMOS
XM$1525 \$I2294 \$I2295 VDD VDD PMOS L=1u W=3.4u AS=10.88p AD=6.46p PS=13.2u
+ PD=7.2u
* device instance $1526 r0 *1 313.6,262.9 PMOS
XM$1526 VDD \$I2294 \$I2295 VDD PMOS L=1u W=3.4u AS=6.46p AD=10.88p PS=7.2u
+ PD=13.2u
* device instance $1527 r0 *1 304,242.5 NMOS
XM$1527 BL13 WL8 \$I2294 VSS NMOS L=1u W=3.4u AS=10.88p AD=6.46p PS=13.2u
+ PD=7.2u
* device instance $1528 r0 *1 308.8,242.5 NMOS
XM$1528 \$I2294 \$I2295 VSS VSS NMOS L=1u W=3.4u AS=6.46p AD=6.46p PS=7.2u
+ PD=7.2u
* device instance $1529 r0 *1 313.6,242.5 NMOS
XM$1529 VSS \$I2294 \$I2295 VSS NMOS L=1u W=3.4u AS=6.46p AD=6.46p PS=7.2u
+ PD=7.2u
* device instance $1530 r0 *1 318.4,242.5 NMOS
XM$1530 \$I2295 WL8 BLB13 VSS NMOS L=1u W=3.4u AS=6.46p AD=10.88p PS=7.2u
+ PD=13.2u
* device instance $1531 r0 *1 308.8,322.1 PMOS
XM$1531 \$I2296 \$I2297 VDD VDD PMOS L=1u W=3.4u AS=10.88p AD=6.46p PS=13.2u
+ PD=7.2u
* device instance $1532 r0 *1 313.6,322.1 PMOS
XM$1532 VDD \$I2296 \$I2297 VDD PMOS L=1u W=3.4u AS=6.46p AD=10.88p PS=7.2u
+ PD=13.2u
* device instance $1533 r0 *1 304,301.7 NMOS
XM$1533 BL13 WL10 \$I2296 VSS NMOS L=1u W=3.4u AS=10.88p AD=6.46p PS=13.2u
+ PD=7.2u
* device instance $1534 r0 *1 308.8,301.7 NMOS
XM$1534 \$I2296 \$I2297 VSS VSS NMOS L=1u W=3.4u AS=6.46p AD=6.46p PS=7.2u
+ PD=7.2u
* device instance $1535 r0 *1 313.6,301.7 NMOS
XM$1535 VSS \$I2296 \$I2297 VSS NMOS L=1u W=3.4u AS=6.46p AD=6.46p PS=7.2u
+ PD=7.2u
* device instance $1536 r0 *1 318.4,301.7 NMOS
XM$1536 \$I2297 WL10 BLB13 VSS NMOS L=1u W=3.4u AS=6.46p AD=10.88p PS=7.2u
+ PD=13.2u
.ENDS wlstrap16_16x16

.subckt sense_amp_7t BL BLB SAE SOUT SOUTB VDD VSS
*.ipin BL
*.ipin BLB
*.opin SOUT
*.opin SOUTB
*.iopin VSS
*.iopin VDD
*.ipin SAE
XXP_ISO_L SOUT SAE BL VDD PMOS w=3.4u l=1u nrd=0 nrs=0
XXP_ISO_R SOUTB SAE BLB VDD PMOS w=3.4u l=1u nrd=0 nrs=0
XXP_L SOUT SOUTB VDD VDD PMOS w=3.4u l=1u nrd=0 nrs=0
XXN_L SOUT SOUTB net1 VSS NMOS w=3.4u l=1u nrd=0 nrs=0
XXP_R SOUTB SOUT VDD VDD PMOS w=3.4u l=1u nrd=0 nrs=0
XXN_R SOUTB SOUT net1 VSS NMOS w=3.4u l=1u nrd=0 nrs=0
XXN_TAIL net1 SAE VSS VSS NMOS w=3.4u l=1u nrd=0 nrs=0
.ends
.subckt write_control DIN WRITE_EN PD_Y PD_YB VDD VSS
*.ipin DIN
*.ipin WRITE_EN
*.opin PD_Y
*.opin PD_YB
*.iopin VDD
*.iopin VSS
xdin_inv VDD DIN DIN_B VSS INV_X1
xdec0 VDD PD_Y_B DIN_B WRITE_EN VSS NAND2
xdrv0 VDD PD_Y_B PD_Y VSS INV_X1
xdec1 VDD PD_YB_B DIN WRITE_EN VSS NAND2
xdrv1 VDD PD_YB_B PD_YB VSS INV_X1
.ends
.subckt INV_X1 VDD A Y GND
*.ipin A
*.opin Y
*.iopin GND
*.iopin VDD
XM7 Y A VDD VDD PMOS w=10.2u l=1u nrd=0 nrs=0
XM2 Y A GND GND NMOS w=3.4u l=1u nrd=0 nrs=0
.ends
.subckt NAND2 VDD Y A B GND
*.ipin B
*.ipin A
*.opin Y
*.iopin GND
*.iopin VDD
XM7 Y A VDD VDD PMOS w=10.2u l=1u nrd=0 nrs=0
XM1 Y B VDD VDD PMOS w=10.2u l=1u nrd=0 nrs=0
XM2 Y B net1 GND NMOS w=3.4u l=1u nrd=0 nrs=0
XM3 net1 A GND GND NMOS w=3.4u l=1u nrd=0 nrs=0
.ends
.subckt AND2_X1 VDD Y A B GND
*.opin Y
*.ipin A
*.ipin B
*.iopin VDD
*.iopin GND
XM7 net1 B VDD VDD PMOS w=10.2u l=1u nrd=0 nrs=0
XM1 net1 A VDD VDD PMOS w=10.2u l=1u nrd=0 nrs=0
XM2 Y net1 VDD VDD PMOS w=10.2u l=1u nrd=0 nrs=0
XM3 Y net1 GND GND NMOS w=3.4u l=1u nrd=0 nrs=0
XM4 net1 A net2 GND NMOS w=3.4u l=1u nrd=0 nrs=0
XM5 net2 B GND GND NMOS w=3.4u l=1u nrd=0 nrs=0
.ends
.subckt DFFR VDD QB D Q RST GND CK
*.iopin VDD
*.iopin GND
*.ipin CK
*.ipin D
*.opin Q
*.opin QB
*.ipin RST
XM2 net2 D VDD VDD PMOS w=10.2u l=1u nrd=0 nrs=0
XM1 net3 CLK net2 VDD PMOS w=10.2u l=1u nrd=0 nrs=0
XM11 net5 net8 VDD VDD PMOS w=10.2u l=1u nrd=0 nrs=0
XM12 net3 CKB net5 VDD PMOS w=10.2u l=1u nrd=0 nrs=0
XM15 net7 net3 VDD VDD PMOS w=10.2u l=1u nrd=0 nrs=0
XM16 net8 RST net7 VDD PMOS w=10.2u l=1u nrd=0 nrs=0
XM18 net9 net8 VDD VDD PMOS w=10.2u l=1u nrd=0 nrs=0
XM19 net10 CKB net9 VDD PMOS w=10.2u l=1u nrd=0 nrs=0
XM23 net12 net14 VDD VDD PMOS w=10.2u l=1u nrd=0 nrs=0
XM24 net10 CLK net12 VDD PMOS w=10.2u l=1u nrd=0 nrs=0
XM27 net15 net10 VDD VDD PMOS w=10.2u l=1u nrd=0 nrs=0
XM28 net14 RST net15 VDD PMOS w=10.2u l=1u nrd=0 nrs=0
XM31 QB net14 VDD VDD PMOS w=10.2u l=1u nrd=0 nrs=0
XM33 Q QB VDD VDD PMOS w=10.2u l=1u nrd=0 nrs=0
XM35 QB net14 GND GND NMOS w=3.4u l=1u nrd=0 nrs=0
XM32 Q QB GND GND NMOS w=3.4u l=1u nrd=0 nrs=0
XM29 net14 RST GND GND NMOS w=3.4u l=1u nrd=0 nrs=0
XM30 net14 net10 GND GND NMOS w=3.4u l=1u nrd=0 nrs=0
XM25 net10 CKB net13 GND NMOS w=3.4u l=1u nrd=0 nrs=0
XM26 net13 net14 GND GND NMOS w=3.4u l=1u nrd=0 nrs=0
XM20 net10 CLK net11 GND NMOS w=3.4u l=1u nrd=0 nrs=0
XM21 net11 net8 GND GND NMOS w=3.4u l=1u nrd=0 nrs=0
XM17 net8 net3 GND GND NMOS w=3.4u l=1u nrd=0 nrs=0
XM22 net8 RST GND GND NMOS w=3.4u l=1u nrd=0 nrs=0
XM13 net3 CLK net6 GND NMOS w=3.4u l=1u nrd=0 nrs=0
XM14 net6 net8 GND GND NMOS w=3.4u l=1u nrd=0 nrs=0
XM7 net3 CKB net4 GND NMOS w=3.4u l=1u nrd=0 nrs=0
XM8 net4 D GND GND NMOS w=3.4u l=1u nrd=0 nrs=0
XM3 net1 CK VDD VDD PMOS w=10.2u l=1u nrd=0 nrs=0
XM4 CLK net1 VDD VDD PMOS w=10.2u l=1u nrd=0 nrs=0
XM5 CKB CLK VDD VDD PMOS w=10.2u l=1u nrd=0 nrs=0
XM34 net1 CK GND GND NMOS w=3.4u l=1u nrd=0 nrs=0
XM6 CLK net1 GND GND NMOS w=3.4u l=1u nrd=0 nrs=0
XM9 CKB CLK GND GND NMOS w=3.4u l=1u nrd=0 nrs=0
.ends
.subckt XOR2 VDD Y A B GND
*.iopin VDD
*.iopin GND
*.ipin A
*.ipin B
*.opin Y
XM10 net1 A VDD VDD PMOS w=10.2u l=1u nrd=0 nrs=0
XM1 net2 B net1 VDD PMOS w=10.2u l=1u nrd=0 nrs=0
XM8 net3 B VDD VDD PMOS w=10.2u l=1u nrd=0 nrs=0
XM2 net3 A VDD VDD PMOS w=10.2u l=1u nrd=0 nrs=0
XM9 Y net2 net3 VDD PMOS w=10.2u l=1u nrd=0 nrs=0
XM3 net2 A GND GND NMOS w=3.4u l=1u nrd=0 nrs=0
XM4 net2 B GND GND NMOS w=3.4u l=1u nrd=0 nrs=0
XM5 Y net2 GND GND NMOS w=3.4u l=1u nrd=0 nrs=0
XM7 net4 B GND GND NMOS w=3.4u l=1u nrd=0 nrs=0
XM6 Y A net4 GND NMOS w=3.4u l=1u nrd=0 nrs=0
.ends
.subckt AND3_X1 C VDD Y A B GND
*.opin Y
*.ipin A
*.ipin B
*.iopin VDD
*.iopin GND
*.ipin C
XM4 net1 C VDD VDD PMOS w=10.2u l=1u nrd=0 nrs=0
XM2 net1 B VDD VDD PMOS w=10.2u l=1u nrd=0 nrs=0
XM3 Y net1 VDD VDD PMOS w=10.2u l=1u nrd=0 nrs=0
XM1 VDD A net1 VDD PMOS w=10.2u l=1u nrd=0 nrs=0
XM8 Y net1 GND GND NMOS w=3.4u l=1u nrd=0 nrs=0
XM5 net1 A net3 GND NMOS w=3.4u l=1u nrd=0 nrs=0
XM6 net3 B net2 GND NMOS w=3.4u l=1u nrd=0 nrs=0
XM7 net2 C GND GND NMOS w=3.4u l=1u nrd=0 nrs=0
.ends
.subckt OR2 VDD Y A B GND
*.ipin A
*.ipin B
*.opin Y
*.iopin VDD
*.iopin GND
XM7 net2 B VDD VDD PMOS w=10.2u l=1u nrd=0 nrs=0
XM2 net1 A net2 VDD PMOS w=10.2u l=1u nrd=0 nrs=0
XM4 Y net1 VDD VDD PMOS w=10.2u l=1u nrd=0 nrs=0
XM1 net1 B GND GND NMOS w=3.4u l=1u nrd=0 nrs=0
XM3 net1 A GND GND NMOS w=3.4u l=1u nrd=0 nrs=0
XM5 Y net1 GND GND NMOS w=3.4u l=1u nrd=0 nrs=0
.ends
.subckt AND4_X1 D C VDD Y A B GND
*.opin Y
*.ipin A
*.ipin B
*.iopin VDD
*.iopin GND
*.ipin C
*.ipin D
XM7 net1 A net4 GND NMOS w=3.4u l=1u nrd=0 nrs=0
XM5 net3 C net2 GND NMOS w=3.4u l=1u nrd=0 nrs=0
XM8 Y net1 GND GND NMOS w=3.4u l=1u nrd=0 nrs=0
XM10 net2 D GND GND NMOS w=3.4u l=1u nrd=0 nrs=0
XM6 net4 B net3 GND NMOS w=3.4u l=1u nrd=0 nrs=0
XM11 net1 A VDD VDD PMOS w=10.2u l=1u nrd=0 nrs=0
XM1 net1 D VDD VDD PMOS w=10.2u l=1u nrd=0 nrs=0
XM3 net1 C VDD VDD PMOS w=10.2u l=1u nrd=0 nrs=0
XM4 Y net1 VDD VDD PMOS w=10.2u l=1u nrd=0 nrs=0
XM2 net1 B VDD VDD PMOS w=10.2u l=1u nrd=0 nrs=0
.ends
.subckt OR4 A B C D VDD Y GND
*.ipin B
*.ipin A
*.opin Y
*.iopin VDD
*.iopin GND
*.ipin C
*.ipin D
XM10 net1 B VDD VDD PMOS w=10.2u l=1u nrd=0 nrs=0
XM2 net2 A net1 VDD PMOS w=10.2u l=1u nrd=0 nrs=0
XM3 net4 C net2 VDD PMOS w=10.2u l=1u nrd=0 nrs=0
XM7 Y net3 VDD VDD PMOS w=10.2u l=1u nrd=0 nrs=0
XM9 net4 D net3 VDD PMOS w=10.2u l=1u nrd=0 nrs=0
XM11 net3 A GND GND NMOS w=3.4u l=1u nrd=0 nrs=0
XM1 net3 B GND GND NMOS w=3.4u l=1u nrd=0 nrs=0
XM4 net3 C GND GND NMOS w=3.4u l=1u nrd=0 nrs=0
XM5 net3 D GND GND NMOS w=3.4u l=1u nrd=0 nrs=0
XM6 Y net3 GND GND NMOS w=3.4u l=1u nrd=0 nrs=0
.ends
.subckt OR3 C VDD Y A B GND
*.ipin A
*.ipin B
*.opin Y
*.iopin VDD
*.iopin GND
*.ipin C
XM8 net1 B VDD VDD PMOS w=10.2u l=1u nrd=0 nrs=0
XM2 net2 A net1 VDD PMOS w=10.2u l=1u nrd=0 nrs=0
XM3 net3 C net2 VDD PMOS w=10.2u l=1u nrd=0 nrs=0
XM7 Y net3 VDD VDD PMOS w=10.2u l=1u nrd=0 nrs=0
XM9 Y net3 GND GND NMOS w=3.4u l=1u nrd=0 nrs=0
XM1 net3 C GND GND NMOS w=3.4u l=1u nrd=0 nrs=0
XM4 net3 A GND GND NMOS w=3.4u l=1u nrd=0 nrs=0
XM5 net3 B GND GND NMOS w=3.4u l=1u nrd=0 nrs=0
.ends
.subckt MUX2 A B S VDD Y GND
*.ipin B
*.ipin S
*.opin Y
*.iopin VDD
*.iopin GND
*.ipin A
XM13 net1 S VDD VDD PMOS w=6.8u l=1u nrd=0 nrs=0
XM9 net2 B VDD VDD PMOS w=6.8u l=1u nrd=0 nrs=0
XM8 net4 net1 net2 VDD PMOS w=6.8u l=1u nrd=0 nrs=0
XM10 Y net4 VDD VDD PMOS w=5.1u l=1u nrd=0 nrs=0 m=2
XM2 net4 S net3 VDD PMOS w=6.8u l=1u nrd=0 nrs=0
XM12 net1 S GND GND NMOS w=3.4u l=1u nrd=0 nrs=0
XM3 net2 B GND GND NMOS w=3.4u l=1u nrd=0 nrs=0
XM1 Y net4 GND GND NMOS w=3.4u l=1u nrd=0 nrs=0
XM5 net3 A GND GND NMOS w=3.4u l=1u nrd=0 nrs=0
XM6 net4 S net2 GND NMOS w=3.4u l=1u nrd=0 nrs=0 m=2
XM4 net4 net1 net3 GND NMOS w=3.4u l=1u nrd=0 nrs=0 m=2
XM7 net3 A VDD VDD PMOS w=6.8u l=1u nrd=0 nrs=0
.ends
