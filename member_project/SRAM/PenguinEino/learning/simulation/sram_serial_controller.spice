** sch_path: /home/ishi-kai/sram/sram_serial_controller.sch
.subckt sram_serial_controller CLK RESET SDI WE SOUT RA CA DIN PREB WRITE_EN WL_EN SAE SDO VDD VSS
*.PININFO CLK:I RESET:I PREB:O WL_EN:O WRITE_EN:O SAE:O SDI:I DIN:O CA:O RA:O WE:I SOUT:I SDO:O VDD:B VSS:B
xnext0 VDD NEXT0 C0B COUNT_RUN VSS AND2_X1
xcnt0 VDD C0B NEXT0 C0 RESET VSS CLK DFFR
xtoggle1 VDD net1 C1 C0 VSS XOR2
xnext1 VDD NEXT1 net1 COUNT_RUN VSS AND2_X1
xcnt1 VDD C1B NEXT1 C1 RESET VSS CLK DFFR
xtoggle2 VDD net2 C2 CARRY2 VSS XOR2
xnext2 VDD NEXT2 net2 COUNT_RUN VSS AND2_X1
xcnt2 VDD C2B NEXT2 C2 RESET VSS CLK DFFR
xtoggle3 VDD net3 C3 CARRY3 VSS XOR2
xnext3 VDD NEXT3 net3 COUNT_RUN VSS AND2_X1
xcnt3 VDD C3B NEXT3 C3 RESET VSS CLK DFFR
xcarry2 VDD CARRY2 C0 C1 VSS AND2_X1
xcarry3 C2 VDD CARRY3 C0 C1 VSS AND3_X1
xupper VDD net4 C1 C2 VSS OR2
xrun VDD COUNT_RUN C3 net4 VSS NAND2
xdecode0 C0 C1 VDD E0 C3B C2B VSS AND4_X1
xdecode1 C0B C1B VDD E1 C3B C2 VSS AND4_X1
xdecode2 C0 C1B VDD E2 C3B C2 VSS AND4_X1
xdecode3 C0B C1 VDD E3 C3B C2 VSS AND4_X1
xdecode4 C0 C1 VDD E4 C3B C2 VSS AND4_X1
xdecode5 C0B C1B VDD E5 C3 C2B VSS AND4_X1
xdecode6 C0 C1B VDD E6 C3 C2B VSS AND4_X1
xdecode7 C0B C1 VDD E7 C3 C2B VSS AND4_X1
* noconn E7
xrx_low VDD net5 C0 C1 VSS NAND2
xrx net5 VDD RX C3B C2B VSS AND3_X1
xpc VDD PREB E0 PC_ON RESET VSS CLK DFFR
* noconn PC_ON
xwl_d VDD WL_D E3 E4 VSS OR2
xwl VDD net10 WL_D WL_EN RESET VSS CLK DFFR
xwrite_window E2 E3 E4 E5 VDD WRITE_WINDOW VSS OR4
xwrite_d VDD WRITE_D WRITE_WINDOW W VSS AND2_X1
xwrite VDD net11 WRITE_D WRITE_EN RESET VSS CLK DFFR
xwe_b VDD WE net6 VSS INV_X1
xtrack_e0 VDD net8 net6 E0 VSS AND2_X1
xtrack_window E3 VDD net7 E1 E2 VSS OR3
xtrack_later VDD net9 net7 W_B VSS AND2_X1
xtrack_d VDD TRACK_D net8 net9 VSS OR2
xtrack VDD SAE TRACK_D TRACK RESET VSS CLK DFFR
* noconn TRACK
xshift0_mux SR0 SDI RX VDD xshift0_D VSS MUX2
xshift0_ff VDD net12 xshift0_D SR0 RESET VSS CLK DFFR
xshift1_mux SR1 SR0 RX VDD xshift1_D VSS MUX2
xshift1_ff VDD net13 xshift1_D SR1 RESET VSS CLK DFFR
xshift2_mux SR2 SR1 RX VDD xshift2_D VSS MUX2
xshift2_ff VDD net14 xshift2_D SR2 RESET VSS CLK DFFR
xcmd0_mux DIN SR0 E0 VDD xcmd0_D VSS MUX2
xcmd0_ff VDD net15 xcmd0_D DIN RESET VSS CLK DFFR
xcmd1_mux CA SR1 E0 VDD xcmd1_D VSS MUX2
xcmd1_ff VDD net16 xcmd1_D CA RESET VSS CLK DFFR
xcmd2_mux RA SR2 E0 VDD xcmd2_D VSS MUX2
xcmd2_ff VDD net17 xcmd2_D RA RESET VSS CLK DFFR
xcmd3_mux W WE E0 VDD xcmd3_D VSS MUX2
xcmd3_ff VDD W_B xcmd3_D W RESET VSS CLK DFFR
xread_capture VDD READ_CAPTURE E6 W_B VSS AND2_X1
xread_mux SDO SOUT READ_CAPTURE VDD xread_D VSS MUX2
xread_ff VDD net18 xread_D SDO RESET VSS CLK DFFR
* noconn #net10
* noconn #net11
* noconn #net12
* noconn #net13
* noconn #net14
* noconn #net15
* noconn #net16
* noconn #net17
* noconn #net18
.ends

* expanding   symbol:  TR-1um_5_stdcell/AND2_X1.sym # of pins=5
** sym_path: /home/ishi-kai/pdk/TR-1um/libs.tech/xschem/TR-1um_5_stdcell/AND2_X1.sym
** sch_path: /home/ishi-kai/pdk/TR-1um/libs.tech/xschem/TR-1um_5_stdcell/AND2_X1.sch
.subckt AND2_X1 VDD Y A B GND
*.PININFO Y:O A:I B:I VDD:B GND:B
MM7 net1 B VDD VDD PMOS w=10.2u l=1u
MM1 net1 A VDD VDD PMOS w=10.2u l=1u
MM2 Y net1 VDD VDD PMOS w=10.2u l=1u
MM3 Y net1 GND GND NMOS w=3.4u l=1u
MM4 net1 A net2 GND NMOS w=3.4u l=1u
MM5 net2 B GND GND NMOS w=3.4u l=1u
.ends

* expanding   symbol:  TR-1um_5_stdcell/DFFR.sym # of pins=7
** sym_path: /home/ishi-kai/pdk/TR-1um/libs.tech/xschem/TR-1um_5_stdcell/DFFR.sym
** sch_path: /home/ishi-kai/pdk/TR-1um/libs.tech/xschem/TR-1um_5_stdcell/DFFR.sch
.subckt DFFR VDD QB D Q RST GND CK
*.PININFO VDD:B GND:B CK:I D:I Q:O QB:O RST:I
MM2 net2 D VDD VDD PMOS w=10.2u l=1u
MM1 net3 CLK net2 VDD PMOS w=10.2u l=1u
MM11 net5 net8 VDD VDD PMOS w=10.2u l=1u
MM12 net3 CKB net5 VDD PMOS w=10.2u l=1u
MM15 net7 net3 VDD VDD PMOS w=10.2u l=1u
MM16 net8 RST net7 VDD PMOS w=10.2u l=1u
MM18 net9 net8 VDD VDD PMOS w=10.2u l=1u
MM19 net10 CKB net9 VDD PMOS w=10.2u l=1u
MM23 net12 net14 VDD VDD PMOS w=10.2u l=1u
MM24 net10 CLK net12 VDD PMOS w=10.2u l=1u
MM27 net15 net10 VDD VDD PMOS w=10.2u l=1u
MM28 net14 RST net15 VDD PMOS w=10.2u l=1u
MM31 QB net14 VDD VDD PMOS w=10.2u l=1u
MM33 Q QB VDD VDD PMOS w=10.2u l=1u
MM35 QB net14 GND GND NMOS w=3.4u l=1u
MM32 Q QB GND GND NMOS w=3.4u l=1u
MM29 net14 RST GND GND NMOS w=3.4u l=1u
MM30 net14 net10 GND GND NMOS w=3.4u l=1u
MM25 net10 CKB net13 GND NMOS w=3.4u l=1u
MM26 net13 net14 GND GND NMOS w=3.4u l=1u
MM20 net10 CLK net11 GND NMOS w=3.4u l=1u
MM21 net11 net8 GND GND NMOS w=3.4u l=1u
MM17 net8 net3 GND GND NMOS w=3.4u l=1u
MM22 net8 RST GND GND NMOS w=3.4u l=1u
MM13 net3 CLK net6 GND NMOS w=3.4u l=1u
MM14 net6 net8 GND GND NMOS w=3.4u l=1u
MM7 net3 CKB net4 GND NMOS w=3.4u l=1u
MM8 net4 D GND GND NMOS w=3.4u l=1u
MM3 net1 CK VDD VDD PMOS w=10.2u l=1u
MM4 CLK net1 VDD VDD PMOS w=10.2u l=1u
MM5 CKB CLK VDD VDD PMOS w=10.2u l=1u
MM34 net1 CK GND GND NMOS w=3.4u l=1u
MM6 CLK net1 GND GND NMOS w=3.4u l=1u
MM9 CKB CLK GND GND NMOS w=3.4u l=1u
.ends

* expanding   symbol:  TR-1um_5_stdcell/XOR2.sym # of pins=5
** sym_path: /home/ishi-kai/pdk/TR-1um/libs.tech/xschem/TR-1um_5_stdcell/XOR2.sym
** sch_path: /home/ishi-kai/pdk/TR-1um/libs.tech/xschem/TR-1um_5_stdcell/XOR2.sch
.subckt XOR2 VDD Y A B GND
*.PININFO VDD:B GND:B A:I B:I Y:O
MM10 net1 A VDD VDD PMOS w=10.2u l=1u
MM1 net2 B net1 VDD PMOS w=10.2u l=1u
MM8 net3 B VDD VDD PMOS w=10.2u l=1u
MM2 net3 A VDD VDD PMOS w=10.2u l=1u
MM9 Y net2 net3 VDD PMOS w=10.2u l=1u
MM3 net2 A GND GND NMOS w=3.4u l=1u
MM4 net2 B GND GND NMOS w=3.4u l=1u
MM5 Y net2 GND GND NMOS w=3.4u l=1u
MM7 net4 B GND GND NMOS w=3.4u l=1u
MM6 Y A net4 GND NMOS w=3.4u l=1u
.ends

* expanding   symbol:  TR-1um_5_stdcell/AND3_X1.sym # of pins=6
** sym_path: /home/ishi-kai/pdk/TR-1um/libs.tech/xschem/TR-1um_5_stdcell/AND3_X1.sym
** sch_path: /home/ishi-kai/pdk/TR-1um/libs.tech/xschem/TR-1um_5_stdcell/AND3_X1.sch
.subckt AND3_X1 C VDD Y A B GND
*.PININFO Y:O A:I B:I VDD:B GND:B C:I
MM4 net1 C VDD VDD PMOS w=10.2u l=1u
MM2 net1 B VDD VDD PMOS w=10.2u l=1u
MM3 Y net1 VDD VDD PMOS w=10.2u l=1u
MM1 VDD A net1 VDD PMOS w=10.2u l=1u
MM8 Y net1 GND GND NMOS w=3.4u l=1u
MM5 net1 A net3 GND NMOS w=3.4u l=1u
MM6 net3 B net2 GND NMOS w=3.4u l=1u
MM7 net2 C GND GND NMOS w=3.4u l=1u
.ends

* expanding   symbol:  TR-1um_5_stdcell/OR2.sym # of pins=5
** sym_path: /home/ishi-kai/pdk/TR-1um/libs.tech/xschem/TR-1um_5_stdcell/OR2.sym
** sch_path: /home/ishi-kai/pdk/TR-1um/libs.tech/xschem/TR-1um_5_stdcell/OR2.sch
.subckt OR2 VDD Y A B GND
*.PININFO A:I B:I Y:O VDD:B GND:B
MM7 net2 B VDD VDD PMOS w=10.2u l=1u
MM2 net1 A net2 VDD PMOS w=10.2u l=1u
MM4 Y net1 VDD VDD PMOS w=10.2u l=1u
MM1 net1 B GND GND NMOS w=3.4u l=1u
MM3 net1 A GND GND NMOS w=3.4u l=1u
MM5 Y net1 GND GND NMOS w=3.4u l=1u
.ends

* expanding   symbol:  TR-1um_5_stdcell/NAND2.sym # of pins=5
** sym_path: /home/ishi-kai/pdk/TR-1um/libs.tech/xschem/TR-1um_5_stdcell/NAND2.sym
** sch_path: /home/ishi-kai/pdk/TR-1um/libs.tech/xschem/TR-1um_5_stdcell/NAND2.sch
.subckt NAND2 VDD Y A B GND
*.PININFO B:I A:I Y:O GND:B VDD:B
MM7 Y A VDD VDD PMOS w=10.2u l=1u
MM1 Y B VDD VDD PMOS w=10.2u l=1u
MM2 Y B net1 GND NMOS w=3.4u l=1u
MM3 net1 A GND GND NMOS w=3.4u l=1u
.ends

* expanding   symbol:  TR-1um_5_stdcell/AND4_X1.sym # of pins=7
** sym_path: /home/ishi-kai/pdk/TR-1um/libs.tech/xschem/TR-1um_5_stdcell/AND4_X1.sym
** sch_path: /home/ishi-kai/pdk/TR-1um/libs.tech/xschem/TR-1um_5_stdcell/AND4_X1.sch
.subckt AND4_X1 D C VDD Y A B GND
*.PININFO Y:O A:I B:I VDD:B GND:B C:I D:I
MM7 net1 A net4 GND NMOS w=3.4u l=1u
MM5 net3 C net2 GND NMOS w=3.4u l=1u
MM8 Y net1 GND GND NMOS w=3.4u l=1u
MM10 net2 D GND GND NMOS w=3.4u l=1u
MM6 net4 B net3 GND NMOS w=3.4u l=1u
MM11 net1 A VDD VDD PMOS w=10.2u l=1u
MM1 net1 D VDD VDD PMOS w=10.2u l=1u
MM3 net1 C VDD VDD PMOS w=10.2u l=1u
MM4 Y net1 VDD VDD PMOS w=10.2u l=1u
MM2 net1 B VDD VDD PMOS w=10.2u l=1u
.ends

* expanding   symbol:  TR-1um_5_stdcell/OR4.sym # of pins=7
** sym_path: /home/ishi-kai/pdk/TR-1um/libs.tech/xschem/TR-1um_5_stdcell/OR4.sym
** sch_path: /home/ishi-kai/pdk/TR-1um/libs.tech/xschem/TR-1um_5_stdcell/OR4.sch
.subckt OR4 A B C D VDD Y GND
*.PININFO B:I A:I Y:O VDD:B GND:B C:I D:I
MM10 net1 B VDD VDD PMOS w=10.2u l=1u
MM2 net2 A net1 VDD PMOS w=10.2u l=1u
MM3 net4 C net2 VDD PMOS w=10.2u l=1u
MM7 Y net3 VDD VDD PMOS w=10.2u l=1u
MM9 net4 D net3 VDD PMOS w=10.2u l=1u
MM11 net3 A GND GND NMOS w=3.4u l=1u
MM1 net3 B GND GND NMOS w=3.4u l=1u
MM4 net3 C GND GND NMOS w=3.4u l=1u
MM5 net3 D GND GND NMOS w=3.4u l=1u
MM6 Y net3 GND GND NMOS w=3.4u l=1u
.ends

* expanding   symbol:  TR-1um_5_stdcell/INV_X1.sym # of pins=4
** sym_path: /home/ishi-kai/pdk/TR-1um/libs.tech/xschem/TR-1um_5_stdcell/INV_X1.sym
** sch_path: /home/ishi-kai/pdk/TR-1um/libs.tech/xschem/TR-1um_5_stdcell/INV_X1.sch
.subckt INV_X1 VDD A Y GND
*.PININFO A:I Y:O GND:B VDD:B
MM7 Y A VDD VDD PMOS w=10.2u l=1u
MM2 Y A GND GND NMOS w=3.4u l=1u
.ends

* expanding   symbol:  TR-1um_5_stdcell/OR3.sym # of pins=6
** sym_path: /home/ishi-kai/pdk/TR-1um/libs.tech/xschem/TR-1um_5_stdcell/OR3.sym
** sch_path: /home/ishi-kai/pdk/TR-1um/libs.tech/xschem/TR-1um_5_stdcell/OR3.sch
.subckt OR3 C VDD Y A B GND
*.PININFO A:I B:I Y:O VDD:B GND:B C:I
MM8 net1 B VDD VDD PMOS w=10.2u l=1u
MM2 net2 A net1 VDD PMOS w=10.2u l=1u
MM3 net3 C net2 VDD PMOS w=10.2u l=1u
MM7 Y net3 VDD VDD PMOS w=10.2u l=1u
MM9 Y net3 GND GND NMOS w=3.4u l=1u
MM1 net3 C GND GND NMOS w=3.4u l=1u
MM4 net3 A GND GND NMOS w=3.4u l=1u
MM5 net3 B GND GND NMOS w=3.4u l=1u
.ends

* expanding   symbol:  TR-1um_5_stdcell/MUX2.sym # of pins=6
** sym_path: /home/ishi-kai/pdk/TR-1um/libs.tech/xschem/TR-1um_5_stdcell/MUX2.sym
** sch_path: /home/ishi-kai/pdk/TR-1um/libs.tech/xschem/TR-1um_5_stdcell/MUX2.sch
.subckt MUX2 A B S VDD Y GND
*.PININFO B:I S:I Y:O VDD:B GND:B A:I
MM13 net1 S VDD VDD PMOS w=6.8u l=1u
MM9 net2 B VDD VDD PMOS w=6.8u l=1u
MM8 net4 net1 net2 VDD PMOS w=6.8u l=1u
MM10 Y net4 VDD VDD PMOS w=5.1u l=1u m=2
MM2 net4 S net3 VDD PMOS w=6.8u l=1u
MM12 net1 S GND GND NMOS w=3.4u l=1u
MM3 net2 B GND GND NMOS w=3.4u l=1u
MM1 Y net4 GND GND NMOS w=3.4u l=1u
MM5 net3 A GND GND NMOS w=3.4u l=1u
MM6 net4 S net2 GND NMOS w=3.4u l=1u m=2
MM4 net4 net1 net3 GND NMOS w=3.4u l=1u m=2
MM7 net3 A VDD VDD PMOS w=6.8u l=1u
.ends
