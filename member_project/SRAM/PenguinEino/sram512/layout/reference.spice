** sch_path: /home/ishi-kai/sram/sram512_macro.sch
.subckt sram512_macro CLK RESET SDI WE SDO VDD VSS
*.PININFO CLK:I RESET:I SDI:I WE:I SDO:O VDD:B VSS:B
xcore CLK RESET SDI WE SDO VDD VSS sram512
.ends

* expanding   symbol:  sram512.sym # of pins=7
** sym_path: /home/ishi-kai/sram/sram512.sym
** sch_path: /home/ishi-kai/sram/sram512.sch
.subckt sram512 CLK RESET SDI WE SDO VDD VSS
*.PININFO CLK:I RESET:I SDI:I WE:I SDO:O VDD:B VSS:B
xarray WL0 WL1 WL2 WL3 WL4 WL5 WL6 WL7 WL8 WL9 WL10 WL11 WL12 WL13 WL14 WL15 BL0 BLB0 BL1 BLB1 BL2 BLB2 BL3 BLB3 BL4 BLB4 BL5 BLB5
+ BL6 BLB6 BL7 BLB7 BL8 BLB8 BL9 BLB9 BL10 BLB10 BL11 BLB11 BL12 BLB12 BL13 BLB13 BL14 BLB14 BL15 BLB15 BL16 BLB16 BL17 BLB17 BL18
+ BLB18 BL19 BLB19 BL20 BLB20 BL21 BLB21 BL22 BLB22 BL23 BLB23 BL24 BLB24 BL25 BLB25 BL26 BLB26 BL27 BLB27 BL28 BLB28 BL29 BLB29 BL30
+ BLB30 BL31 BLB31 VDD VSS sram512_array
xrow RA0 RA1 RA2 RA3 WL_EN WL0 WL1 WL2 WL3 WL4 WL5 WL6 WL7 WL8 WL9 WL10 WL11 WL12 WL13 WL14 WL15 VDD VSS sram512_row_decoder
xcol0 BL0 BLB0 Y YB COL0 PREB VDD VSS sram512_column
xcol1 BL1 BLB1 Y YB COL1 PREB VDD VSS sram512_column
xcol2 BL2 BLB2 Y YB COL2 PREB VDD VSS sram512_column
xcol3 BL3 BLB3 Y YB COL3 PREB VDD VSS sram512_column
xcol4 BL4 BLB4 Y YB COL4 PREB VDD VSS sram512_column
xcol5 BL5 BLB5 Y YB COL5 PREB VDD VSS sram512_column
xcol6 BL6 BLB6 Y YB COL6 PREB VDD VSS sram512_column
xcol7 BL7 BLB7 Y YB COL7 PREB VDD VSS sram512_column
xcol8 BL8 BLB8 Y YB COL8 PREB VDD VSS sram512_column
xcol9 BL9 BLB9 Y YB COL9 PREB VDD VSS sram512_column
xcol10 BL10 BLB10 Y YB COL10 PREB VDD VSS sram512_column
xcol11 BL11 BLB11 Y YB COL11 PREB VDD VSS sram512_column
xcol12 BL12 BLB12 Y YB COL12 PREB VDD VSS sram512_column
xcol13 BL13 BLB13 Y YB COL13 PREB VDD VSS sram512_column
xcol14 BL14 BLB14 Y YB COL14 PREB VDD VSS sram512_column
xcol15 BL15 BLB15 Y YB COL15 PREB VDD VSS sram512_column
xcol16 BL16 BLB16 Y YB COL16 PREB VDD VSS sram512_column
xcol17 BL17 BLB17 Y YB COL17 PREB VDD VSS sram512_column
xcol18 BL18 BLB18 Y YB COL18 PREB VDD VSS sram512_column
xcol19 BL19 BLB19 Y YB COL19 PREB VDD VSS sram512_column
xcol20 BL20 BLB20 Y YB COL20 PREB VDD VSS sram512_column
xcol21 BL21 BLB21 Y YB COL21 PREB VDD VSS sram512_column
xcol22 BL22 BLB22 Y YB COL22 PREB VDD VSS sram512_column
xcol23 BL23 BLB23 Y YB COL23 PREB VDD VSS sram512_column
xcol24 BL24 BLB24 Y YB COL24 PREB VDD VSS sram512_column
xcol25 BL25 BLB25 Y YB COL25 PREB VDD VSS sram512_column
xcol26 BL26 BLB26 Y YB COL26 PREB VDD VSS sram512_column
xcol27 BL27 BLB27 Y YB COL27 PREB VDD VSS sram512_column
xcol28 BL28 BLB28 Y YB COL28 PREB VDD VSS sram512_column
xcol29 BL29 BLB29 Y YB COL29 PREB VDD VSS sram512_column
xcol30 BL30 BLB30 Y YB COL30 PREB VDD VSS sram512_column
xcol31 BL31 BLB31 Y YB COL31 PREB VDD VSS sram512_column
xcol_decode COL0 COL1 COL2 COL3 COL4 COL5 COL6 COL7 COL8 COL9 COL10 COL11 COL12 COL13 COL14 COL15 COL16 COL17 COL18 COL19 COL20
+ COL21 COL22 COL23 COL24 COL25 COL26 COL27 COL28 COL29 COL30 COL31 CA0 CA0B CA1 CA1B CA2 CA2B CA3 CA3B CA4 CA4B VDD VSS
+ sram512_col_decoder
xsense Y YB SAE SOUT SOUTB VDD VSS sense_amp_7t
Mxpc_Y Y PREB VDD VDD PMOS w=10.2u l=1u
Mxwrite_Y Y PD_Y VSS VSS NMOS w=10.2u l=1u
xwrite_data0 VDD PD_Y DINB WRITE_EN VSS AND2_X1
Mxpc_YB YB PREB VDD VDD PMOS w=10.2u l=1u
Mxwrite_YB YB PD_YB VSS VSS NMOS w=10.2u l=1u
xwrite_data1 VDD PD_YB DIN WRITE_EN VSS AND2_X1
xctrl CLK RESET SDI WE SOUT DIN DINB CA0 CA0B CA1 CA1B CA2 CA2B CA3 CA3B CA4 CA4B RA0 RA0B RA1 RA1B RA2 RA2B RA3 RA3B PREB SAE
+ WL_EN WRITE_EN SDO VDD VSS sram512_controller
xinput_clk CLK VDD VSS sram512_input_clamp
xinput_reset RESET VDD VSS sram512_input_clamp
xinput_sdi SDI VDD VSS sram512_input_clamp
xinput_we WE VDD VSS sram512_input_clamp
* noconn SOUTB
* noconn RA0B
* noconn RA1B
* noconn RA2B
* noconn RA3B
.ends

* expanding   symbol:  sram512_array.sym # of pins=82
** sym_path: /home/ishi-kai/sram/sram512_array.sym
** sch_path: /home/ishi-kai/sram/sram512_array.sch
.subckt sram512_array WL0 WL1 WL2 WL3 WL4 WL5 WL6 WL7 WL8 WL9 WL10 WL11 WL12 WL13 WL14 WL15 BL0 BLB0 BL1 BLB1 BL2 BLB2 BL3 BLB3
+ BL4 BLB4 BL5 BLB5 BL6 BLB6 BL7 BLB7 BL8 BLB8 BL9 BLB9 BL10 BLB10 BL11 BLB11 BL12 BLB12 BL13 BLB13 BL14 BLB14 BL15 BLB15 BL16 BLB16
+ BL17 BLB17 BL18 BLB18 BL19 BLB19 BL20 BLB20 BL21 BLB21 BL22 BLB22 BL23 BLB23 BL24 BLB24 BL25 BLB25 BL26 BLB26 BL27 BLB27 BL28 BLB28
+ BL29 BLB29 BL30 BLB30 BL31 BLB31 VDD VSS
*.PININFO WL0:I WL1:I WL2:I WL3:I WL4:I WL5:I WL6:I WL7:I WL8:I WL9:I WL10:I WL11:I WL12:I WL13:I WL14:I WL15:I BL0:B BLB0:B BL1:B
*+ BLB1:B BL2:B BLB2:B BL3:B BLB3:B BL4:B BLB4:B BL5:B BLB5:B BL6:B BLB6:B BL7:B BLB7:B BL8:B BLB8:B BL9:B BLB9:B BL10:B BLB10:B BL11:B
*+ BLB11:B BL12:B BLB12:B BL13:B BLB13:B BL14:B BLB14:B BL15:B BLB15:B BL16:B BLB16:B BL17:B BLB17:B BL18:B BLB18:B BL19:B BLB19:B BL20:B
*+ BLB20:B BL21:B BLB21:B BL22:B BLB22:B BL23:B BLB23:B BL24:B BLB24:B BL25:B BLB25:B BL26:B BLB26:B BL27:B BLB27:B BL28:B BLB28:B BL29:B
*+ BLB29:B BL30:B BLB30:B BL31:B BLB31:B VDD:B VSS:B
xr0c0 WL0 BL0 BLB0 VDD VSS sram512_bitcell
xr0c1 WL0 BL1 BLB1 VDD VSS sram512_bitcell
xr0c2 WL0 BL2 BLB2 VDD VSS sram512_bitcell
xr0c3 WL0 BL3 BLB3 VDD VSS sram512_bitcell
xr0c4 WL0 BL4 BLB4 VDD VSS sram512_bitcell
xr0c5 WL0 BL5 BLB5 VDD VSS sram512_bitcell
xr0c6 WL0 BL6 BLB6 VDD VSS sram512_bitcell
xr0c7 WL0 BL7 BLB7 VDD VSS sram512_bitcell
xr0c8 WL0 BL8 BLB8 VDD VSS sram512_bitcell
xr0c9 WL0 BL9 BLB9 VDD VSS sram512_bitcell
xr0c10 WL0 BL10 BLB10 VDD VSS sram512_bitcell
xr0c11 WL0 BL11 BLB11 VDD VSS sram512_bitcell
xr0c12 WL0 BL12 BLB12 VDD VSS sram512_bitcell
xr0c13 WL0 BL13 BLB13 VDD VSS sram512_bitcell
xr0c14 WL0 BL14 BLB14 VDD VSS sram512_bitcell
xr0c15 WL0 BL15 BLB15 VDD VSS sram512_bitcell
xr0c16 WL0 BL16 BLB16 VDD VSS sram512_bitcell
xr0c17 WL0 BL17 BLB17 VDD VSS sram512_bitcell
xr0c18 WL0 BL18 BLB18 VDD VSS sram512_bitcell
xr0c19 WL0 BL19 BLB19 VDD VSS sram512_bitcell
xr0c20 WL0 BL20 BLB20 VDD VSS sram512_bitcell
xr0c21 WL0 BL21 BLB21 VDD VSS sram512_bitcell
xr0c22 WL0 BL22 BLB22 VDD VSS sram512_bitcell
xr0c23 WL0 BL23 BLB23 VDD VSS sram512_bitcell
xr0c24 WL0 BL24 BLB24 VDD VSS sram512_bitcell
xr0c25 WL0 BL25 BLB25 VDD VSS sram512_bitcell
xr0c26 WL0 BL26 BLB26 VDD VSS sram512_bitcell
xr0c27 WL0 BL27 BLB27 VDD VSS sram512_bitcell
xr0c28 WL0 BL28 BLB28 VDD VSS sram512_bitcell
xr0c29 WL0 BL29 BLB29 VDD VSS sram512_bitcell
xr0c30 WL0 BL30 BLB30 VDD VSS sram512_bitcell
xr0c31 WL0 BL31 BLB31 VDD VSS sram512_bitcell
xr1c0 WL1 BL0 BLB0 VDD VSS sram512_bitcell
xr1c1 WL1 BL1 BLB1 VDD VSS sram512_bitcell
xr1c2 WL1 BL2 BLB2 VDD VSS sram512_bitcell
xr1c3 WL1 BL3 BLB3 VDD VSS sram512_bitcell
xr1c4 WL1 BL4 BLB4 VDD VSS sram512_bitcell
xr1c5 WL1 BL5 BLB5 VDD VSS sram512_bitcell
xr1c6 WL1 BL6 BLB6 VDD VSS sram512_bitcell
xr1c7 WL1 BL7 BLB7 VDD VSS sram512_bitcell
xr1c8 WL1 BL8 BLB8 VDD VSS sram512_bitcell
xr1c9 WL1 BL9 BLB9 VDD VSS sram512_bitcell
xr1c10 WL1 BL10 BLB10 VDD VSS sram512_bitcell
xr1c11 WL1 BL11 BLB11 VDD VSS sram512_bitcell
xr1c12 WL1 BL12 BLB12 VDD VSS sram512_bitcell
xr1c13 WL1 BL13 BLB13 VDD VSS sram512_bitcell
xr1c14 WL1 BL14 BLB14 VDD VSS sram512_bitcell
xr1c15 WL1 BL15 BLB15 VDD VSS sram512_bitcell
xr1c16 WL1 BL16 BLB16 VDD VSS sram512_bitcell
xr1c17 WL1 BL17 BLB17 VDD VSS sram512_bitcell
xr1c18 WL1 BL18 BLB18 VDD VSS sram512_bitcell
xr1c19 WL1 BL19 BLB19 VDD VSS sram512_bitcell
xr1c20 WL1 BL20 BLB20 VDD VSS sram512_bitcell
xr1c21 WL1 BL21 BLB21 VDD VSS sram512_bitcell
xr1c22 WL1 BL22 BLB22 VDD VSS sram512_bitcell
xr1c23 WL1 BL23 BLB23 VDD VSS sram512_bitcell
xr1c24 WL1 BL24 BLB24 VDD VSS sram512_bitcell
xr1c25 WL1 BL25 BLB25 VDD VSS sram512_bitcell
xr1c26 WL1 BL26 BLB26 VDD VSS sram512_bitcell
xr1c27 WL1 BL27 BLB27 VDD VSS sram512_bitcell
xr1c28 WL1 BL28 BLB28 VDD VSS sram512_bitcell
xr1c29 WL1 BL29 BLB29 VDD VSS sram512_bitcell
xr1c30 WL1 BL30 BLB30 VDD VSS sram512_bitcell
xr1c31 WL1 BL31 BLB31 VDD VSS sram512_bitcell
xr2c0 WL2 BL0 BLB0 VDD VSS sram512_bitcell
xr2c1 WL2 BL1 BLB1 VDD VSS sram512_bitcell
xr2c2 WL2 BL2 BLB2 VDD VSS sram512_bitcell
xr2c3 WL2 BL3 BLB3 VDD VSS sram512_bitcell
xr2c4 WL2 BL4 BLB4 VDD VSS sram512_bitcell
xr2c5 WL2 BL5 BLB5 VDD VSS sram512_bitcell
xr2c6 WL2 BL6 BLB6 VDD VSS sram512_bitcell
xr2c7 WL2 BL7 BLB7 VDD VSS sram512_bitcell
xr2c8 WL2 BL8 BLB8 VDD VSS sram512_bitcell
xr2c9 WL2 BL9 BLB9 VDD VSS sram512_bitcell
xr2c10 WL2 BL10 BLB10 VDD VSS sram512_bitcell
xr2c11 WL2 BL11 BLB11 VDD VSS sram512_bitcell
xr2c12 WL2 BL12 BLB12 VDD VSS sram512_bitcell
xr2c13 WL2 BL13 BLB13 VDD VSS sram512_bitcell
xr2c14 WL2 BL14 BLB14 VDD VSS sram512_bitcell
xr2c15 WL2 BL15 BLB15 VDD VSS sram512_bitcell
xr2c16 WL2 BL16 BLB16 VDD VSS sram512_bitcell
xr2c17 WL2 BL17 BLB17 VDD VSS sram512_bitcell
xr2c18 WL2 BL18 BLB18 VDD VSS sram512_bitcell
xr2c19 WL2 BL19 BLB19 VDD VSS sram512_bitcell
xr2c20 WL2 BL20 BLB20 VDD VSS sram512_bitcell
xr2c21 WL2 BL21 BLB21 VDD VSS sram512_bitcell
xr2c22 WL2 BL22 BLB22 VDD VSS sram512_bitcell
xr2c23 WL2 BL23 BLB23 VDD VSS sram512_bitcell
xr2c24 WL2 BL24 BLB24 VDD VSS sram512_bitcell
xr2c25 WL2 BL25 BLB25 VDD VSS sram512_bitcell
xr2c26 WL2 BL26 BLB26 VDD VSS sram512_bitcell
xr2c27 WL2 BL27 BLB27 VDD VSS sram512_bitcell
xr2c28 WL2 BL28 BLB28 VDD VSS sram512_bitcell
xr2c29 WL2 BL29 BLB29 VDD VSS sram512_bitcell
xr2c30 WL2 BL30 BLB30 VDD VSS sram512_bitcell
xr2c31 WL2 BL31 BLB31 VDD VSS sram512_bitcell
xr3c0 WL3 BL0 BLB0 VDD VSS sram512_bitcell
xr3c1 WL3 BL1 BLB1 VDD VSS sram512_bitcell
xr3c2 WL3 BL2 BLB2 VDD VSS sram512_bitcell
xr3c3 WL3 BL3 BLB3 VDD VSS sram512_bitcell
xr3c4 WL3 BL4 BLB4 VDD VSS sram512_bitcell
xr3c5 WL3 BL5 BLB5 VDD VSS sram512_bitcell
xr3c6 WL3 BL6 BLB6 VDD VSS sram512_bitcell
xr3c7 WL3 BL7 BLB7 VDD VSS sram512_bitcell
xr3c8 WL3 BL8 BLB8 VDD VSS sram512_bitcell
xr3c9 WL3 BL9 BLB9 VDD VSS sram512_bitcell
xr3c10 WL3 BL10 BLB10 VDD VSS sram512_bitcell
xr3c11 WL3 BL11 BLB11 VDD VSS sram512_bitcell
xr3c12 WL3 BL12 BLB12 VDD VSS sram512_bitcell
xr3c13 WL3 BL13 BLB13 VDD VSS sram512_bitcell
xr3c14 WL3 BL14 BLB14 VDD VSS sram512_bitcell
xr3c15 WL3 BL15 BLB15 VDD VSS sram512_bitcell
xr3c16 WL3 BL16 BLB16 VDD VSS sram512_bitcell
xr3c17 WL3 BL17 BLB17 VDD VSS sram512_bitcell
xr3c18 WL3 BL18 BLB18 VDD VSS sram512_bitcell
xr3c19 WL3 BL19 BLB19 VDD VSS sram512_bitcell
xr3c20 WL3 BL20 BLB20 VDD VSS sram512_bitcell
xr3c21 WL3 BL21 BLB21 VDD VSS sram512_bitcell
xr3c22 WL3 BL22 BLB22 VDD VSS sram512_bitcell
xr3c23 WL3 BL23 BLB23 VDD VSS sram512_bitcell
xr3c24 WL3 BL24 BLB24 VDD VSS sram512_bitcell
xr3c25 WL3 BL25 BLB25 VDD VSS sram512_bitcell
xr3c26 WL3 BL26 BLB26 VDD VSS sram512_bitcell
xr3c27 WL3 BL27 BLB27 VDD VSS sram512_bitcell
xr3c28 WL3 BL28 BLB28 VDD VSS sram512_bitcell
xr3c29 WL3 BL29 BLB29 VDD VSS sram512_bitcell
xr3c30 WL3 BL30 BLB30 VDD VSS sram512_bitcell
xr3c31 WL3 BL31 BLB31 VDD VSS sram512_bitcell
xr4c0 WL4 BL0 BLB0 VDD VSS sram512_bitcell
xr4c1 WL4 BL1 BLB1 VDD VSS sram512_bitcell
xr4c2 WL4 BL2 BLB2 VDD VSS sram512_bitcell
xr4c3 WL4 BL3 BLB3 VDD VSS sram512_bitcell
xr4c4 WL4 BL4 BLB4 VDD VSS sram512_bitcell
xr4c5 WL4 BL5 BLB5 VDD VSS sram512_bitcell
xr4c6 WL4 BL6 BLB6 VDD VSS sram512_bitcell
xr4c7 WL4 BL7 BLB7 VDD VSS sram512_bitcell
xr4c8 WL4 BL8 BLB8 VDD VSS sram512_bitcell
xr4c9 WL4 BL9 BLB9 VDD VSS sram512_bitcell
xr4c10 WL4 BL10 BLB10 VDD VSS sram512_bitcell
xr4c11 WL4 BL11 BLB11 VDD VSS sram512_bitcell
xr4c12 WL4 BL12 BLB12 VDD VSS sram512_bitcell
xr4c13 WL4 BL13 BLB13 VDD VSS sram512_bitcell
xr4c14 WL4 BL14 BLB14 VDD VSS sram512_bitcell
xr4c15 WL4 BL15 BLB15 VDD VSS sram512_bitcell
xr4c16 WL4 BL16 BLB16 VDD VSS sram512_bitcell
xr4c17 WL4 BL17 BLB17 VDD VSS sram512_bitcell
xr4c18 WL4 BL18 BLB18 VDD VSS sram512_bitcell
xr4c19 WL4 BL19 BLB19 VDD VSS sram512_bitcell
xr4c20 WL4 BL20 BLB20 VDD VSS sram512_bitcell
xr4c21 WL4 BL21 BLB21 VDD VSS sram512_bitcell
xr4c22 WL4 BL22 BLB22 VDD VSS sram512_bitcell
xr4c23 WL4 BL23 BLB23 VDD VSS sram512_bitcell
xr4c24 WL4 BL24 BLB24 VDD VSS sram512_bitcell
xr4c25 WL4 BL25 BLB25 VDD VSS sram512_bitcell
xr4c26 WL4 BL26 BLB26 VDD VSS sram512_bitcell
xr4c27 WL4 BL27 BLB27 VDD VSS sram512_bitcell
xr4c28 WL4 BL28 BLB28 VDD VSS sram512_bitcell
xr4c29 WL4 BL29 BLB29 VDD VSS sram512_bitcell
xr4c30 WL4 BL30 BLB30 VDD VSS sram512_bitcell
xr4c31 WL4 BL31 BLB31 VDD VSS sram512_bitcell
xr5c0 WL5 BL0 BLB0 VDD VSS sram512_bitcell
xr5c1 WL5 BL1 BLB1 VDD VSS sram512_bitcell
xr5c2 WL5 BL2 BLB2 VDD VSS sram512_bitcell
xr5c3 WL5 BL3 BLB3 VDD VSS sram512_bitcell
xr5c4 WL5 BL4 BLB4 VDD VSS sram512_bitcell
xr5c5 WL5 BL5 BLB5 VDD VSS sram512_bitcell
xr5c6 WL5 BL6 BLB6 VDD VSS sram512_bitcell
xr5c7 WL5 BL7 BLB7 VDD VSS sram512_bitcell
xr5c8 WL5 BL8 BLB8 VDD VSS sram512_bitcell
xr5c9 WL5 BL9 BLB9 VDD VSS sram512_bitcell
xr5c10 WL5 BL10 BLB10 VDD VSS sram512_bitcell
xr5c11 WL5 BL11 BLB11 VDD VSS sram512_bitcell
xr5c12 WL5 BL12 BLB12 VDD VSS sram512_bitcell
xr5c13 WL5 BL13 BLB13 VDD VSS sram512_bitcell
xr5c14 WL5 BL14 BLB14 VDD VSS sram512_bitcell
xr5c15 WL5 BL15 BLB15 VDD VSS sram512_bitcell
xr5c16 WL5 BL16 BLB16 VDD VSS sram512_bitcell
xr5c17 WL5 BL17 BLB17 VDD VSS sram512_bitcell
xr5c18 WL5 BL18 BLB18 VDD VSS sram512_bitcell
xr5c19 WL5 BL19 BLB19 VDD VSS sram512_bitcell
xr5c20 WL5 BL20 BLB20 VDD VSS sram512_bitcell
xr5c21 WL5 BL21 BLB21 VDD VSS sram512_bitcell
xr5c22 WL5 BL22 BLB22 VDD VSS sram512_bitcell
xr5c23 WL5 BL23 BLB23 VDD VSS sram512_bitcell
xr5c24 WL5 BL24 BLB24 VDD VSS sram512_bitcell
xr5c25 WL5 BL25 BLB25 VDD VSS sram512_bitcell
xr5c26 WL5 BL26 BLB26 VDD VSS sram512_bitcell
xr5c27 WL5 BL27 BLB27 VDD VSS sram512_bitcell
xr5c28 WL5 BL28 BLB28 VDD VSS sram512_bitcell
xr5c29 WL5 BL29 BLB29 VDD VSS sram512_bitcell
xr5c30 WL5 BL30 BLB30 VDD VSS sram512_bitcell
xr5c31 WL5 BL31 BLB31 VDD VSS sram512_bitcell
xr6c0 WL6 BL0 BLB0 VDD VSS sram512_bitcell
xr6c1 WL6 BL1 BLB1 VDD VSS sram512_bitcell
xr6c2 WL6 BL2 BLB2 VDD VSS sram512_bitcell
xr6c3 WL6 BL3 BLB3 VDD VSS sram512_bitcell
xr6c4 WL6 BL4 BLB4 VDD VSS sram512_bitcell
xr6c5 WL6 BL5 BLB5 VDD VSS sram512_bitcell
xr6c6 WL6 BL6 BLB6 VDD VSS sram512_bitcell
xr6c7 WL6 BL7 BLB7 VDD VSS sram512_bitcell
xr6c8 WL6 BL8 BLB8 VDD VSS sram512_bitcell
xr6c9 WL6 BL9 BLB9 VDD VSS sram512_bitcell
xr6c10 WL6 BL10 BLB10 VDD VSS sram512_bitcell
xr6c11 WL6 BL11 BLB11 VDD VSS sram512_bitcell
xr6c12 WL6 BL12 BLB12 VDD VSS sram512_bitcell
xr6c13 WL6 BL13 BLB13 VDD VSS sram512_bitcell
xr6c14 WL6 BL14 BLB14 VDD VSS sram512_bitcell
xr6c15 WL6 BL15 BLB15 VDD VSS sram512_bitcell
xr6c16 WL6 BL16 BLB16 VDD VSS sram512_bitcell
xr6c17 WL6 BL17 BLB17 VDD VSS sram512_bitcell
xr6c18 WL6 BL18 BLB18 VDD VSS sram512_bitcell
xr6c19 WL6 BL19 BLB19 VDD VSS sram512_bitcell
xr6c20 WL6 BL20 BLB20 VDD VSS sram512_bitcell
xr6c21 WL6 BL21 BLB21 VDD VSS sram512_bitcell
xr6c22 WL6 BL22 BLB22 VDD VSS sram512_bitcell
xr6c23 WL6 BL23 BLB23 VDD VSS sram512_bitcell
xr6c24 WL6 BL24 BLB24 VDD VSS sram512_bitcell
xr6c25 WL6 BL25 BLB25 VDD VSS sram512_bitcell
xr6c26 WL6 BL26 BLB26 VDD VSS sram512_bitcell
xr6c27 WL6 BL27 BLB27 VDD VSS sram512_bitcell
xr6c28 WL6 BL28 BLB28 VDD VSS sram512_bitcell
xr6c29 WL6 BL29 BLB29 VDD VSS sram512_bitcell
xr6c30 WL6 BL30 BLB30 VDD VSS sram512_bitcell
xr6c31 WL6 BL31 BLB31 VDD VSS sram512_bitcell
xr7c0 WL7 BL0 BLB0 VDD VSS sram512_bitcell
xr7c1 WL7 BL1 BLB1 VDD VSS sram512_bitcell
xr7c2 WL7 BL2 BLB2 VDD VSS sram512_bitcell
xr7c3 WL7 BL3 BLB3 VDD VSS sram512_bitcell
xr7c4 WL7 BL4 BLB4 VDD VSS sram512_bitcell
xr7c5 WL7 BL5 BLB5 VDD VSS sram512_bitcell
xr7c6 WL7 BL6 BLB6 VDD VSS sram512_bitcell
xr7c7 WL7 BL7 BLB7 VDD VSS sram512_bitcell
xr7c8 WL7 BL8 BLB8 VDD VSS sram512_bitcell
xr7c9 WL7 BL9 BLB9 VDD VSS sram512_bitcell
xr7c10 WL7 BL10 BLB10 VDD VSS sram512_bitcell
xr7c11 WL7 BL11 BLB11 VDD VSS sram512_bitcell
xr7c12 WL7 BL12 BLB12 VDD VSS sram512_bitcell
xr7c13 WL7 BL13 BLB13 VDD VSS sram512_bitcell
xr7c14 WL7 BL14 BLB14 VDD VSS sram512_bitcell
xr7c15 WL7 BL15 BLB15 VDD VSS sram512_bitcell
xr7c16 WL7 BL16 BLB16 VDD VSS sram512_bitcell
xr7c17 WL7 BL17 BLB17 VDD VSS sram512_bitcell
xr7c18 WL7 BL18 BLB18 VDD VSS sram512_bitcell
xr7c19 WL7 BL19 BLB19 VDD VSS sram512_bitcell
xr7c20 WL7 BL20 BLB20 VDD VSS sram512_bitcell
xr7c21 WL7 BL21 BLB21 VDD VSS sram512_bitcell
xr7c22 WL7 BL22 BLB22 VDD VSS sram512_bitcell
xr7c23 WL7 BL23 BLB23 VDD VSS sram512_bitcell
xr7c24 WL7 BL24 BLB24 VDD VSS sram512_bitcell
xr7c25 WL7 BL25 BLB25 VDD VSS sram512_bitcell
xr7c26 WL7 BL26 BLB26 VDD VSS sram512_bitcell
xr7c27 WL7 BL27 BLB27 VDD VSS sram512_bitcell
xr7c28 WL7 BL28 BLB28 VDD VSS sram512_bitcell
xr7c29 WL7 BL29 BLB29 VDD VSS sram512_bitcell
xr7c30 WL7 BL30 BLB30 VDD VSS sram512_bitcell
xr7c31 WL7 BL31 BLB31 VDD VSS sram512_bitcell
xr8c0 WL8 BL0 BLB0 VDD VSS sram512_bitcell
xr8c1 WL8 BL1 BLB1 VDD VSS sram512_bitcell
xr8c2 WL8 BL2 BLB2 VDD VSS sram512_bitcell
xr8c3 WL8 BL3 BLB3 VDD VSS sram512_bitcell
xr8c4 WL8 BL4 BLB4 VDD VSS sram512_bitcell
xr8c5 WL8 BL5 BLB5 VDD VSS sram512_bitcell
xr8c6 WL8 BL6 BLB6 VDD VSS sram512_bitcell
xr8c7 WL8 BL7 BLB7 VDD VSS sram512_bitcell
xr8c8 WL8 BL8 BLB8 VDD VSS sram512_bitcell
xr8c9 WL8 BL9 BLB9 VDD VSS sram512_bitcell
xr8c10 WL8 BL10 BLB10 VDD VSS sram512_bitcell
xr8c11 WL8 BL11 BLB11 VDD VSS sram512_bitcell
xr8c12 WL8 BL12 BLB12 VDD VSS sram512_bitcell
xr8c13 WL8 BL13 BLB13 VDD VSS sram512_bitcell
xr8c14 WL8 BL14 BLB14 VDD VSS sram512_bitcell
xr8c15 WL8 BL15 BLB15 VDD VSS sram512_bitcell
xr8c16 WL8 BL16 BLB16 VDD VSS sram512_bitcell
xr8c17 WL8 BL17 BLB17 VDD VSS sram512_bitcell
xr8c18 WL8 BL18 BLB18 VDD VSS sram512_bitcell
xr8c19 WL8 BL19 BLB19 VDD VSS sram512_bitcell
xr8c20 WL8 BL20 BLB20 VDD VSS sram512_bitcell
xr8c21 WL8 BL21 BLB21 VDD VSS sram512_bitcell
xr8c22 WL8 BL22 BLB22 VDD VSS sram512_bitcell
xr8c23 WL8 BL23 BLB23 VDD VSS sram512_bitcell
xr8c24 WL8 BL24 BLB24 VDD VSS sram512_bitcell
xr8c25 WL8 BL25 BLB25 VDD VSS sram512_bitcell
xr8c26 WL8 BL26 BLB26 VDD VSS sram512_bitcell
xr8c27 WL8 BL27 BLB27 VDD VSS sram512_bitcell
xr8c28 WL8 BL28 BLB28 VDD VSS sram512_bitcell
xr8c29 WL8 BL29 BLB29 VDD VSS sram512_bitcell
xr8c30 WL8 BL30 BLB30 VDD VSS sram512_bitcell
xr8c31 WL8 BL31 BLB31 VDD VSS sram512_bitcell
xr9c0 WL9 BL0 BLB0 VDD VSS sram512_bitcell
xr9c1 WL9 BL1 BLB1 VDD VSS sram512_bitcell
xr9c2 WL9 BL2 BLB2 VDD VSS sram512_bitcell
xr9c3 WL9 BL3 BLB3 VDD VSS sram512_bitcell
xr9c4 WL9 BL4 BLB4 VDD VSS sram512_bitcell
xr9c5 WL9 BL5 BLB5 VDD VSS sram512_bitcell
xr9c6 WL9 BL6 BLB6 VDD VSS sram512_bitcell
xr9c7 WL9 BL7 BLB7 VDD VSS sram512_bitcell
xr9c8 WL9 BL8 BLB8 VDD VSS sram512_bitcell
xr9c9 WL9 BL9 BLB9 VDD VSS sram512_bitcell
xr9c10 WL9 BL10 BLB10 VDD VSS sram512_bitcell
xr9c11 WL9 BL11 BLB11 VDD VSS sram512_bitcell
xr9c12 WL9 BL12 BLB12 VDD VSS sram512_bitcell
xr9c13 WL9 BL13 BLB13 VDD VSS sram512_bitcell
xr9c14 WL9 BL14 BLB14 VDD VSS sram512_bitcell
xr9c15 WL9 BL15 BLB15 VDD VSS sram512_bitcell
xr9c16 WL9 BL16 BLB16 VDD VSS sram512_bitcell
xr9c17 WL9 BL17 BLB17 VDD VSS sram512_bitcell
xr9c18 WL9 BL18 BLB18 VDD VSS sram512_bitcell
xr9c19 WL9 BL19 BLB19 VDD VSS sram512_bitcell
xr9c20 WL9 BL20 BLB20 VDD VSS sram512_bitcell
xr9c21 WL9 BL21 BLB21 VDD VSS sram512_bitcell
xr9c22 WL9 BL22 BLB22 VDD VSS sram512_bitcell
xr9c23 WL9 BL23 BLB23 VDD VSS sram512_bitcell
xr9c24 WL9 BL24 BLB24 VDD VSS sram512_bitcell
xr9c25 WL9 BL25 BLB25 VDD VSS sram512_bitcell
xr9c26 WL9 BL26 BLB26 VDD VSS sram512_bitcell
xr9c27 WL9 BL27 BLB27 VDD VSS sram512_bitcell
xr9c28 WL9 BL28 BLB28 VDD VSS sram512_bitcell
xr9c29 WL9 BL29 BLB29 VDD VSS sram512_bitcell
xr9c30 WL9 BL30 BLB30 VDD VSS sram512_bitcell
xr9c31 WL9 BL31 BLB31 VDD VSS sram512_bitcell
xr10c0 WL10 BL0 BLB0 VDD VSS sram512_bitcell
xr10c1 WL10 BL1 BLB1 VDD VSS sram512_bitcell
xr10c2 WL10 BL2 BLB2 VDD VSS sram512_bitcell
xr10c3 WL10 BL3 BLB3 VDD VSS sram512_bitcell
xr10c4 WL10 BL4 BLB4 VDD VSS sram512_bitcell
xr10c5 WL10 BL5 BLB5 VDD VSS sram512_bitcell
xr10c6 WL10 BL6 BLB6 VDD VSS sram512_bitcell
xr10c7 WL10 BL7 BLB7 VDD VSS sram512_bitcell
xr10c8 WL10 BL8 BLB8 VDD VSS sram512_bitcell
xr10c9 WL10 BL9 BLB9 VDD VSS sram512_bitcell
xr10c10 WL10 BL10 BLB10 VDD VSS sram512_bitcell
xr10c11 WL10 BL11 BLB11 VDD VSS sram512_bitcell
xr10c12 WL10 BL12 BLB12 VDD VSS sram512_bitcell
xr10c13 WL10 BL13 BLB13 VDD VSS sram512_bitcell
xr10c14 WL10 BL14 BLB14 VDD VSS sram512_bitcell
xr10c15 WL10 BL15 BLB15 VDD VSS sram512_bitcell
xr10c16 WL10 BL16 BLB16 VDD VSS sram512_bitcell
xr10c17 WL10 BL17 BLB17 VDD VSS sram512_bitcell
xr10c18 WL10 BL18 BLB18 VDD VSS sram512_bitcell
xr10c19 WL10 BL19 BLB19 VDD VSS sram512_bitcell
xr10c20 WL10 BL20 BLB20 VDD VSS sram512_bitcell
xr10c21 WL10 BL21 BLB21 VDD VSS sram512_bitcell
xr10c22 WL10 BL22 BLB22 VDD VSS sram512_bitcell
xr10c23 WL10 BL23 BLB23 VDD VSS sram512_bitcell
xr10c24 WL10 BL24 BLB24 VDD VSS sram512_bitcell
xr10c25 WL10 BL25 BLB25 VDD VSS sram512_bitcell
xr10c26 WL10 BL26 BLB26 VDD VSS sram512_bitcell
xr10c27 WL10 BL27 BLB27 VDD VSS sram512_bitcell
xr10c28 WL10 BL28 BLB28 VDD VSS sram512_bitcell
xr10c29 WL10 BL29 BLB29 VDD VSS sram512_bitcell
xr10c30 WL10 BL30 BLB30 VDD VSS sram512_bitcell
xr10c31 WL10 BL31 BLB31 VDD VSS sram512_bitcell
xr11c0 WL11 BL0 BLB0 VDD VSS sram512_bitcell
xr11c1 WL11 BL1 BLB1 VDD VSS sram512_bitcell
xr11c2 WL11 BL2 BLB2 VDD VSS sram512_bitcell
xr11c3 WL11 BL3 BLB3 VDD VSS sram512_bitcell
xr11c4 WL11 BL4 BLB4 VDD VSS sram512_bitcell
xr11c5 WL11 BL5 BLB5 VDD VSS sram512_bitcell
xr11c6 WL11 BL6 BLB6 VDD VSS sram512_bitcell
xr11c7 WL11 BL7 BLB7 VDD VSS sram512_bitcell
xr11c8 WL11 BL8 BLB8 VDD VSS sram512_bitcell
xr11c9 WL11 BL9 BLB9 VDD VSS sram512_bitcell
xr11c10 WL11 BL10 BLB10 VDD VSS sram512_bitcell
xr11c11 WL11 BL11 BLB11 VDD VSS sram512_bitcell
xr11c12 WL11 BL12 BLB12 VDD VSS sram512_bitcell
xr11c13 WL11 BL13 BLB13 VDD VSS sram512_bitcell
xr11c14 WL11 BL14 BLB14 VDD VSS sram512_bitcell
xr11c15 WL11 BL15 BLB15 VDD VSS sram512_bitcell
xr11c16 WL11 BL16 BLB16 VDD VSS sram512_bitcell
xr11c17 WL11 BL17 BLB17 VDD VSS sram512_bitcell
xr11c18 WL11 BL18 BLB18 VDD VSS sram512_bitcell
xr11c19 WL11 BL19 BLB19 VDD VSS sram512_bitcell
xr11c20 WL11 BL20 BLB20 VDD VSS sram512_bitcell
xr11c21 WL11 BL21 BLB21 VDD VSS sram512_bitcell
xr11c22 WL11 BL22 BLB22 VDD VSS sram512_bitcell
xr11c23 WL11 BL23 BLB23 VDD VSS sram512_bitcell
xr11c24 WL11 BL24 BLB24 VDD VSS sram512_bitcell
xr11c25 WL11 BL25 BLB25 VDD VSS sram512_bitcell
xr11c26 WL11 BL26 BLB26 VDD VSS sram512_bitcell
xr11c27 WL11 BL27 BLB27 VDD VSS sram512_bitcell
xr11c28 WL11 BL28 BLB28 VDD VSS sram512_bitcell
xr11c29 WL11 BL29 BLB29 VDD VSS sram512_bitcell
xr11c30 WL11 BL30 BLB30 VDD VSS sram512_bitcell
xr11c31 WL11 BL31 BLB31 VDD VSS sram512_bitcell
xr12c0 WL12 BL0 BLB0 VDD VSS sram512_bitcell
xr12c1 WL12 BL1 BLB1 VDD VSS sram512_bitcell
xr12c2 WL12 BL2 BLB2 VDD VSS sram512_bitcell
xr12c3 WL12 BL3 BLB3 VDD VSS sram512_bitcell
xr12c4 WL12 BL4 BLB4 VDD VSS sram512_bitcell
xr12c5 WL12 BL5 BLB5 VDD VSS sram512_bitcell
xr12c6 WL12 BL6 BLB6 VDD VSS sram512_bitcell
xr12c7 WL12 BL7 BLB7 VDD VSS sram512_bitcell
xr12c8 WL12 BL8 BLB8 VDD VSS sram512_bitcell
xr12c9 WL12 BL9 BLB9 VDD VSS sram512_bitcell
xr12c10 WL12 BL10 BLB10 VDD VSS sram512_bitcell
xr12c11 WL12 BL11 BLB11 VDD VSS sram512_bitcell
xr12c12 WL12 BL12 BLB12 VDD VSS sram512_bitcell
xr12c13 WL12 BL13 BLB13 VDD VSS sram512_bitcell
xr12c14 WL12 BL14 BLB14 VDD VSS sram512_bitcell
xr12c15 WL12 BL15 BLB15 VDD VSS sram512_bitcell
xr12c16 WL12 BL16 BLB16 VDD VSS sram512_bitcell
xr12c17 WL12 BL17 BLB17 VDD VSS sram512_bitcell
xr12c18 WL12 BL18 BLB18 VDD VSS sram512_bitcell
xr12c19 WL12 BL19 BLB19 VDD VSS sram512_bitcell
xr12c20 WL12 BL20 BLB20 VDD VSS sram512_bitcell
xr12c21 WL12 BL21 BLB21 VDD VSS sram512_bitcell
xr12c22 WL12 BL22 BLB22 VDD VSS sram512_bitcell
xr12c23 WL12 BL23 BLB23 VDD VSS sram512_bitcell
xr12c24 WL12 BL24 BLB24 VDD VSS sram512_bitcell
xr12c25 WL12 BL25 BLB25 VDD VSS sram512_bitcell
xr12c26 WL12 BL26 BLB26 VDD VSS sram512_bitcell
xr12c27 WL12 BL27 BLB27 VDD VSS sram512_bitcell
xr12c28 WL12 BL28 BLB28 VDD VSS sram512_bitcell
xr12c29 WL12 BL29 BLB29 VDD VSS sram512_bitcell
xr12c30 WL12 BL30 BLB30 VDD VSS sram512_bitcell
xr12c31 WL12 BL31 BLB31 VDD VSS sram512_bitcell
xr13c0 WL13 BL0 BLB0 VDD VSS sram512_bitcell
xr13c1 WL13 BL1 BLB1 VDD VSS sram512_bitcell
xr13c2 WL13 BL2 BLB2 VDD VSS sram512_bitcell
xr13c3 WL13 BL3 BLB3 VDD VSS sram512_bitcell
xr13c4 WL13 BL4 BLB4 VDD VSS sram512_bitcell
xr13c5 WL13 BL5 BLB5 VDD VSS sram512_bitcell
xr13c6 WL13 BL6 BLB6 VDD VSS sram512_bitcell
xr13c7 WL13 BL7 BLB7 VDD VSS sram512_bitcell
xr13c8 WL13 BL8 BLB8 VDD VSS sram512_bitcell
xr13c9 WL13 BL9 BLB9 VDD VSS sram512_bitcell
xr13c10 WL13 BL10 BLB10 VDD VSS sram512_bitcell
xr13c11 WL13 BL11 BLB11 VDD VSS sram512_bitcell
xr13c12 WL13 BL12 BLB12 VDD VSS sram512_bitcell
xr13c13 WL13 BL13 BLB13 VDD VSS sram512_bitcell
xr13c14 WL13 BL14 BLB14 VDD VSS sram512_bitcell
xr13c15 WL13 BL15 BLB15 VDD VSS sram512_bitcell
xr13c16 WL13 BL16 BLB16 VDD VSS sram512_bitcell
xr13c17 WL13 BL17 BLB17 VDD VSS sram512_bitcell
xr13c18 WL13 BL18 BLB18 VDD VSS sram512_bitcell
xr13c19 WL13 BL19 BLB19 VDD VSS sram512_bitcell
xr13c20 WL13 BL20 BLB20 VDD VSS sram512_bitcell
xr13c21 WL13 BL21 BLB21 VDD VSS sram512_bitcell
xr13c22 WL13 BL22 BLB22 VDD VSS sram512_bitcell
xr13c23 WL13 BL23 BLB23 VDD VSS sram512_bitcell
xr13c24 WL13 BL24 BLB24 VDD VSS sram512_bitcell
xr13c25 WL13 BL25 BLB25 VDD VSS sram512_bitcell
xr13c26 WL13 BL26 BLB26 VDD VSS sram512_bitcell
xr13c27 WL13 BL27 BLB27 VDD VSS sram512_bitcell
xr13c28 WL13 BL28 BLB28 VDD VSS sram512_bitcell
xr13c29 WL13 BL29 BLB29 VDD VSS sram512_bitcell
xr13c30 WL13 BL30 BLB30 VDD VSS sram512_bitcell
xr13c31 WL13 BL31 BLB31 VDD VSS sram512_bitcell
xr14c0 WL14 BL0 BLB0 VDD VSS sram512_bitcell
xr14c1 WL14 BL1 BLB1 VDD VSS sram512_bitcell
xr14c2 WL14 BL2 BLB2 VDD VSS sram512_bitcell
xr14c3 WL14 BL3 BLB3 VDD VSS sram512_bitcell
xr14c4 WL14 BL4 BLB4 VDD VSS sram512_bitcell
xr14c5 WL14 BL5 BLB5 VDD VSS sram512_bitcell
xr14c6 WL14 BL6 BLB6 VDD VSS sram512_bitcell
xr14c7 WL14 BL7 BLB7 VDD VSS sram512_bitcell
xr14c8 WL14 BL8 BLB8 VDD VSS sram512_bitcell
xr14c9 WL14 BL9 BLB9 VDD VSS sram512_bitcell
xr14c10 WL14 BL10 BLB10 VDD VSS sram512_bitcell
xr14c11 WL14 BL11 BLB11 VDD VSS sram512_bitcell
xr14c12 WL14 BL12 BLB12 VDD VSS sram512_bitcell
xr14c13 WL14 BL13 BLB13 VDD VSS sram512_bitcell
xr14c14 WL14 BL14 BLB14 VDD VSS sram512_bitcell
xr14c15 WL14 BL15 BLB15 VDD VSS sram512_bitcell
xr14c16 WL14 BL16 BLB16 VDD VSS sram512_bitcell
xr14c17 WL14 BL17 BLB17 VDD VSS sram512_bitcell
xr14c18 WL14 BL18 BLB18 VDD VSS sram512_bitcell
xr14c19 WL14 BL19 BLB19 VDD VSS sram512_bitcell
xr14c20 WL14 BL20 BLB20 VDD VSS sram512_bitcell
xr14c21 WL14 BL21 BLB21 VDD VSS sram512_bitcell
xr14c22 WL14 BL22 BLB22 VDD VSS sram512_bitcell
xr14c23 WL14 BL23 BLB23 VDD VSS sram512_bitcell
xr14c24 WL14 BL24 BLB24 VDD VSS sram512_bitcell
xr14c25 WL14 BL25 BLB25 VDD VSS sram512_bitcell
xr14c26 WL14 BL26 BLB26 VDD VSS sram512_bitcell
xr14c27 WL14 BL27 BLB27 VDD VSS sram512_bitcell
xr14c28 WL14 BL28 BLB28 VDD VSS sram512_bitcell
xr14c29 WL14 BL29 BLB29 VDD VSS sram512_bitcell
xr14c30 WL14 BL30 BLB30 VDD VSS sram512_bitcell
xr14c31 WL14 BL31 BLB31 VDD VSS sram512_bitcell
xr15c0 WL15 BL0 BLB0 VDD VSS sram512_bitcell
xr15c1 WL15 BL1 BLB1 VDD VSS sram512_bitcell
xr15c2 WL15 BL2 BLB2 VDD VSS sram512_bitcell
xr15c3 WL15 BL3 BLB3 VDD VSS sram512_bitcell
xr15c4 WL15 BL4 BLB4 VDD VSS sram512_bitcell
xr15c5 WL15 BL5 BLB5 VDD VSS sram512_bitcell
xr15c6 WL15 BL6 BLB6 VDD VSS sram512_bitcell
xr15c7 WL15 BL7 BLB7 VDD VSS sram512_bitcell
xr15c8 WL15 BL8 BLB8 VDD VSS sram512_bitcell
xr15c9 WL15 BL9 BLB9 VDD VSS sram512_bitcell
xr15c10 WL15 BL10 BLB10 VDD VSS sram512_bitcell
xr15c11 WL15 BL11 BLB11 VDD VSS sram512_bitcell
xr15c12 WL15 BL12 BLB12 VDD VSS sram512_bitcell
xr15c13 WL15 BL13 BLB13 VDD VSS sram512_bitcell
xr15c14 WL15 BL14 BLB14 VDD VSS sram512_bitcell
xr15c15 WL15 BL15 BLB15 VDD VSS sram512_bitcell
xr15c16 WL15 BL16 BLB16 VDD VSS sram512_bitcell
xr15c17 WL15 BL17 BLB17 VDD VSS sram512_bitcell
xr15c18 WL15 BL18 BLB18 VDD VSS sram512_bitcell
xr15c19 WL15 BL19 BLB19 VDD VSS sram512_bitcell
xr15c20 WL15 BL20 BLB20 VDD VSS sram512_bitcell
xr15c21 WL15 BL21 BLB21 VDD VSS sram512_bitcell
xr15c22 WL15 BL22 BLB22 VDD VSS sram512_bitcell
xr15c23 WL15 BL23 BLB23 VDD VSS sram512_bitcell
xr15c24 WL15 BL24 BLB24 VDD VSS sram512_bitcell
xr15c25 WL15 BL25 BLB25 VDD VSS sram512_bitcell
xr15c26 WL15 BL26 BLB26 VDD VSS sram512_bitcell
xr15c27 WL15 BL27 BLB27 VDD VSS sram512_bitcell
xr15c28 WL15 BL28 BLB28 VDD VSS sram512_bitcell
xr15c29 WL15 BL29 BLB29 VDD VSS sram512_bitcell
xr15c30 WL15 BL30 BLB30 VDD VSS sram512_bitcell
xr15c31 WL15 BL31 BLB31 VDD VSS sram512_bitcell
.ends

* expanding   symbol:  sram512_row_decoder.sym # of pins=23
** sym_path: /home/ishi-kai/sram/sram512_row_decoder.sym
** sch_path: /home/ishi-kai/sram/sram512_row_decoder.sch
.subckt sram512_row_decoder RA0 RA1 RA2 RA3 WL_EN WL0 WL1 WL2 WL3 WL4 WL5 WL6 WL7 WL8 WL9 WL10 WL11 WL12 WL13 WL14 WL15 VDD VSS
*.PININFO RA0:I RA1:I RA2:I RA3:I WL_EN:I WL0:O WL1:O WL2:O WL3:O WL4:O WL5:O WL6:O WL7:O WL8:O WL9:O WL10:O WL11:O WL12:O WL13:O
*+ WL14:O WL15:O VDD:B VSS:B
xaddress_b0 VDD RA0 RA0B VSS INV_X1
xaddress_b1 VDD RA1 RA1B VSS INV_X1
xaddress_b2 VDD RA2 RA2B VSS INV_X1
xaddress_b3 VDD RA3 RA3B VSS INV_X1
xpre0_0 VDD R0_0 RA0B RA1B VSS AND2_X1
xpre0_1 VDD R0_1 RA0 RA1B VSS AND2_X1
xpre0_2 VDD R0_2 RA0B RA1 VSS AND2_X1
xpre0_3 VDD R0_3 RA0 RA1 VSS AND2_X1
xpre1_0 VDD R1_0 RA2B RA3B VSS AND2_X1
xpre1_1 VDD R1_1 RA2 RA3B VSS AND2_X1
xpre1_2 VDD R1_2 RA2B RA3 VSS AND2_X1
xpre1_3 VDD R1_3 RA2 RA3 VSS AND2_X1
xdriver0 WL_EN VDD WL0 R0_0 R1_0 VSS AND3_X1
xdriver1 WL_EN VDD WL1 R0_1 R1_0 VSS AND3_X1
xdriver2 WL_EN VDD WL2 R0_2 R1_0 VSS AND3_X1
xdriver3 WL_EN VDD WL3 R0_3 R1_0 VSS AND3_X1
xdriver4 WL_EN VDD WL4 R0_0 R1_1 VSS AND3_X1
xdriver5 WL_EN VDD WL5 R0_1 R1_1 VSS AND3_X1
xdriver6 WL_EN VDD WL6 R0_2 R1_1 VSS AND3_X1
xdriver7 WL_EN VDD WL7 R0_3 R1_1 VSS AND3_X1
xdriver8 WL_EN VDD WL8 R0_0 R1_2 VSS AND3_X1
xdriver9 WL_EN VDD WL9 R0_1 R1_2 VSS AND3_X1
xdriver10 WL_EN VDD WL10 R0_2 R1_2 VSS AND3_X1
xdriver11 WL_EN VDD WL11 R0_3 R1_2 VSS AND3_X1
xdriver12 WL_EN VDD WL12 R0_0 R1_3 VSS AND3_X1
xdriver13 WL_EN VDD WL13 R0_1 R1_3 VSS AND3_X1
xdriver14 WL_EN VDD WL14 R0_2 R1_3 VSS AND3_X1
xdriver15 WL_EN VDD WL15 R0_3 R1_3 VSS AND3_X1
.ends

* expanding   symbol:  sram512_column.sym # of pins=8
** sym_path: /home/ishi-kai/sram/sram512_column.sym
** sch_path: /home/ishi-kai/sram/sram512_column.sch
.subckt sram512_column BL BLB Y YB COL PREB VDD VSS
*.PININFO BL:B Y:B BLB:B YB:B PREB:I COL:I VDD:B VSS:B
MxpcBL BL PREB VDD VDD PMOS w=3.4u l=1u
MxmuxBL BL COL Y VSS NMOS w=5.1u l=1u
MxpcBLB BLB PREB VDD VDD PMOS w=3.4u l=1u
MxmuxBLB BLB COL YB VSS NMOS w=5.1u l=1u
.ends

* expanding   symbol:  sram512_col_decoder.sym # of pins=44
** sym_path: /home/ishi-kai/sram/sram512_col_decoder.sym
** sch_path: /home/ishi-kai/sram/sram512_col_decoder.sch
.subckt sram512_col_decoder COL0 COL1 COL2 COL3 COL4 COL5 COL6 COL7 COL8 COL9 COL10 COL11 COL12 COL13 COL14 COL15 COL16 COL17
+ COL18 COL19 COL20 COL21 COL22 COL23 COL24 COL25 COL26 COL27 COL28 COL29 COL30 COL31 CA0 CA0B CA1 CA1B CA2 CA2B CA3 CA3B CA4 CA4B VDD
+ VSS
*.PININFO CA0:I CA0B:I CA1:I CA1B:I CA2:I CA2B:I CA3:I CA3B:I CA4:I CA4B:I COL0:O COL1:O COL2:O COL3:O COL4:O COL5:O COL6:O COL7:O
*+ COL8:O COL9:O COL10:O COL11:O COL12:O COL13:O COL14:O COL15:O COL16:O COL17:O COL18:O COL19:O COL20:O COL21:O COL22:O COL23:O COL24:O
*+ COL25:O COL26:O COL27:O COL28:O COL29:O COL30:O COL31:O VDD:B VSS:B
xlow0 VDD CL0 CA0B CA1B VSS AND2_X1
xlow1 VDD CL1 CA0 CA1B VSS AND2_X1
xlow2 VDD CL2 CA0B CA1 VSS AND2_X1
xlow3 VDD CL3 CA0 CA1 VSS AND2_X1
xhigh0 CA4B VDD CH0 CA2B CA3B VSS AND3_X1
xhigh1 CA4B VDD CH1 CA2 CA3B VSS AND3_X1
xhigh2 CA4B VDD CH2 CA2B CA3 VSS AND3_X1
xhigh3 CA4B VDD CH3 CA2 CA3 VSS AND3_X1
xhigh4 CA4 VDD CH4 CA2B CA3B VSS AND3_X1
xhigh5 CA4 VDD CH5 CA2 CA3B VSS AND3_X1
xhigh6 CA4 VDD CH6 CA2B CA3 VSS AND3_X1
xhigh7 CA4 VDD CH7 CA2 CA3 VSS AND3_X1
xselect0 VDD COL0 CL0 CH0 VSS AND2_X1
xselect1 VDD COL1 CL1 CH0 VSS AND2_X1
xselect2 VDD COL2 CL2 CH0 VSS AND2_X1
xselect3 VDD COL3 CL3 CH0 VSS AND2_X1
xselect4 VDD COL4 CL0 CH1 VSS AND2_X1
xselect5 VDD COL5 CL1 CH1 VSS AND2_X1
xselect6 VDD COL6 CL2 CH1 VSS AND2_X1
xselect7 VDD COL7 CL3 CH1 VSS AND2_X1
xselect8 VDD COL8 CL0 CH2 VSS AND2_X1
xselect9 VDD COL9 CL1 CH2 VSS AND2_X1
xselect10 VDD COL10 CL2 CH2 VSS AND2_X1
xselect11 VDD COL11 CL3 CH2 VSS AND2_X1
xselect12 VDD COL12 CL0 CH3 VSS AND2_X1
xselect13 VDD COL13 CL1 CH3 VSS AND2_X1
xselect14 VDD COL14 CL2 CH3 VSS AND2_X1
xselect15 VDD COL15 CL3 CH3 VSS AND2_X1
xselect16 VDD COL16 CL0 CH4 VSS AND2_X1
xselect17 VDD COL17 CL1 CH4 VSS AND2_X1
xselect18 VDD COL18 CL2 CH4 VSS AND2_X1
xselect19 VDD COL19 CL3 CH4 VSS AND2_X1
xselect20 VDD COL20 CL0 CH5 VSS AND2_X1
xselect21 VDD COL21 CL1 CH5 VSS AND2_X1
xselect22 VDD COL22 CL2 CH5 VSS AND2_X1
xselect23 VDD COL23 CL3 CH5 VSS AND2_X1
xselect24 VDD COL24 CL0 CH6 VSS AND2_X1
xselect25 VDD COL25 CL1 CH6 VSS AND2_X1
xselect26 VDD COL26 CL2 CH6 VSS AND2_X1
xselect27 VDD COL27 CL3 CH6 VSS AND2_X1
xselect28 VDD COL28 CL0 CH7 VSS AND2_X1
xselect29 VDD COL29 CL1 CH7 VSS AND2_X1
xselect30 VDD COL30 CL2 CH7 VSS AND2_X1
xselect31 VDD COL31 CL3 CH7 VSS AND2_X1
.ends

* expanding   symbol:  sense_amp_7t.sym # of pins=7
** sym_path: /home/ishi-kai/sram/sense_amp_7t.sym
** sch_path: /home/ishi-kai/sram/sense_amp_7t.sch
.subckt sense_amp_7t BL BLB SAE SOUT SOUTB VDD VSS
*.PININFO BL:I BLB:I SOUT:O SOUTB:O VSS:B VDD:B SAE:I
MXP_ISO_L SOUT SAE BL VDD PMOS w=3.4u l=1u
MXP_ISO_R SOUTB SAE BLB VDD PMOS w=3.4u l=1u
MXP_L SOUT SOUTB VDD VDD PMOS w=3.4u l=1u
MXN_L SOUT SOUTB net1 VSS NMOS w=3.4u l=1u
MXP_R SOUTB SOUT VDD VDD PMOS w=3.4u l=1u
MXN_R SOUTB SOUT net1 VSS NMOS w=3.4u l=1u
MXN_TAIL net1 SAE VSS VSS NMOS w=3.4u l=1u
.ends

* expanding   symbol:  TR-1um_5_stdcell/AND2_X1.sym # of pins=5
** sym_path: /home/ishi-kai/sram/.pdk/dev/TR-1um/libs.tech/xschem/TR-1um_5_stdcell/AND2_X1.sym
** sch_path: /home/ishi-kai/sram/.pdk/dev/TR-1um/libs.tech/xschem/TR-1um_5_stdcell/AND2_X1.sch
.subckt AND2_X1 VDD Y A B GND
*.PININFO Y:O A:I B:I VDD:B GND:B
MM7 net1 B VDD VDD PMOS w=10.2u l=1u
MM1 net1 A VDD VDD PMOS w=10.2u l=1u
MM2 Y net1 VDD VDD PMOS w=10.2u l=1u
MM3 Y net1 GND GND NMOS w=3.4u l=1u
MM4 net1 A net2 GND NMOS w=3.4u l=1u
MM5 net2 B GND GND NMOS w=3.4u l=1u
.ends

* expanding   symbol:  sram512_controller.sym # of pins=32
** sym_path: /home/ishi-kai/sram/sram512_controller.sym
** sch_path: /home/ishi-kai/sram/sram512_controller.sch
.subckt sram512_controller CLK RESET SDI WE SOUT DIN DINB CA0 CA0B CA1 CA1B CA2 CA2B CA3 CA3B CA4 CA4B RA0 RA0B RA1 RA1B RA2 RA2B
+ RA3 RA3B PREB SAE WL_EN WRITE_EN SDO VDD VSS
*.PININFO CLK:I RESET:I SDI:I WE:I SOUT:I DIN:O DINB:O CA0:O CA0B:O CA1:O CA1B:O CA2:O CA2B:O CA3:O CA3B:O CA4:O CA4B:O RA0:O
*+ RA0B:O RA1:O RA1B:O RA2:O RA2B:O RA3:O RA3B:O PREB:O SAE:O WL_EN:O WRITE_EN:O SDO:O VDD:B VSS:B
xclock VDD CLK CKI VSS BUF_X4
xreset VDD RESET RSTI VSS BUF_X4
xphase CKI RSTI RX E0 E1 E2 E3 E4 E5 E6 E7 VDD VSS sram512_phase
xframe CKI RSTI RX SDI DIN DINB CA0 CA0B CA1 CA1B CA2 CA2B CA3 CA3B CA4 CA4B RA0 RA0B RA1 RA1B RA2 RA2B RA3 RA3B VDD VSS
+ sram512_frame
xcontrol CKI RSTI WE SOUT E0 E1 E2 E3 E4 E5 E6 PREB_I WL_EN WRITE_EN SAE_I READ_DATA VDD VSS sram512_control
xpreb_drive VDD PREB_I PREB VSS BUF_X4
xsae_drive VDD SAE_I SAE VSS BUF_X4
xsdo_drive VDD READ_DATA SDO VSS BUF_X4
* noconn E7
.ends

* expanding   symbol:  sram512_input_clamp.sym # of pins=3
** sym_path: /home/ishi-kai/sram/sram512_input_clamp.sym
** sch_path: /home/ishi-kai/sram/sram512_input_clamp.sch
.subckt sram512_input_clamp IN VDD VSS
*.PININFO IN:B VDD:B VSS:B
Dxupper IN VDD DP A=12.96p P=14.4u
Dxlower VSS IN DN A=12.96p P=14.4u
.ends

* expanding   symbol:  sram512_bitcell.sym # of pins=5
** sym_path: /home/ishi-kai/sram/sram512_bitcell.sym
** sch_path: /home/ishi-kai/sram/sram512_bitcell.sch
.subckt sram512_bitcell WL BL BLB VDD VSS
*.PININFO VDD:B BLB:B BL:B WL:I VSS:B
MXM1 Q QB VSS VSS NMOS w=3.4u l=1u
MXM2 Q QB VDD VDD PMOS w=3.4u l=1u
MXM3 QB Q VSS VSS NMOS w=3.4u l=1u
MXM4 QB Q VDD VDD PMOS w=3.4u l=1u
MXM7 Q WL BL VSS NMOS w=3.4u l=1u
MXM6 QB WL BLB VSS NMOS w=3.4u l=1u
.ends

* expanding   symbol:  TR-1um_5_stdcell/INV_X1.sym # of pins=4
** sym_path: /home/ishi-kai/sram/.pdk/dev/TR-1um/libs.tech/xschem/TR-1um_5_stdcell/INV_X1.sym
** sch_path: /home/ishi-kai/sram/.pdk/dev/TR-1um/libs.tech/xschem/TR-1um_5_stdcell/INV_X1.sch
.subckt INV_X1 VDD A Y GND
*.PININFO A:I Y:O GND:B VDD:B
MM7 Y A VDD VDD PMOS w=10.2u l=1u
MM2 Y A GND GND NMOS w=3.4u l=1u
.ends

* expanding   symbol:  TR-1um_5_stdcell/AND3_X1.sym # of pins=6
** sym_path: /home/ishi-kai/sram/.pdk/dev/TR-1um/libs.tech/xschem/TR-1um_5_stdcell/AND3_X1.sym
** sch_path: /home/ishi-kai/sram/.pdk/dev/TR-1um/libs.tech/xschem/TR-1um_5_stdcell/AND3_X1.sch
.subckt AND3_X1 C VDD Y A B GND
*.PININFO Y:O A:I B:I VDD:B GND:B C:I
MM4 net1 C VDD VDD PMOS w=10.2u l=1u
MM2 net1 B VDD VDD PMOS w=10.2u l=1u
MM3 Y net1 VDD VDD PMOS w=10.2u l=1u
MM1 VDD A net1 VDD PMOS w=10.2u l=1u
MM8 Y net1 GND GND NMOS w=3.4u l=1u
MM5 net1 A net3 GND NMOS w=3.4u l=1u
MM6 net3 B net2 GND NMOS w=3.4u l=1u
MM7 net2 C GND GND NMOS w=3.4u l=1u
.ends

* expanding   symbol:  TR-1um_5_stdcell/BUF_X4.sym # of pins=4
** sym_path: /home/ishi-kai/sram/.pdk/dev/TR-1um/libs.tech/xschem/TR-1um_5_stdcell/BUF_X4.sym
** sch_path: /home/ishi-kai/sram/.pdk/dev/TR-1um/libs.tech/xschem/TR-1um_5_stdcell/BUF_X4.sch
.subckt BUF_X4 VDD A Y GND
*.PININFO A:I Y:O VDD:B GND:B
MM7 net1 A VDD VDD PMOS w=10.2u l=1u m=2
MM1 Y net1 VDD VDD PMOS w=10.2u l=1u m=4
MM3 net1 A GND GND NMOS w=3.4u l=1u m=2
MM2 Y net1 GND GND NMOS w=3.4u l=1u m=4
.ends

* expanding   symbol:  sram512_phase.sym # of pins=13
** sym_path: /home/ishi-kai/sram/sram512_phase.sym
** sch_path: /home/ishi-kai/sram/sram512_phase.sch
.subckt sram512_phase CLK RESET RX E0 E1 E2 E3 E4 E5 E6 E7 VDD VSS
*.PININFO CLK:I RESET:I RX:O E0:O E1:O E2:O E3:O E4:O E5:O E6:O E7:O VDD:B VSS:B
xcount_low_zero C3B C2B VDD LOW_ZERO C0B C1B VSS AND4_X1
xcount_run VDD COUNT_RUN C4B LOW_ZERO VSS OR2
xnext0 VDD NEXT0 C0B COUNT_RUN VSS AND2_X1
xcounter0 VDD C0B NEXT0 C0 RESET VSS CLK DFFR
xtoggle1 VDD TOGGLE1 C1 C0 VSS XOR2
xnext1 VDD NEXT1 TOGGLE1 COUNT_RUN VSS AND2_X1
xcounter1 VDD C1B NEXT1 C1 RESET VSS CLK DFFR
xcarry2 VDD CARRY2 C0 C1 VSS AND2_X1
xtoggle2 VDD TOGGLE2 C2 CARRY2 VSS XOR2
xnext2 VDD NEXT2 TOGGLE2 COUNT_RUN VSS AND2_X1
xcounter2 VDD C2B NEXT2 C2 RESET VSS CLK DFFR
xcarry3 C2 VDD CARRY3 C0 C1 VSS AND3_X1
xtoggle3 VDD TOGGLE3 C3 CARRY3 VSS XOR2
xnext3 VDD NEXT3 TOGGLE3 COUNT_RUN VSS AND2_X1
xcounter3 VDD C3B NEXT3 C3 RESET VSS CLK DFFR
xcarry4 C3 C2 VDD CARRY4 C0 C1 VSS AND4_X1
xtoggle4 VDD TOGGLE4 C4 CARRY4 VSS XOR2
xnext4 VDD NEXT4 TOGGLE4 COUNT_RUN VSS AND2_X1
xcounter4 VDD C4B NEXT4 C4 RESET VSS CLK DFFR
xphase0_low C3 C2B VDD E0_LOW C0B C1 VSS AND4_X1
xphase0 VDD E0 E0_LOW C4B VSS AND2_X1
xphase1_low C3 C2B VDD E1_LOW C0 C1 VSS AND4_X1
xphase1 VDD E1 E1_LOW C4B VSS AND2_X1
xphase2_low C3 C2 VDD E2_LOW C0B C1B VSS AND4_X1
xphase2 VDD E2 E2_LOW C4B VSS AND2_X1
xphase3_low C3 C2 VDD E3_LOW C0 C1B VSS AND4_X1
xphase3 VDD E3 E3_LOW C4B VSS AND2_X1
xphase4_low C3 C2 VDD E4_LOW C0B C1 VSS AND4_X1
xphase4 VDD E4 E4_LOW C4B VSS AND2_X1
xphase5_low C3 C2 VDD E5_LOW C0 C1 VSS AND4_X1
xphase5 VDD E5 E5_LOW C4B VSS AND2_X1
xphase6_low C3B C2B VDD E6_LOW C0B C1B VSS AND4_X1
xphase6 VDD E6 E6_LOW C4 VSS AND2_X1
xphase7_low C3B C2B VDD E7_LOW C0 C1B VSS AND4_X1
xphase7 VDD E7 E7_LOW C4 VSS AND2_X1
xrx_low VDD RX_LOW C2B C1B VSS AND2_X1
xrx_upper VDD RX_UPPER C3B RX_LOW VSS OR2
xrx VDD RX C4B RX_UPPER VSS AND2_X1
.ends

* expanding   symbol:  sram512_frame.sym # of pins=26
** sym_path: /home/ishi-kai/sram/sram512_frame.sym
** sch_path: /home/ishi-kai/sram/sram512_frame.sch
.subckt sram512_frame CLK RESET RX SDI DIN DINB CA0 CA0B CA1 CA1B CA2 CA2B CA3 CA3B CA4 CA4B RA0 RA0B RA1 RA1B RA2 RA2B RA3 RA3B
+ VDD VSS
*.PININFO CLK:I RESET:I RX:I SDI:I DIN:O DINB:O CA0:O CA0B:O CA1:O CA1B:O CA2:O CA2B:O CA3:O CA3B:O CA4:O CA4B:O RA0:O RA0B:O
*+ RA1:O RA1B:O RA2:O RA2B:O RA3:O RA3B:O VDD:B VSS:B
xframe_DIN_hold DIN SDI RX VDD net1 VSS MUX2
xframe_DIN VDD DINB net1 DIN RESET VSS CLK DFFR
xframe_CA0_hold CA0 DIN RX VDD net2 VSS MUX2
xframe_CA0 VDD CA0B net2 CA0 RESET VSS CLK DFFR
xframe_CA1_hold CA1 CA0 RX VDD net3 VSS MUX2
xframe_CA1 VDD CA1B net3 CA1 RESET VSS CLK DFFR
xframe_CA2_hold CA2 CA1 RX VDD net4 VSS MUX2
xframe_CA2 VDD CA2B net4 CA2 RESET VSS CLK DFFR
xframe_CA3_hold CA3 CA2 RX VDD net5 VSS MUX2
xframe_CA3 VDD CA3B net5 CA3 RESET VSS CLK DFFR
xframe_CA4_hold CA4 CA3 RX VDD net6 VSS MUX2
xframe_CA4 VDD CA4B net6 CA4 RESET VSS CLK DFFR
xframe_RA0_hold RA0 CA4 RX VDD net7 VSS MUX2
xframe_RA0 VDD RA0B net7 RA0 RESET VSS CLK DFFR
xframe_RA1_hold RA1 RA0 RX VDD net8 VSS MUX2
xframe_RA1 VDD RA1B net8 RA1 RESET VSS CLK DFFR
xframe_RA2_hold RA2 RA1 RX VDD net9 VSS MUX2
xframe_RA2 VDD RA2B net9 RA2 RESET VSS CLK DFFR
xframe_RA3_hold RA3 RA2 RX VDD net10 VSS MUX2
xframe_RA3 VDD RA3B net10 RA3 RESET VSS CLK DFFR
.ends

* expanding   symbol:  sram512_control.sym # of pins=18
** sym_path: /home/ishi-kai/sram/sram512_control.sym
** sch_path: /home/ishi-kai/sram/sram512_control.sch
.subckt sram512_control CLK RESET WE SOUT E0 E1 E2 E3 E4 E5 E6 PREB WL_EN WRITE_EN SAE READ_DATA VDD VSS
*.PININFO CLK:I RESET:I WE:I SOUT:I E0:I E1:I E2:I E3:I E4:I E5:I E6:I PREB:O WL_EN:O WRITE_EN:O SAE:O READ_DATA:O VDD:B VSS:B
xpc VDD PREB E0 PC_ON RESET VSS CLK DFFR
xwl_window VDD WL_D E3 E4 VSS OR2
xwl VDD WL_ENB WL_D WL_EN RESET VSS CLK DFFR
xwrite_window E2 E3 E4 E5 VDD WRITE_WINDOW VSS OR4
xwrite_data VDD WRITE_D WRITE_WINDOW W VSS AND2_X1
xwrite VDD WRITE_ENB WRITE_D WRITE_EN RESET VSS CLK DFFR
xwe_b VDD WE WE_B VSS INV_X1
xtrack_first VDD TRACK_FIRST WE_B E0 VSS AND2_X1
xtrack_later_window E3 VDD TRACK_WINDOW E1 E2 VSS OR3
xtrack_later VDD TRACK_LATER TRACK_WINDOW WB VSS AND2_X1
xtrack_data VDD TRACK_D TRACK_FIRST TRACK_LATER VSS OR2
xtrack VDD SAE TRACK_D TRACK RESET VSS CLK DFFR
xmode_hold W WE E0 VDD net1 VSS MUX2
xmode VDD WB net1 W RESET VSS CLK DFFR
xread_capture VDD READ_CAPTURE E6 WB VSS AND2_X1
xresult_hold READ_DATA SOUT READ_CAPTURE VDD net2 VSS MUX2
xresult VDD READ_DATAB net2 READ_DATA RESET VSS CLK DFFR
* noconn PC_ON
* noconn WL_ENB
* noconn WRITE_ENB
* noconn TRACK
* noconn READ_DATAB
.ends

* expanding   symbol:  TR-1um_5_stdcell/AND4_X1.sym # of pins=7
** sym_path: /home/ishi-kai/sram/.pdk/dev/TR-1um/libs.tech/xschem/TR-1um_5_stdcell/AND4_X1.sym
** sch_path: /home/ishi-kai/sram/.pdk/dev/TR-1um/libs.tech/xschem/TR-1um_5_stdcell/AND4_X1.sch
.subckt AND4_X1 D C VDD Y A B GND
*.PININFO Y:O A:I B:I VDD:B GND:B C:I D:I
MM7 net1 A net4 GND NMOS w=3.4u l=1u
MM5 net3 C net2 GND NMOS w=3.4u l=1u
MM8 Y net1 GND GND NMOS w=3.4u l=1u
MM10 net2 D GND GND NMOS w=3.4u l=1u
MM6 net4 B net3 GND NMOS w=3.4u l=1u
MM11 net1 A VDD VDD PMOS w=10.2u l=1u
MM1 net1 D VDD VDD PMOS w=10.2u l=1u
MM3 net1 C VDD VDD PMOS w=10.2u l=1u
MM4 Y net1 VDD VDD PMOS w=10.2u l=1u
MM2 net1 B VDD VDD PMOS w=10.2u l=1u
.ends

* expanding   symbol:  TR-1um_5_stdcell/OR2.sym # of pins=5
** sym_path: /home/ishi-kai/sram/.pdk/dev/TR-1um/libs.tech/xschem/TR-1um_5_stdcell/OR2.sym
** sch_path: /home/ishi-kai/sram/.pdk/dev/TR-1um/libs.tech/xschem/TR-1um_5_stdcell/OR2.sch
.subckt OR2 VDD Y A B GND
*.PININFO A:I B:I Y:O VDD:B GND:B
MM7 net2 B VDD VDD PMOS w=10.2u l=1u
MM2 net1 A net2 VDD PMOS w=10.2u l=1u
MM4 Y net1 VDD VDD PMOS w=10.2u l=1u
MM1 net1 B GND GND NMOS w=3.4u l=1u
MM3 net1 A GND GND NMOS w=3.4u l=1u
MM5 Y net1 GND GND NMOS w=3.4u l=1u
.ends

* expanding   symbol:  TR-1um_5_stdcell/DFFR.sym # of pins=7
** sym_path: /home/ishi-kai/sram/.pdk/dev/TR-1um/libs.tech/xschem/TR-1um_5_stdcell/DFFR.sym
** sch_path: /home/ishi-kai/sram/.pdk/dev/TR-1um/libs.tech/xschem/TR-1um_5_stdcell/DFFR.sch
.subckt DFFR VDD QB D Q RST GND CK
*.PININFO VDD:B GND:B CK:I D:I Q:O QB:O RST:I
MM2 net2 D VDD VDD PMOS w=10.2u l=1u
MM1 net3 CLK net2 VDD PMOS w=10.2u l=1u
MM11 net5 net8 VDD VDD PMOS w=10.2u l=1u
MM12 net3 CKB net5 VDD PMOS w=10.2u l=1u
MM15 net7 net3 VDD VDD PMOS w=10.2u l=1u
MM16 net8 RST net7 VDD PMOS w=10.2u l=1u
MM18 net9 net8 VDD VDD PMOS w=10.2u l=1u
MM19 net10 CKB net9 VDD PMOS w=10.2u l=1u
MM23 net12 net14 VDD VDD PMOS w=10.2u l=1u
MM24 net10 CLK net12 VDD PMOS w=10.2u l=1u
MM27 net15 net10 VDD VDD PMOS w=10.2u l=1u
MM28 net14 RST net15 VDD PMOS w=10.2u l=1u
MM31 QB net14 VDD VDD PMOS w=10.2u l=1u
MM33 Q QB VDD VDD PMOS w=10.2u l=1u
MM35 QB net14 GND GND NMOS w=3.4u l=1u
MM32 Q QB GND GND NMOS w=3.4u l=1u
MM29 net14 RST GND GND NMOS w=3.4u l=1u
MM30 net14 net10 GND GND NMOS w=3.4u l=1u
MM25 net10 CKB net13 GND NMOS w=3.4u l=1u
MM26 net13 net14 GND GND NMOS w=3.4u l=1u
MM20 net10 CLK net11 GND NMOS w=3.4u l=1u
MM21 net11 net8 GND GND NMOS w=3.4u l=1u
MM17 net8 net3 GND GND NMOS w=3.4u l=1u
MM22 net8 RST GND GND NMOS w=3.4u l=1u
MM13 net3 CLK net6 GND NMOS w=3.4u l=1u
MM14 net6 net8 GND GND NMOS w=3.4u l=1u
MM7 net3 CKB net4 GND NMOS w=3.4u l=1u
MM8 net4 D GND GND NMOS w=3.4u l=1u
MM3 net1 CK VDD VDD PMOS w=10.2u l=1u
MM4 CLK net1 VDD VDD PMOS w=10.2u l=1u
MM5 CKB CLK VDD VDD PMOS w=10.2u l=1u
MM34 net1 CK GND GND NMOS w=3.4u l=1u
MM6 CLK net1 GND GND NMOS w=3.4u l=1u
MM9 CKB CLK GND GND NMOS w=3.4u l=1u
.ends

* expanding   symbol:  TR-1um_5_stdcell/XOR2.sym # of pins=5
** sym_path: /home/ishi-kai/sram/.pdk/dev/TR-1um/libs.tech/xschem/TR-1um_5_stdcell/XOR2.sym
** sch_path: /home/ishi-kai/sram/.pdk/dev/TR-1um/libs.tech/xschem/TR-1um_5_stdcell/XOR2.sch
.subckt XOR2 VDD Y A B GND
*.PININFO VDD:B GND:B A:I B:I Y:O
MM10 net1 A VDD VDD PMOS w=10.2u l=1u
MM1 net2 B net1 VDD PMOS w=10.2u l=1u
MM8 net3 B VDD VDD PMOS w=10.2u l=1u
MM2 net3 A VDD VDD PMOS w=10.2u l=1u
MM9 Y net2 net3 VDD PMOS w=10.2u l=1u
MM3 net2 A GND GND NMOS w=3.4u l=1u
MM4 net2 B GND GND NMOS w=3.4u l=1u
MM5 Y net2 GND GND NMOS w=3.4u l=1u
MM7 net4 B GND GND NMOS w=3.4u l=1u
MM6 Y A net4 GND NMOS w=3.4u l=1u
.ends

* expanding   symbol:  TR-1um_5_stdcell/MUX2.sym # of pins=6
** sym_path: /home/ishi-kai/sram/.pdk/dev/TR-1um/libs.tech/xschem/TR-1um_5_stdcell/MUX2.sym
** sch_path: /home/ishi-kai/sram/.pdk/dev/TR-1um/libs.tech/xschem/TR-1um_5_stdcell/MUX2.sch
.subckt MUX2 A B S VDD Y GND
*.PININFO B:I S:I Y:O VDD:B GND:B A:I
MM13 net1 S VDD VDD PMOS w=6.8u l=1u
MM9 net2 B VDD VDD PMOS w=6.8u l=1u
MM8 net4 net1 net2 VDD PMOS w=6.8u l=1u
MM10 Y net4 VDD VDD PMOS w=5.1u l=1u m=2
MM2 net4 S net3 VDD PMOS w=6.8u l=1u
MM12 net1 S GND GND NMOS w=3.4u l=1u
MM3 net2 B GND GND NMOS w=3.4u l=1u
MM1 Y net4 GND GND NMOS w=3.4u l=1u
MM5 net3 A GND GND NMOS w=3.4u l=1u
MM6 net4 S net2 GND NMOS w=3.4u l=1u m=2
MM4 net4 net1 net3 GND NMOS w=3.4u l=1u m=2
MM7 net3 A VDD VDD PMOS w=6.8u l=1u
.ends

* expanding   symbol:  TR-1um_5_stdcell/OR4.sym # of pins=7
** sym_path: /home/ishi-kai/sram/.pdk/dev/TR-1um/libs.tech/xschem/TR-1um_5_stdcell/OR4.sym
** sch_path: /home/ishi-kai/sram/.pdk/dev/TR-1um/libs.tech/xschem/TR-1um_5_stdcell/OR4.sch
.subckt OR4 A B C D VDD Y GND
*.PININFO B:I A:I Y:O VDD:B GND:B C:I D:I
MM10 net1 B VDD VDD PMOS w=10.2u l=1u
MM2 net2 A net1 VDD PMOS w=10.2u l=1u
MM3 net4 C net2 VDD PMOS w=10.2u l=1u
MM7 Y net3 VDD VDD PMOS w=10.2u l=1u
MM9 net4 D net3 VDD PMOS w=10.2u l=1u
MM11 net3 A GND GND NMOS w=3.4u l=1u
MM1 net3 B GND GND NMOS w=3.4u l=1u
MM4 net3 C GND GND NMOS w=3.4u l=1u
MM5 net3 D GND GND NMOS w=3.4u l=1u
MM6 Y net3 GND GND NMOS w=3.4u l=1u
.ends

* expanding   symbol:  TR-1um_5_stdcell/OR3.sym # of pins=6
** sym_path: /home/ishi-kai/sram/.pdk/dev/TR-1um/libs.tech/xschem/TR-1um_5_stdcell/OR3.sym
** sch_path: /home/ishi-kai/sram/.pdk/dev/TR-1um/libs.tech/xschem/TR-1um_5_stdcell/OR3.sch
.subckt OR3 C VDD Y A B GND
*.PININFO A:I B:I Y:O VDD:B GND:B C:I
MM8 net1 B VDD VDD PMOS w=10.2u l=1u
MM2 net2 A net1 VDD PMOS w=10.2u l=1u
MM3 net3 C net2 VDD PMOS w=10.2u l=1u
MM7 Y net3 VDD VDD PMOS w=10.2u l=1u
MM9 Y net3 GND GND NMOS w=3.4u l=1u
MM1 net3 C GND GND NMOS w=3.4u l=1u
MM4 net3 A GND GND NMOS w=3.4u l=1u
MM5 net3 B GND GND NMOS w=3.4u l=1u
.ends
