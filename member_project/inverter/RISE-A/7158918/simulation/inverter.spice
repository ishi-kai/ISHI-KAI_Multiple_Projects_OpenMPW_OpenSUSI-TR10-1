** sch_path: /home/eda/work/ishikai_0919_2026/inverter.sch
.subckt inverter VDD OUT IN VSS
*.PININFO OUT:I IN:I VDD:B VSS:B
MXM1 OUT IN VDD VDD PMOS w=3.4u l=1u
MXM2 OUT IN VSS VSS NMOS w=3.4u l=1u
.ends
