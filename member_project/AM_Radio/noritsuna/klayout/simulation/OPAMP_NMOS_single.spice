** sch_path: /mnt/c/Data/OneDrive/MyDocuments/Community/ISHIKAI/shuttle/OpenSUSI-TR10/2026/Projects/AM_Radio/noritsuna/xschem/OPAMP_NMOS_single.sch
.subckt OPAMP_NMOS_single VSS VB1 VB2 OUT1 VIN_N VIN_P MN_MDMY2 MN_MDMY3 MN_MDMY4 TO_P MN_MDMY5 VOUT CCOUT VSS L_U_G L_D_G T_D
*.PININFO VSS:B VB1:B VB2:B OUT1:O VIN_N:I VIN_P:I MN_MDMY2:B MN_MDMY3:B MN_MDMY4:B TO_P:B MN_MDMY5:B VOUT:O CCOUT:O VSS:B L_U_G:B
*+ L_D_G:B T_D:B
MMM4 OUT1 VB2 MN_MDMY4 VSS NMOS w=84u l=8u
MMM19 MN_MDMY3 VB2 MN_MDMY2 VSS NMOS w=84u l=8u
MMM20 MN_MDMY4 VIN_P MN_MDMY5 VSS NMOS w=672u l=8u
MMM21 MN_MDMY2 VIN_N MN_MDMY5 VSS NMOS w=672u l=8u
MMM22 MN_MDMY5 VB1 VSS VSS NMOS w=84u l=8u
MMDMYN2 MN_MDMY2 VSS VSS VSS NMOS w=42u l=8u m=2
MMDMYN3 MN_MDMY3 VSS VSS VSS NMOS w=7u l=8u m=4
MMM6 net1 net1 VSS VSS NMOS w=168u l=8u
MMM5 TO_P TO_P net1 VSS NMOS w=168u l=8u
MMDMYN4 MN_MDMY4 VSS VSS VSS NMOS w=42u l=8u m=2
MMDMYN5 MN_MDMY5 VSS VSS VSS NMOS w=42u l=8u m=2
MMM8 VOUT OUT1 VSS VSS NMOS w=1680u l=8u
MMM3 CCOUT TO_P OUT1 VSS NMOS w=168u l=8u
MMDMYN6 OUT1 VSS VSS VSS NMOS w=42u l=8u m=4
MMM1 VB2 VB2 VB1 VSS NMOS w=84u l=8u
MMM2 VB1 VB1 VSS VSS NMOS w=84u l=8u
MMM11 T_D L_U_G net2 VSS NMOS w=84u l=8u
MMM12 net2 L_D_G VSS VSS NMOS w=84u l=8u
MMDMYN7 T_D VSS VSS VSS NMOS w=7u l=8u m=4
.ends
