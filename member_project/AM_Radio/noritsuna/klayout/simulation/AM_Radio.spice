** sch_path: /mnt/c/Data/OneDrive/MyDocuments/Community/ISHIKAI/shuttle/OpenSUSI-TR10/2026/Projects/AM_Radio/noritsuna/xschem/AM_Radio.sch
.subckt AM_Radio VDD VB VREF RFINP RFINN DETOUT VSS RFOUT
*.PININFO VREF:I VSS:B VDD:B VB:B RFINN:I RFINP:I DETOUT:O RFOUT:O
x3 VDD VSS RFOUT DETOUT VB2 VREF VB1 ideal_diode
x1 VDD VSS VB VB1 VB2 current_mirror
x2 VDD VSS RFINP RFINN RFOUT VB2 VB1 cascode_opamp
.ends

* expanding   symbol:  ideal_diode.sym # of pins=7
** sym_path: /mnt/c/Data/OneDrive/MyDocuments/Community/ISHIKAI/shuttle/OpenSUSI-TR10/2026/Projects/AM_Radio/noritsuna/xschem/ideal_diode.sym
** sch_path: /mnt/c/Data/OneDrive/MyDocuments/Community/ISHIKAI/shuttle/OpenSUSI-TR10/2026/Projects/AM_Radio/noritsuna/xschem/ideal_diode.sch
.subckt ideal_diode VDD VSS VIN VOUT VB2 VREF VB1
*.PININFO VDD:B VIN:I VOUT:O VSS:B VREF:B VB1:I VB2:I
XR1 VOUT VREF VDD F_RR w=4e-06 l=76.9e-06
x1 VDD VSS VIN VOUT opout VB2 VB1 cascode_opamp_2
XXC1 opout VOUT VSS F_CSIO x=30u y=30u A=900p P=120u
DD1 opout VOUT DP A=12.96p P=14.4u m=4
DD2 VREF opout DP A=12.96p P=14.4u m=4
.ends

* expanding   symbol:  current_mirror.sym # of pins=5
** sym_path: /mnt/c/Data/OneDrive/MyDocuments/Community/ISHIKAI/shuttle/OpenSUSI-TR10/2026/Projects/AM_Radio/noritsuna/xschem/current_mirror.sym
** sch_path: /mnt/c/Data/OneDrive/MyDocuments/Community/ISHIKAI/shuttle/OpenSUSI-TR10/2026/Projects/AM_Radio/noritsuna/xschem/current_mirror.sch
.subckt current_mirror VDD VSS VB VB1 VB2
*.PININFO VDD:B VSS:B VB:I VB1:O VB2:O
MMM13 VB2 VB2 VB1 VSS NMOS w=84u l=8u
MMM14 VB1 VB1 VSS VSS NMOS w=84u l=8u
MMM23 VB VB VDD VDD PMOS w=240u l=8u
MMM24 VB2 net2 net1 VDD PMOS w=240u l=8u
MMM25 net1 VB VDD VDD PMOS w=240u l=8u
MMM26 iB net2 VB VDD PMOS w=240u l=8u
MMM5 iB net2 net3 VSS NMOS w=84u l=8u
MMM6 net3 net3 VSS VSS NMOS w=84u l=8u
MMDMYP1 iB VDD VDD VDD PMOS w=20u l=8u m=4
MMDMYN7 iB VSS VSS VSS NMOS w=7u l=8u m=4
.ends

* expanding   symbol:  cascode_opamp.sym # of pins=7
** sym_path: /mnt/c/Data/OneDrive/MyDocuments/Community/ISHIKAI/shuttle/OpenSUSI-TR10/2026/Projects/AM_Radio/noritsuna/xschem/cascode_opamp.sym
** sch_path: /mnt/c/Data/OneDrive/MyDocuments/Community/ISHIKAI/shuttle/OpenSUSI-TR10/2026/Projects/AM_Radio/noritsuna/xschem/cascode_opamp.sch
.subckt cascode_opamp VDD VSS VIN_P VIN_N VOUT VB2 VB1
*.PININFO VOUT:O VIN_N:I VIN_P:I VSS:I VDD:I VB1:I VB2:I
MMM2 net2 net1 VDD VDD PMOS w=240u l=8u
MMM4 OUT1 VB2 MN_MDMY4 VSS NMOS w=84u l=8u
MMM7 VOUT iB VDD VDD PMOS w=2400u l=8u
MMM8 VOUT OUT1 VSS VSS NMOS w=1680u l=8u
MMM16 net1 net1 VDD VDD PMOS w=240u l=8u
MMM17 OUT1 MPN_MDMY3 net2 VDD PMOS w=240u l=8u
MMM18 MPN_MDMY3 MPN_MDMY3 net1 VDD PMOS w=240u l=8u
MMM19 MPN_MDMY3 VB2 MN_MDMY2 VSS NMOS w=84u l=8u
MMM20 MN_MDMY4 VIN_P MN_MDMY5 VSS NMOS w=672u l=8u
MMM21 MN_MDMY2 VIN_N MN_MDMY5 VSS NMOS w=672u l=8u
MMM22 MN_MDMY5 VB1 VSS VSS NMOS w=84u l=8u
MMM3 net3 net7 OUT1 VSS NMOS w=168u l=8u
MMM6 net4 net4 VSS VSS NMOS w=168u l=8u
MMM13 VB2 VB2 VB1 VSS NMOS w=84u l=8u
MMM14 VB1 VB1 VSS VSS NMOS w=84u l=8u
MMM23 VB4 VB4 VDD VDD PMOS w=240u l=8u
MMM24 VB2 iB net5 VDD PMOS w=240u l=8u
MMM25 net5 VB4 VDD VDD PMOS w=240u l=8u
MMM26 iB iB VB4 VDD PMOS w=240u l=8u
MMM1 net7 iB net6 VDD PMOS w=240u l=8u
MMM9 net6 VB4 VDD VDD PMOS w=240u l=8u
MMM5 net7 net7 net4 VSS NMOS w=168u l=8u
XXC1 net3 VOUT VSS F_CSIO x=30u y=30u A=900p P=120u
MMDMYN2 MN_MDMY2 VSS VSS VSS NMOS w=42u l=8u m=2
MMDMYN3 MPN_MDMY3 VSS VSS VSS NMOS w=7u l=8u m=4
MMDMYN4 MN_MDMY4 VSS VSS VSS NMOS w=42u l=8u m=2
MMDMYN5 MN_MDMY5 VSS VSS VSS NMOS w=42u l=8u m=2
MMDMYN6 OUT1 VSS VSS VSS NMOS w=42u l=8u m=4
MMDMYP1 iB VDD VDD VDD PMOS w=20u l=8u m=4
MMDMYP2 MPN_MDMY3 VDD VDD VDD PMOS w=20u l=8u m=4
MMDMYP3 VDD VDD VDD VDD PMOS w=60u l=8u m=4
MMM10 iB VB2 net8 VSS NMOS w=84u l=8u
MMM11 net8 VB1 VSS VSS NMOS w=84u l=8u
MMDMYN7 iB VSS VSS VSS NMOS w=7u l=8u m=4
.ends

* expanding   symbol:  cascode_opamp_2.sym # of pins=7
** sym_path: /mnt/c/Data/OneDrive/MyDocuments/Community/ISHIKAI/shuttle/OpenSUSI-TR10/2026/Projects/AM_Radio/noritsuna/xschem/cascode_opamp_2.sym
** sch_path: /mnt/c/Data/OneDrive/MyDocuments/Community/ISHIKAI/shuttle/OpenSUSI-TR10/2026/Projects/AM_Radio/noritsuna/xschem/cascode_opamp_2.sch
.subckt cascode_opamp_2 VDD VSS VIN_P VIN_N VOUT VB2 VB1
*.PININFO VOUT:O VIN_N:I VIN_P:I VSS:I VDD:I VB1:I VB2:I
MMM2 net2 net1 VDD VDD PMOS w=240u l=8u
MMM4 OUT1 VB2 MN_MDMY4 VSS NMOS w=84u l=8u
MMM7 VOUT iB VDD VDD PMOS w=2400u l=8u
MMM8 VOUT OUT1 VSS VSS NMOS w=1680u l=8u
MMM16 net1 net1 VDD VDD PMOS w=240u l=8u
MMM17 OUT1 MPN_MDMY3 net2 VDD PMOS w=240u l=8u
MMM18 MPN_MDMY3 MPN_MDMY3 net1 VDD PMOS w=240u l=8u
MMM19 MPN_MDMY3 VB2 MN_MDMY2 VSS NMOS w=84u l=8u
MMM20 MN_MDMY4 VIN_P MN_MDMY5 VSS NMOS w=672u l=8u
MMM21 MN_MDMY2 VIN_N MN_MDMY5 VSS NMOS w=672u l=8u
MMM22 MN_MDMY5 VB1 VSS VSS NMOS w=84u l=8u
MMM3 net3 net7 OUT1 VSS NMOS w=168u l=8u
MMM6 net4 net4 VSS VSS NMOS w=168u l=8u
MMM13 VB2 VB2 VB1 VSS NMOS w=84u l=8u
MMM14 VB1 VB1 VSS VSS NMOS w=84u l=8u
MMM23 VB4 VB4 VDD VDD PMOS w=240u l=8u
MMM24 VB2 iB net5 VDD PMOS w=240u l=8u
MMM25 net5 VB4 VDD VDD PMOS w=240u l=8u
MMM26 iB iB VB4 VDD PMOS w=240u l=8u
MMM1 net7 iB net6 VDD PMOS w=240u l=8u
MMM9 net6 VB4 VDD VDD PMOS w=240u l=8u
MMM5 net7 net7 net4 VSS NMOS w=168u l=8u
XXC1 net3 VOUT VSS F_CSIO x=30u y=30u A=900p P=120u
MMDMYN2 MN_MDMY2 VSS VSS VSS NMOS w=42u l=8u m=2
MMDMYN3 MPN_MDMY3 VSS VSS VSS NMOS w=7u l=8u m=4
MMDMYN4 MN_MDMY4 VSS VSS VSS NMOS w=42u l=8u m=2
MMDMYN5 MN_MDMY5 VSS VSS VSS NMOS w=42u l=8u m=2
MMDMYN6 OUT1 VSS VSS VSS NMOS w=42u l=8u m=4
MMDMYP1 iB VDD VDD VDD PMOS w=20u l=8u m=4
MMDMYP2 MPN_MDMY3 VDD VDD VDD PMOS w=20u l=8u m=4
MMDMYP3 VDD VDD VDD VDD PMOS w=60u l=8u m=4
MMM10 iB VB2 net8 VSS NMOS w=84u l=8u
MMM11 net8 VB1 VSS VSS NMOS w=84u l=8u
MMDMYN7 iB VSS VSS VSS NMOS w=7u l=8u m=4
.ends
